* slot_4: Bandgap_Core_Res wired to the Chipalooza slot4_wrapper pins.
* Generated by layout/scripts/build_slot4.py from layout/release/reference.spice; do not edit.
.subckt slot_4 s4_an[0] s4_an[1] vdd_3v3 vss_5v0 vdd_5v0 vss_3v3 analog_bus3
+ analog_bus2 analog_bus1 analog_bus0 vbias ibias0 ibias1 dig_out[0]
+ dig_out[1] dig_out[2] dig_out[3] dig_out[4] dig_out[5] dig_out[6] dig_out[7]
+ dig_out[8] dig_out[9] dig_out[10] dig_out[11] dig_in[0] dig_in[1] dig_in[2]
+ dig_in[3] dig_in[4] dig_in[5] dig_in[6] dig_in[7] dig_in[8] dig_in[9]
+ dig_in[10] dig_in[11] dig_in[12] dig_in[13] dig_in[14] dig_in[15] dig_in[16]
+ dig_in[17] dig_in[18] dig_in[19] dig_in[20] dig_in[21] dig_in[22] dig_in[23]
+ reset enable clk
CC2 s4_an[0] vss_5v0 cap_mim_2f0fF W=70.7u L=70.7u
CC3 s4_an[0] vss_5v0 cap_mim_2f0fF W=70.7u L=70.7u
CC4 s4_an[0] vss_5v0 cap_mim_2f0fF W=70.7u L=70.7u
CC5 s4_an[0] vss_5v0 cap_mim_2f0fF W=70.7u L=70.7u
CC6 s4_an[0] vss_5v0 cap_mim_2f0fF W=70.7u L=70.7u
CC7 s4_an[0] vss_5v0 cap_mim_2f0fF W=70.7u L=70.7u
CC8 s4_an[0] vss_5v0 cap_mim_2f0fF W=70.7u L=70.7u
CC9 s4_an[0] vss_5v0 cap_mim_2f0fF W=70.7u L=70.7u
CC10 s4_an[0] vss_5v0 cap_mim_2f0fF W=70.7u L=70.7u
CC11 s4_an[0] vss_5v0 cap_mim_2f0fF W=70.7u L=70.7u
MDUM_M11_0 vdd_5v0 vdd_5v0 vdd_5v0 vdd_5v0 pfet_05v0 W=16.42u L=4.0u
MDUM_M11_1 vdd_5v0 vdd_5v0 vdd_5v0 vdd_5v0 pfet_05v0 W=16.42u L=4.0u
MDUM_M11_2 vdd_5v0 vdd_5v0 vdd_5v0 vdd_5v0 pfet_05v0 W=16.42u L=4.0u
MDUM_M11_3 vdd_5v0 vdd_5v0 vdd_5v0 vdd_5v0 pfet_05v0 W=16.42u L=4.0u
MDUM_M11_4 vdd_5v0 vdd_5v0 vdd_5v0 vdd_5v0 pfet_05v0 W=16.42u L=4.0u
MDUM_M11_5 vdd_5v0 vdd_5v0 vdd_5v0 vdd_5v0 pfet_05v0 W=16.42u L=4.0u
MDUM_M11_6 vdd_5v0 vdd_5v0 vdd_5v0 vdd_5v0 pfet_05v0 W=16.42u L=4.0u
MDUM_M11_7 vdd_5v0 vdd_5v0 vdd_5v0 vdd_5v0 pfet_05v0 W=16.42u L=4.0u
MDUM_M11_8 vdd_5v0 vdd_5v0 vdd_5v0 vdd_5v0 pfet_05v0 W=16.42u L=4.0u
MM11_0 vgn1 vcasp vx1 vdd_5v0 pfet_05v0 W=16.42u L=4.0u
MM12_0 psrg_m3_feed vcasp vx2 vdd_5v0 pfet_05v0 W=16.42u L=4.0u
MDUM_M11_9 vdd_5v0 vdd_5v0 vdd_5v0 vdd_5v0 pfet_05v0 W=16.42u L=4.0u
MM13_0 s4_an[0] vcasp vx3 vdd_5v0 pfet_05v0 W=16.42u L=4.0u
MDUM_M11_10 vdd_5v0 vdd_5v0 vdd_5v0 vdd_5v0 pfet_05v0 W=16.42u L=4.0u
MDUM_M11_11 vdd_5v0 vdd_5v0 vdd_5v0 vdd_5v0 pfet_05v0 W=16.42u L=4.0u
MDUM_M11_12 vdd_5v0 vdd_5v0 vdd_5v0 vdd_5v0 pfet_05v0 W=16.42u L=4.0u
MM13_1 s4_an[0] vcasp vx3 vdd_5v0 pfet_05v0 W=16.42u L=4.0u
MM12_1 psrg_m3_feed vcasp vx2 vdd_5v0 pfet_05v0 W=16.42u L=4.0u
MM11_1 vgn1 vcasp vx1 vdd_5v0 pfet_05v0 W=16.42u L=4.0u
MDUM_M11_13 vdd_5v0 vdd_5v0 vdd_5v0 vdd_5v0 pfet_05v0 W=16.42u L=4.0u
MDUM_M11_14 vdd_5v0 vdd_5v0 vdd_5v0 vdd_5v0 pfet_05v0 W=16.42u L=4.0u
MDUM_M11_15 vdd_5v0 vdd_5v0 vdd_5v0 vdd_5v0 pfet_05v0 W=16.42u L=4.0u
MDUM_M11_16 vdd_5v0 vdd_5v0 vdd_5v0 vdd_5v0 pfet_05v0 W=16.42u L=4.0u
MM13_2 s4_an[0] vcasp vx3 vdd_5v0 pfet_05v0 W=16.42u L=4.0u
MDUM_M11_17 vdd_5v0 vdd_5v0 vdd_5v0 vdd_5v0 pfet_05v0 W=16.42u L=4.0u
MM11_2 vgn1 vcasp vx1 vdd_5v0 pfet_05v0 W=16.42u L=4.0u
MM12_2 psrg_m3_feed vcasp vx2 vdd_5v0 pfet_05v0 W=16.42u L=4.0u
MDUM_M11_18 vdd_5v0 vdd_5v0 vdd_5v0 vdd_5v0 pfet_05v0 W=16.42u L=4.0u
MDUM_M11_19 vdd_5v0 vdd_5v0 vdd_5v0 vdd_5v0 pfet_05v0 W=16.42u L=4.0u
MM12_3 psrg_m3_feed vcasp vx2 vdd_5v0 pfet_05v0 W=16.42u L=4.0u
MM13_3 s4_an[0] vcasp vx3 vdd_5v0 pfet_05v0 W=16.42u L=4.0u
MDUM_M11_20 vdd_5v0 vdd_5v0 vdd_5v0 vdd_5v0 pfet_05v0 W=16.42u L=4.0u
MM11_3 vgn1 vcasp vx1 vdd_5v0 pfet_05v0 W=16.42u L=4.0u
MDUM_M11_21 vdd_5v0 vdd_5v0 vdd_5v0 vdd_5v0 pfet_05v0 W=16.42u L=4.0u
MDUM_M11_22 vdd_5v0 vdd_5v0 vdd_5v0 vdd_5v0 pfet_05v0 W=16.42u L=4.0u
MDUM_M11_23 vdd_5v0 vdd_5v0 vdd_5v0 vdd_5v0 pfet_05v0 W=16.42u L=4.0u
MM11_4 vgn1 vcasp vx1 vdd_5v0 pfet_05v0 W=16.42u L=4.0u
MDUM_M11_24 vdd_5v0 vdd_5v0 vdd_5v0 vdd_5v0 pfet_05v0 W=16.42u L=4.0u
MM12_4 psrg_m3_feed vcasp vx2 vdd_5v0 pfet_05v0 W=16.42u L=4.0u
MM13_4 s4_an[0] vcasp vx3 vdd_5v0 pfet_05v0 W=16.42u L=4.0u
MDUM_M11_25 vdd_5v0 vdd_5v0 vdd_5v0 vdd_5v0 pfet_05v0 W=16.42u L=4.0u
MDUM_M11_26 vdd_5v0 vdd_5v0 vdd_5v0 vdd_5v0 pfet_05v0 W=16.42u L=4.0u
MDUM_M11_27 vdd_5v0 vdd_5v0 vdd_5v0 vdd_5v0 pfet_05v0 W=16.42u L=4.0u
MDUM_M11_28 vdd_5v0 vdd_5v0 vdd_5v0 vdd_5v0 pfet_05v0 W=16.42u L=4.0u
MDUM_M11_29 vdd_5v0 vdd_5v0 vdd_5v0 vdd_5v0 pfet_05v0 W=16.42u L=4.0u
MDUM_M11_30 vdd_5v0 vdd_5v0 vdd_5v0 vdd_5v0 pfet_05v0 W=16.42u L=4.0u
MDUM_M11_31 vdd_5v0 vdd_5v0 vdd_5v0 vdd_5v0 pfet_05v0 W=16.42u L=4.0u
MDUM_M11_32 vdd_5v0 vdd_5v0 vdd_5v0 vdd_5v0 pfet_05v0 W=16.42u L=4.0u
MDUM_M11_33 vdd_5v0 vdd_5v0 vdd_5v0 vdd_5v0 pfet_05v0 W=16.42u L=4.0u
MDUM_M1_0 vdd_5v0 vdd_5v0 vdd_5v0 vdd_5v0 pfet_05v0 W=16.75u L=2.0u
MDUM_M1_1 vdd_5v0 vdd_5v0 vdd_5v0 vdd_5v0 pfet_05v0 W=16.75u L=2.0u
MDUM_M1_2 vdd_5v0 vdd_5v0 vdd_5v0 vdd_5v0 pfet_05v0 W=16.75u L=2.0u
MDUM_M1_3 vdd_5v0 vdd_5v0 vdd_5v0 vdd_5v0 pfet_05v0 W=16.75u L=2.0u
MDUM_M1_4 vdd_5v0 vdd_5v0 vdd_5v0 vdd_5v0 pfet_05v0 W=16.75u L=2.0u
MDUM_M1_5 vdd_5v0 vdd_5v0 vdd_5v0 vdd_5v0 pfet_05v0 W=16.75u L=2.0u
MDUM_M1_6 vdd_5v0 vdd_5v0 vdd_5v0 vdd_5v0 pfet_05v0 W=16.75u L=2.0u
MDUM_M1_7 vdd_5v0 vdd_5v0 vdd_5v0 vdd_5v0 pfet_05v0 W=16.75u L=2.0u
MDUM_M1_8 vdd_5v0 vdd_5v0 vdd_5v0 vdd_5v0 pfet_05v0 W=16.75u L=2.0u
MM1_0 vx2 psrg_m3_feed vdd_5v0 vdd_5v0 pfet_05v0 W=16.75u L=2.0u
MM2_0 vx1 psrg_m3_feed vdd_5v0 vdd_5v0 pfet_05v0 W=16.75u L=2.0u
MM5_0 vx3 psrg_m3_feed vdd_5v0 vdd_5v0 pfet_05v0 W=16.75u L=2.0u
MM5_1 vx3 psrg_m3_feed vdd_5v0 vdd_5v0 pfet_05v0 W=16.75u L=2.0u
MM2_1 vx1 psrg_m3_feed vdd_5v0 vdd_5v0 pfet_05v0 W=16.75u L=2.0u
MM1_1 vx2 psrg_m3_feed vdd_5v0 vdd_5v0 pfet_05v0 W=16.75u L=2.0u
MDUM_M1_9 vdd_5v0 vdd_5v0 vdd_5v0 vdd_5v0 pfet_05v0 W=16.75u L=2.0u
MDUM_M1_10 vdd_5v0 vdd_5v0 vdd_5v0 vdd_5v0 pfet_05v0 W=16.75u L=2.0u
MM2_2 vx1 psrg_m3_feed vdd_5v0 vdd_5v0 pfet_05v0 W=16.75u L=2.0u
MM5_2 vx3 psrg_m3_feed vdd_5v0 vdd_5v0 pfet_05v0 W=16.75u L=2.0u
MM1_2 vx2 psrg_m3_feed vdd_5v0 vdd_5v0 pfet_05v0 W=16.75u L=2.0u
MM1_3 vx2 psrg_m3_feed vdd_5v0 vdd_5v0 pfet_05v0 W=16.75u L=2.0u
MM5_3 vx3 psrg_m3_feed vdd_5v0 vdd_5v0 pfet_05v0 W=16.75u L=2.0u
MM2_3 vx1 psrg_m3_feed vdd_5v0 vdd_5v0 pfet_05v0 W=16.75u L=2.0u
MDUM_M1_11 vdd_5v0 vdd_5v0 vdd_5v0 vdd_5v0 pfet_05v0 W=16.75u L=2.0u
MDUM_M1_12 vdd_5v0 vdd_5v0 vdd_5v0 vdd_5v0 pfet_05v0 W=16.75u L=2.0u
MM5_4 vx3 psrg_m3_feed vdd_5v0 vdd_5v0 pfet_05v0 W=16.75u L=2.0u
MM1_4 vx2 psrg_m3_feed vdd_5v0 vdd_5v0 pfet_05v0 W=16.75u L=2.0u
MM2_4 vx1 psrg_m3_feed vdd_5v0 vdd_5v0 pfet_05v0 W=16.75u L=2.0u
MM2_5 vx1 psrg_m3_feed vdd_5v0 vdd_5v0 pfet_05v0 W=16.75u L=2.0u
MM1_5 vx2 psrg_m3_feed vdd_5v0 vdd_5v0 pfet_05v0 W=16.75u L=2.0u
MM5_5 vx3 psrg_m3_feed vdd_5v0 vdd_5v0 pfet_05v0 W=16.75u L=2.0u
MDUM_M1_13 vdd_5v0 vdd_5v0 vdd_5v0 vdd_5v0 pfet_05v0 W=16.75u L=2.0u
MDUM_M1_14 vdd_5v0 vdd_5v0 vdd_5v0 vdd_5v0 pfet_05v0 W=16.75u L=2.0u
MDUM_M1_15 vdd_5v0 vdd_5v0 vdd_5v0 vdd_5v0 pfet_05v0 W=16.75u L=2.0u
MDUM_M1_16 vdd_5v0 vdd_5v0 vdd_5v0 vdd_5v0 pfet_05v0 W=16.75u L=2.0u
MDUM_M1_17 vdd_5v0 vdd_5v0 vdd_5v0 vdd_5v0 pfet_05v0 W=16.75u L=2.0u
MDUM_M1_18 vdd_5v0 vdd_5v0 vdd_5v0 vdd_5v0 pfet_05v0 W=16.75u L=2.0u
MDUM_M1_19 vdd_5v0 vdd_5v0 vdd_5v0 vdd_5v0 pfet_05v0 W=16.75u L=2.0u
MDUM_M1_20 vdd_5v0 vdd_5v0 vdd_5v0 vdd_5v0 pfet_05v0 W=16.75u L=2.0u
MDUM_M1_21 vdd_5v0 vdd_5v0 vdd_5v0 vdd_5v0 pfet_05v0 W=16.75u L=2.0u
MDUM_M3_0 vss_5v0 vss_5v0 vss_5v0 vss_5v0 nfet_05v0 W=14.6u L=4.0u
MDUM_M3_1 vss_5v0 vss_5v0 vss_5v0 vss_5v0 nfet_05v0 W=14.6u L=4.0u
MDUM_M3_2 vss_5v0 vss_5v0 vss_5v0 vss_5v0 nfet_05v0 W=14.6u L=4.0u
MDUM_M3_3 vss_5v0 vss_5v0 vss_5v0 vss_5v0 nfet_05v0 W=14.6u L=4.0u
MDUM_M3_4 vss_5v0 vss_5v0 vss_5v0 vss_5v0 nfet_05v0 W=14.6u L=4.0u
MDUM_M3_5 vss_5v0 vss_5v0 vss_5v0 vss_5v0 nfet_05v0 W=14.6u L=4.0u
MDUM_M3_6 vss_5v0 vss_5v0 vss_5v0 vss_5v0 nfet_05v0 W=14.6u L=4.0u
MM3_0 psrg_m3_protected vgn2 v2 vss_5v0 nfet_05v0 W=14.6u L=4.0u
MM4_0 vgn1 vgn1 v1 vss_5v0 nfet_05v0 W=14.6u L=4.0u
MM4_1 vgn1 vgn1 v1 vss_5v0 nfet_05v0 W=14.6u L=4.0u
MM3_1 psrg_m3_protected vgn2 v2 vss_5v0 nfet_05v0 W=14.6u L=4.0u
MDUM_M3_7 vss_5v0 vss_5v0 vss_5v0 vss_5v0 nfet_05v0 W=14.6u L=4.0u
MDUM_M3_8 vss_5v0 vss_5v0 vss_5v0 vss_5v0 nfet_05v0 W=14.6u L=4.0u
MDUM_M3_9 vss_5v0 vss_5v0 vss_5v0 vss_5v0 nfet_05v0 W=14.6u L=4.0u
MDUM_M3_10 vss_5v0 vss_5v0 vss_5v0 vss_5v0 nfet_05v0 W=14.6u L=4.0u
MDUM_M3_11 vss_5v0 vss_5v0 vss_5v0 vss_5v0 nfet_05v0 W=14.6u L=4.0u
MDUM_M3_12 vss_5v0 vss_5v0 vss_5v0 vss_5v0 nfet_05v0 W=14.6u L=4.0u
MDUM_M3_13 vss_5v0 vss_5v0 vss_5v0 vss_5v0 nfet_05v0 W=14.6u L=4.0u
MM3C_0 psrg_m3_feed psrg_vnc psrg_m3_protected vss_5v0 nfet_05v0 W=14.6u L=4.0u
MM3C_1 psrg_m3_feed psrg_vnc psrg_m3_protected vss_5v0 nfet_05v0 W=14.6u L=4.0u
QQ2_0_0 vss_5v0 vss_5v0 vq2 pnp_05p00x05p00
QQ2_0_1 vss_5v0 vss_5v0 vq2 pnp_05p00x05p00
QQ2_0_2 vss_5v0 vss_5v0 vq2 pnp_05p00x05p00
QQ2_1_0 vss_5v0 vss_5v0 vq2 pnp_05p00x05p00
QQ1_1_1 vss_5v0 vss_5v0 v1 pnp_05p00x05p00
QQ2_1_2 vss_5v0 vss_5v0 vq2 pnp_05p00x05p00
QQ2_2_0 vss_5v0 vss_5v0 vq2 pnp_05p00x05p00
QQ2_2_1 vss_5v0 vss_5v0 vq2 pnp_05p00x05p00
QQ2_2_2 vss_5v0 vss_5v0 vq2 pnp_05p00x05p00
QQ3 vss_5v0 vss_5v0 vq3 pnp_05p00x05p00
RR1 vq2 v2 vss_5v0 ppolyf_u_1k W=4.0u L=42.1u
MM14_0 vaux psrg_m3_feed vdd_5v0 vdd_5v0 pfet_05v0 W=10.0u L=2.0u
MM14_1 vaux psrg_m3_feed vdd_5v0 vdd_5v0 pfet_05v0 W=10.0u L=2.0u
MDUM_M16_0 vss_5v0 vss_5v0 vss_5v0 vss_5v0 nfet_05v0 W=7.55u L=4.0u
MDUM_M16_1 vss_5v0 vss_5v0 vss_5v0 vss_5v0 nfet_05v0 W=7.55u L=4.0u
MDUM_M16_2 vss_5v0 vss_5v0 vss_5v0 vss_5v0 nfet_05v0 W=7.55u L=4.0u
MDUM_M16_3 vss_5v0 vss_5v0 vss_5v0 vss_5v0 nfet_05v0 W=7.55u L=4.0u
MDUM_M16_4 vss_5v0 vss_5v0 vss_5v0 vss_5v0 nfet_05v0 W=7.55u L=4.0u
MM16_0 vbn vbn vss_5v0 vss_5v0 nfet_05v0 W=7.55u L=4.0u
MM18_0 vcasp vbn vss_5v0 vss_5v0 nfet_05v0 W=7.55u L=4.0u
MDUM_M16_5 vss_5v0 vss_5v0 vss_5v0 vss_5v0 nfet_05v0 W=7.55u L=4.0u
MDUM_M16_6 vss_5v0 vss_5v0 vss_5v0 vss_5v0 nfet_05v0 W=7.55u L=4.0u
MDUM_M16_7 vss_5v0 vss_5v0 vss_5v0 vss_5v0 nfet_05v0 W=7.55u L=4.0u
MDUM_M16_8 vss_5v0 vss_5v0 vss_5v0 vss_5v0 nfet_05v0 W=7.55u L=4.0u
MDUM_M16_9 vss_5v0 vss_5v0 vss_5v0 vss_5v0 nfet_05v0 W=7.55u L=4.0u
MM15 vbn vcasp vaux vdd_5v0 pfet_05v0 W=16.0u L=4.0u
MDUM_MINP_0 vdd_5v0 vdd_5v0 vdd_5v0 vdd_5v0 pfet_05v0 W=54.89u L=4.0u
MDUM_MINP_1 vdd_5v0 vdd_5v0 vdd_5v0 vdd_5v0 pfet_05v0 W=54.89u L=4.0u
MDUM_MINP_2 vdd_5v0 vdd_5v0 vdd_5v0 vdd_5v0 pfet_05v0 W=54.89u L=4.0u
MDUM_MINP_3 vdd_5v0 vdd_5v0 vdd_5v0 vdd_5v0 pfet_05v0 W=54.89u L=4.0u
MDUM_MINP_4 vdd_5v0 vdd_5v0 vdd_5v0 vdd_5v0 pfet_05v0 W=54.89u L=4.0u
MDUM_MINP_5 vdd_5v0 vdd_5v0 vdd_5v0 vdd_5v0 pfet_05v0 W=54.89u L=4.0u
MDUM_MINP_6 vdd_5v0 vdd_5v0 vdd_5v0 vdd_5v0 pfet_05v0 W=54.89u L=4.0u
MDUM_MINP_7 vdd_5v0 vdd_5v0 vdd_5v0 vdd_5v0 pfet_05v0 W=54.89u L=4.0u
MDUM_MINP_8 vdd_5v0 vdd_5v0 vdd_5v0 vdd_5v0 pfet_05v0 W=54.89u L=4.0u
MDUM_MINP_9 vdd_5v0 vdd_5v0 vdd_5v0 vdd_5v0 pfet_05v0 W=54.89u L=4.0u
MDUM_MINP_10 vdd_5v0 vdd_5v0 vdd_5v0 vdd_5v0 pfet_05v0 W=54.89u L=4.0u
MDUM_MINP_11 vdd_5v0 vdd_5v0 vdd_5v0 vdd_5v0 pfet_05v0 W=54.89u L=4.0u
MDUM_MINP_12 vdd_5v0 vdd_5v0 vdd_5v0 vdd_5v0 pfet_05v0 W=54.89u L=4.0u
MDUM_MINP_13 vdd_5v0 vdd_5v0 vdd_5v0 vdd_5v0 pfet_05v0 W=54.89u L=4.0u
MMINN_0 xf2 v2 vsp vdd_5v0 pfet_05v0 W=54.89u L=4.0u
MMINP_0 xf1 v1 vsp vdd_5v0 pfet_05v0 W=54.89u L=4.0u
MMINN_1 xf2 v2 vsp vdd_5v0 pfet_05v0 W=54.89u L=4.0u
MMINP_1 xf1 v1 vsp vdd_5v0 pfet_05v0 W=54.89u L=4.0u
MMINP_2 xf1 v1 vsp vdd_5v0 pfet_05v0 W=54.89u L=4.0u
MDUM_MINP_14 vdd_5v0 vdd_5v0 vdd_5v0 vdd_5v0 pfet_05v0 W=54.89u L=4.0u
MMINN_2 xf2 v2 vsp vdd_5v0 pfet_05v0 W=54.89u L=4.0u
MMINN_3 xf2 v2 vsp vdd_5v0 pfet_05v0 W=54.89u L=4.0u
MMINP_3 xf1 v1 vsp vdd_5v0 pfet_05v0 W=54.89u L=4.0u
MMINP_4 xf1 v1 vsp vdd_5v0 pfet_05v0 W=54.89u L=4.0u
MMINN_4 xf2 v2 vsp vdd_5v0 pfet_05v0 W=54.89u L=4.0u
MDUM_MINP_15 vdd_5v0 vdd_5v0 vdd_5v0 vdd_5v0 pfet_05v0 W=54.89u L=4.0u
MDUM_MINP_16 vdd_5v0 vdd_5v0 vdd_5v0 vdd_5v0 pfet_05v0 W=54.89u L=4.0u
MDUM_MINP_17 vdd_5v0 vdd_5v0 vdd_5v0 vdd_5v0 pfet_05v0 W=54.89u L=4.0u
MDUM_MINP_18 vdd_5v0 vdd_5v0 vdd_5v0 vdd_5v0 pfet_05v0 W=54.89u L=4.0u
MDUM_MINP_19 vdd_5v0 vdd_5v0 vdd_5v0 vdd_5v0 pfet_05v0 W=54.89u L=4.0u
MDUM_MINP_20 vdd_5v0 vdd_5v0 vdd_5v0 vdd_5v0 pfet_05v0 W=54.89u L=4.0u
MDUM_MINP_21 vdd_5v0 vdd_5v0 vdd_5v0 vdd_5v0 pfet_05v0 W=54.89u L=4.0u
MDUM_MINP_22 vdd_5v0 vdd_5v0 vdd_5v0 vdd_5v0 pfet_05v0 W=54.89u L=4.0u
MDUM_MINP_23 vdd_5v0 vdd_5v0 vdd_5v0 vdd_5v0 pfet_05v0 W=54.89u L=4.0u
MDUM_MINP_24 vdd_5v0 vdd_5v0 vdd_5v0 vdd_5v0 pfet_05v0 W=54.89u L=4.0u
MDUM_MINP_25 vdd_5v0 vdd_5v0 vdd_5v0 vdd_5v0 pfet_05v0 W=54.89u L=4.0u
MDUM_MINP_26 vdd_5v0 vdd_5v0 vdd_5v0 vdd_5v0 pfet_05v0 W=54.89u L=4.0u
MDUM_MINP_27 vdd_5v0 vdd_5v0 vdd_5v0 vdd_5v0 pfet_05v0 W=54.89u L=4.0u
MDUM_MINP_28 vdd_5v0 vdd_5v0 vdd_5v0 vdd_5v0 pfet_05v0 W=54.89u L=4.0u
MDUM_PCAS1_0 vdd_5v0 vdd_5v0 vdd_5v0 vdd_5v0 pfet_05v0 W=22.21u L=8.0u
MDUM_PCAS1_1 vdd_5v0 vdd_5v0 vdd_5v0 vdd_5v0 pfet_05v0 W=22.21u L=8.0u
MDUM_PCAS1_2 vdd_5v0 vdd_5v0 vdd_5v0 vdd_5v0 pfet_05v0 W=22.21u L=8.0u
MDUM_PCAS1_3 vdd_5v0 vdd_5v0 vdd_5v0 vdd_5v0 pfet_05v0 W=22.21u L=8.0u
MDUM_PCAS1_4 vdd_5v0 vdd_5v0 vdd_5v0 vdd_5v0 pfet_05v0 W=22.21u L=8.0u
MDUM_PCAS1_5 vdd_5v0 vdd_5v0 vdd_5v0 vdd_5v0 pfet_05v0 W=22.21u L=8.0u
MDUM_PCAS1_6 vdd_5v0 vdd_5v0 vdd_5v0 vdd_5v0 pfet_05v0 W=22.21u L=8.0u
MDUM_PCAS1_7 vdd_5v0 vdd_5v0 vdd_5v0 vdd_5v0 pfet_05v0 W=22.21u L=8.0u
MDUM_PCAS1_8 vdd_5v0 vdd_5v0 vdd_5v0 vdd_5v0 pfet_05v0 W=22.21u L=8.0u
MPCAS1_0 y1 vbp_cas pm1 vdd_5v0 pfet_05v0 W=22.21u L=8.0u
MPCAS2_0 vgn2 vbp_cas pm2 vdd_5v0 pfet_05v0 W=22.21u L=8.0u
MPCAS2_1 vgn2 vbp_cas pm2 vdd_5v0 pfet_05v0 W=22.21u L=8.0u
MPCAS1_1 y1 vbp_cas pm1 vdd_5v0 pfet_05v0 W=22.21u L=8.0u
MPCAS1_2 y1 vbp_cas pm1 vdd_5v0 pfet_05v0 W=22.21u L=8.0u
MPCAS2_2 vgn2 vbp_cas pm2 vdd_5v0 pfet_05v0 W=22.21u L=8.0u
MDUM_PCAS1_9 vdd_5v0 vdd_5v0 vdd_5v0 vdd_5v0 pfet_05v0 W=22.21u L=8.0u
MDUM_PCAS1_10 vdd_5v0 vdd_5v0 vdd_5v0 vdd_5v0 pfet_05v0 W=22.21u L=8.0u
MPCAS2_3 vgn2 vbp_cas pm2 vdd_5v0 pfet_05v0 W=22.21u L=8.0u
MPCAS1_3 y1 vbp_cas pm1 vdd_5v0 pfet_05v0 W=22.21u L=8.0u
MPCAS1_4 y1 vbp_cas pm1 vdd_5v0 pfet_05v0 W=22.21u L=8.0u
MPCAS2_4 vgn2 vbp_cas pm2 vdd_5v0 pfet_05v0 W=22.21u L=8.0u
MPCAS2_5 vgn2 vbp_cas pm2 vdd_5v0 pfet_05v0 W=22.21u L=8.0u
MPCAS1_5 y1 vbp_cas pm1 vdd_5v0 pfet_05v0 W=22.21u L=8.0u
MDUM_PCAS1_11 vdd_5v0 vdd_5v0 vdd_5v0 vdd_5v0 pfet_05v0 W=22.21u L=8.0u
MDUM_PCAS1_12 vdd_5v0 vdd_5v0 vdd_5v0 vdd_5v0 pfet_05v0 W=22.21u L=8.0u
MDUM_PCAS1_13 vdd_5v0 vdd_5v0 vdd_5v0 vdd_5v0 pfet_05v0 W=22.21u L=8.0u
MDUM_PCAS1_14 vdd_5v0 vdd_5v0 vdd_5v0 vdd_5v0 pfet_05v0 W=22.21u L=8.0u
MDUM_PCAS1_15 vdd_5v0 vdd_5v0 vdd_5v0 vdd_5v0 pfet_05v0 W=22.21u L=8.0u
MDUM_PCAS1_16 vdd_5v0 vdd_5v0 vdd_5v0 vdd_5v0 pfet_05v0 W=22.21u L=8.0u
MDUM_PCAS1_17 vdd_5v0 vdd_5v0 vdd_5v0 vdd_5v0 pfet_05v0 W=22.21u L=8.0u
MDUM_PCAS1_18 vdd_5v0 vdd_5v0 vdd_5v0 vdd_5v0 pfet_05v0 W=22.21u L=8.0u
MDUM_PCAS1_19 vdd_5v0 vdd_5v0 vdd_5v0 vdd_5v0 pfet_05v0 W=22.21u L=8.0u
MDUM_MFOLD1_0 vss_5v0 vss_5v0 vss_5v0 vss_5v0 nfet_05v0 W=18.49u L=6.0u
MDUM_MFOLD1_1 vss_5v0 vss_5v0 vss_5v0 vss_5v0 nfet_05v0 W=18.49u L=6.0u
MDUM_MFOLD1_2 vss_5v0 vss_5v0 vss_5v0 vss_5v0 nfet_05v0 W=18.49u L=6.0u
MDUM_MFOLD1_3 vss_5v0 vss_5v0 vss_5v0 vss_5v0 nfet_05v0 W=18.49u L=6.0u
MDUM_MFOLD1_4 vss_5v0 vss_5v0 vss_5v0 vss_5v0 nfet_05v0 W=18.49u L=6.0u
MMFOLD1_0 psrg_mf1_protected vbn_fold xf1 vss_5v0 nfet_05v0 W=18.49u L=6.0u
MMFOLD2_0 vgn2 vbn_fold xf2 vss_5v0 nfet_05v0 W=18.49u L=6.0u
MDUM_MFOLD1_5 vss_5v0 vss_5v0 vss_5v0 vss_5v0 nfet_05v0 W=18.49u L=6.0u
MDUM_MFOLD1_6 vss_5v0 vss_5v0 vss_5v0 vss_5v0 nfet_05v0 W=18.49u L=6.0u
MDUM_MFOLD1_7 vss_5v0 vss_5v0 vss_5v0 vss_5v0 nfet_05v0 W=18.49u L=6.0u
MDUM_MFOLD1_8 vss_5v0 vss_5v0 vss_5v0 vss_5v0 nfet_05v0 W=18.49u L=6.0u
MDUM_MFOLD1_9 vss_5v0 vss_5v0 vss_5v0 vss_5v0 nfet_05v0 W=18.49u L=6.0u
MMFOLD1C y1 psrg_vnc psrg_mf1_protected vss_5v0 nfet_05v0 W=18.49u L=6.0u
CC1 vgn2 vss_5v0 cap_mim_2f0fF W=59.0u L=59.0u
MDUM_PLOAD1_0 vdd_5v0 vdd_5v0 vdd_5v0 vdd_5v0 pfet_05v0 W=20.76u L=4.0u
MDUM_PLOAD1_1 vdd_5v0 vdd_5v0 vdd_5v0 vdd_5v0 pfet_05v0 W=20.76u L=4.0u
MDUM_PLOAD1_2 vdd_5v0 vdd_5v0 vdd_5v0 vdd_5v0 pfet_05v0 W=20.76u L=4.0u
MDUM_PLOAD1_3 vdd_5v0 vdd_5v0 vdd_5v0 vdd_5v0 pfet_05v0 W=20.76u L=4.0u
MDUM_PLOAD1_4 vdd_5v0 vdd_5v0 vdd_5v0 vdd_5v0 pfet_05v0 W=20.76u L=4.0u
MDUM_PLOAD1_5 vdd_5v0 vdd_5v0 vdd_5v0 vdd_5v0 pfet_05v0 W=20.76u L=4.0u
MDUM_PLOAD1_6 vdd_5v0 vdd_5v0 vdd_5v0 vdd_5v0 pfet_05v0 W=20.76u L=4.0u
MDUM_PLOAD1_7 vdd_5v0 vdd_5v0 vdd_5v0 vdd_5v0 pfet_05v0 W=20.76u L=4.0u
MDUM_PLOAD1_8 vdd_5v0 vdd_5v0 vdd_5v0 vdd_5v0 pfet_05v0 W=20.76u L=4.0u
MPLOAD1_0 pm1 y1 vdd_5v0 vdd_5v0 pfet_05v0 W=20.76u L=4.0u
MPLOAD2_0 pm2 y1 vdd_5v0 vdd_5v0 pfet_05v0 W=20.76u L=4.0u
MPLOAD2_1 pm2 y1 vdd_5v0 vdd_5v0 pfet_05v0 W=20.76u L=4.0u
MPLOAD1_1 pm1 y1 vdd_5v0 vdd_5v0 pfet_05v0 W=20.76u L=4.0u
MPLOAD1_2 pm1 y1 vdd_5v0 vdd_5v0 pfet_05v0 W=20.76u L=4.0u
MPLOAD2_2 pm2 y1 vdd_5v0 vdd_5v0 pfet_05v0 W=20.76u L=4.0u
MDUM_PLOAD1_9 vdd_5v0 vdd_5v0 vdd_5v0 vdd_5v0 pfet_05v0 W=20.76u L=4.0u
MDUM_PLOAD1_10 vdd_5v0 vdd_5v0 vdd_5v0 vdd_5v0 pfet_05v0 W=20.76u L=4.0u
MPLOAD2_3 pm2 y1 vdd_5v0 vdd_5v0 pfet_05v0 W=20.76u L=4.0u
MPLOAD1_3 pm1 y1 vdd_5v0 vdd_5v0 pfet_05v0 W=20.76u L=4.0u
MPLOAD1_4 pm1 y1 vdd_5v0 vdd_5v0 pfet_05v0 W=20.76u L=4.0u
MPLOAD2_4 pm2 y1 vdd_5v0 vdd_5v0 pfet_05v0 W=20.76u L=4.0u
MPLOAD2_5 pm2 y1 vdd_5v0 vdd_5v0 pfet_05v0 W=20.76u L=4.0u
MPLOAD1_5 pm1 y1 vdd_5v0 vdd_5v0 pfet_05v0 W=20.76u L=4.0u
MDUM_PLOAD1_11 vdd_5v0 vdd_5v0 vdd_5v0 vdd_5v0 pfet_05v0 W=20.76u L=4.0u
MDUM_PLOAD1_12 vdd_5v0 vdd_5v0 vdd_5v0 vdd_5v0 pfet_05v0 W=20.76u L=4.0u
MDUM_PLOAD1_13 vdd_5v0 vdd_5v0 vdd_5v0 vdd_5v0 pfet_05v0 W=20.76u L=4.0u
MDUM_PLOAD1_14 vdd_5v0 vdd_5v0 vdd_5v0 vdd_5v0 pfet_05v0 W=20.76u L=4.0u
MDUM_PLOAD1_15 vdd_5v0 vdd_5v0 vdd_5v0 vdd_5v0 pfet_05v0 W=20.76u L=4.0u
MDUM_PLOAD1_16 vdd_5v0 vdd_5v0 vdd_5v0 vdd_5v0 pfet_05v0 W=20.76u L=4.0u
MDUM_PLOAD1_17 vdd_5v0 vdd_5v0 vdd_5v0 vdd_5v0 pfet_05v0 W=20.76u L=4.0u
MDUM_PLOAD1_18 vdd_5v0 vdd_5v0 vdd_5v0 vdd_5v0 pfet_05v0 W=20.76u L=4.0u
MDUM_PLOAD1_19 vdd_5v0 vdd_5v0 vdd_5v0 vdd_5v0 pfet_05v0 W=20.76u L=4.0u
MDUM_MSINK1_0 vss_5v0 vss_5v0 vss_5v0 vss_5v0 nfet_05v0 W=16.34u L=8.0u
MDUM_MSINK1_1 vss_5v0 vss_5v0 vss_5v0 vss_5v0 nfet_05v0 W=16.34u L=8.0u
MDUM_MSINK1_2 vss_5v0 vss_5v0 vss_5v0 vss_5v0 nfet_05v0 W=16.34u L=8.0u
MDUM_MSINK1_3 vss_5v0 vss_5v0 vss_5v0 vss_5v0 nfet_05v0 W=16.34u L=8.0u
MDUM_MSINK1_4 vss_5v0 vss_5v0 vss_5v0 vss_5v0 nfet_05v0 W=16.34u L=8.0u
MDUM_MSINK1_5 vss_5v0 vss_5v0 vss_5v0 vss_5v0 nfet_05v0 W=16.34u L=8.0u
MDUM_MSINK1_6 vss_5v0 vss_5v0 vss_5v0 vss_5v0 nfet_05v0 W=16.34u L=8.0u
MDUM_MSINK1_7 vss_5v0 vss_5v0 vss_5v0 vss_5v0 nfet_05v0 W=16.34u L=8.0u
MDUM_MSINK1_8 vss_5v0 vss_5v0 vss_5v0 vss_5v0 nfet_05v0 W=16.34u L=8.0u
MMSINK1_0 xf1 vbn_sink vss_5v0 vss_5v0 nfet_05v0 W=16.34u L=8.0u
MMSINK2_0 xf2 vbn_sink vss_5v0 vss_5v0 nfet_05v0 W=16.34u L=8.0u
MMSINK2_1 xf2 vbn_sink vss_5v0 vss_5v0 nfet_05v0 W=16.34u L=8.0u
MMSINK1_1 xf1 vbn_sink vss_5v0 vss_5v0 nfet_05v0 W=16.34u L=8.0u
MMSINK1_2 xf1 vbn_sink vss_5v0 vss_5v0 nfet_05v0 W=16.34u L=8.0u
MMSINK2_2 xf2 vbn_sink vss_5v0 vss_5v0 nfet_05v0 W=16.34u L=8.0u
MDUM_MSINK1_9 vss_5v0 vss_5v0 vss_5v0 vss_5v0 nfet_05v0 W=16.34u L=8.0u
MDUM_MSINK1_10 vss_5v0 vss_5v0 vss_5v0 vss_5v0 nfet_05v0 W=16.34u L=8.0u
MMSINK2_3 xf2 vbn_sink vss_5v0 vss_5v0 nfet_05v0 W=16.34u L=8.0u
MMSINK1_3 xf1 vbn_sink vss_5v0 vss_5v0 nfet_05v0 W=16.34u L=8.0u
MMSINK1_4 xf1 vbn_sink vss_5v0 vss_5v0 nfet_05v0 W=16.34u L=8.0u
MMSINK2_4 xf2 vbn_sink vss_5v0 vss_5v0 nfet_05v0 W=16.34u L=8.0u
MMSINK2_5 xf2 vbn_sink vss_5v0 vss_5v0 nfet_05v0 W=16.34u L=8.0u
MMSINK1_5 xf1 vbn_sink vss_5v0 vss_5v0 nfet_05v0 W=16.34u L=8.0u
MDUM_MSINK1_11 vss_5v0 vss_5v0 vss_5v0 vss_5v0 nfet_05v0 W=16.34u L=8.0u
MDUM_MSINK1_12 vss_5v0 vss_5v0 vss_5v0 vss_5v0 nfet_05v0 W=16.34u L=8.0u
MDUM_MSINK1_13 vss_5v0 vss_5v0 vss_5v0 vss_5v0 nfet_05v0 W=16.34u L=8.0u
MDUM_MSINK1_14 vss_5v0 vss_5v0 vss_5v0 vss_5v0 nfet_05v0 W=16.34u L=8.0u
MDUM_MSINK1_15 vss_5v0 vss_5v0 vss_5v0 vss_5v0 nfet_05v0 W=16.34u L=8.0u
MDUM_MSINK1_16 vss_5v0 vss_5v0 vss_5v0 vss_5v0 nfet_05v0 W=16.34u L=8.0u
MDUM_MSINK1_17 vss_5v0 vss_5v0 vss_5v0 vss_5v0 nfet_05v0 W=16.34u L=8.0u
MDUM_MSINK1_18 vss_5v0 vss_5v0 vss_5v0 vss_5v0 nfet_05v0 W=16.34u L=8.0u
MDUM_MSINK1_19 vss_5v0 vss_5v0 vss_5v0 vss_5v0 nfet_05v0 W=16.34u L=8.0u
MDUM_VBNSINK_0 vss_5v0 vss_5v0 vss_5v0 vss_5v0 nfet_05v0 W=12.31u L=8.0u
MDUM_VBNSINK_1 vss_5v0 vss_5v0 vss_5v0 vss_5v0 nfet_05v0 W=12.31u L=8.0u
MDUM_VBNSINK_2 vss_5v0 vss_5v0 vss_5v0 vss_5v0 nfet_05v0 W=12.31u L=8.0u
MDUM_VBNSINK_3 vss_5v0 vss_5v0 vss_5v0 vss_5v0 nfet_05v0 W=12.31u L=8.0u
MDUM_VBNSINK_4 vss_5v0 vss_5v0 vss_5v0 vss_5v0 nfet_05v0 W=12.31u L=8.0u
MVBNSINK_0 vbn_sink vbn_sink vss_5v0 vss_5v0 nfet_05v0 W=12.31u L=8.0u
MVBNSINK_1 vbn_sink vbn_sink vss_5v0 vss_5v0 nfet_05v0 W=12.31u L=8.0u
MDUM_VBNSINK_5 vss_5v0 vss_5v0 vss_5v0 vss_5v0 nfet_05v0 W=12.31u L=8.0u
MDUM_VBNSINK_6 vss_5v0 vss_5v0 vss_5v0 vss_5v0 nfet_05v0 W=12.31u L=8.0u
MDUM_VBNSINK_7 vss_5v0 vss_5v0 vss_5v0 vss_5v0 nfet_05v0 W=12.31u L=8.0u
MDUM_VBNSINK_8 vss_5v0 vss_5v0 vss_5v0 vss_5v0 nfet_05v0 W=12.31u L=8.0u
MDUM_VBNSINK_9 vss_5v0 vss_5v0 vss_5v0 vss_5v0 nfet_05v0 W=12.31u L=8.0u
MMTAIL_0 vsp vbp_tail vdd_5v0 vdd_5v0 pfet_03v3 W=28.91u L=6.0u
MMTAIL_1 vsp vbp_tail vdd_5v0 vdd_5v0 pfet_03v3 W=28.91u L=6.0u
MMTAIL_2 vsp vbp_tail vdd_5v0 vdd_5v0 pfet_03v3 W=28.91u L=6.0u
MMTAIL_3 vsp vbp_tail vdd_5v0 vdd_5v0 pfet_03v3 W=28.91u L=6.0u
MMTAIL_4 vsp vbp_tail vdd_5v0 vdd_5v0 pfet_03v3 W=28.91u L=6.0u
MMTAIL_5 vsp vbp_tail vdd_5v0 vdd_5v0 pfet_03v3 W=28.91u L=6.0u
MMSU_SENSE su_state vgn2 vss_5v0 vss_5v0 nfet_05v0 W=4.0u L=1.0u
MDUM_MPSINK_0 vdd_5v0 vdd_5v0 vdd_5v0 vdd_5v0 pfet_05v0 W=18.95u L=8.0u
MDUM_MPSINK_1 vdd_5v0 vdd_5v0 vdd_5v0 vdd_5v0 pfet_05v0 W=18.95u L=8.0u
MDUM_MPSINK_2 vdd_5v0 vdd_5v0 vdd_5v0 vdd_5v0 pfet_05v0 W=18.95u L=8.0u
MDUM_MPSINK_3 vdd_5v0 vdd_5v0 vdd_5v0 vdd_5v0 pfet_05v0 W=18.95u L=8.0u
MDUM_MPSINK_4 vdd_5v0 vdd_5v0 vdd_5v0 vdd_5v0 pfet_05v0 W=18.95u L=8.0u
MDUM_MPSINK_5 vdd_5v0 vdd_5v0 vdd_5v0 vdd_5v0 pfet_05v0 W=18.95u L=8.0u
MDUM_MPSINK_6 vdd_5v0 vdd_5v0 vdd_5v0 vdd_5v0 pfet_05v0 W=18.95u L=8.0u
MDUM_MPSINK_7 vdd_5v0 vdd_5v0 vdd_5v0 vdd_5v0 pfet_05v0 W=18.95u L=8.0u
MDUM_MPSINK_8 vdd_5v0 vdd_5v0 vdd_5v0 vdd_5v0 pfet_05v0 W=18.95u L=8.0u
MMPSINK_0 vbn_sink vbp_i vdd_5v0 vdd_5v0 pfet_05v0 W=18.95u L=8.0u
MMPSINK_1 vbn_sink vbp_i vdd_5v0 vdd_5v0 pfet_05v0 W=18.95u L=8.0u
MMPSINK_2 vbn_sink vbp_i vdd_5v0 vdd_5v0 pfet_05v0 W=18.95u L=8.0u
MMPSINK_3 vbn_sink vbp_i vdd_5v0 vdd_5v0 pfet_05v0 W=18.95u L=8.0u
MMPSINK_4 vbn_sink vbp_i vdd_5v0 vdd_5v0 pfet_05v0 W=18.95u L=8.0u
MMPSINK_5 vbn_sink vbp_i vdd_5v0 vdd_5v0 pfet_05v0 W=18.95u L=8.0u
MDUM_MPSINK_9 vdd_5v0 vdd_5v0 vdd_5v0 vdd_5v0 pfet_05v0 W=18.95u L=8.0u
MDUM_MPSINK_10 vdd_5v0 vdd_5v0 vdd_5v0 vdd_5v0 pfet_05v0 W=18.95u L=8.0u
MMPSINK_6 vbn_sink vbp_i vdd_5v0 vdd_5v0 pfet_05v0 W=18.95u L=8.0u
MMPSINK_7 vbn_sink vbp_i vdd_5v0 vdd_5v0 pfet_05v0 W=18.95u L=8.0u
MMPSINK_8 vbn_sink vbp_i vdd_5v0 vdd_5v0 pfet_05v0 W=18.95u L=8.0u
MMPSINK_9 vbn_sink vbp_i vdd_5v0 vdd_5v0 pfet_05v0 W=18.95u L=8.0u
MMPSINK_10 vbn_sink vbp_i vdd_5v0 vdd_5v0 pfet_05v0 W=18.95u L=8.0u
MMPSINK_11 vbn_sink vbp_i vdd_5v0 vdd_5v0 pfet_05v0 W=18.95u L=8.0u
MDUM_MPSINK_11 vdd_5v0 vdd_5v0 vdd_5v0 vdd_5v0 pfet_05v0 W=18.95u L=8.0u
MDUM_MPSINK_12 vdd_5v0 vdd_5v0 vdd_5v0 vdd_5v0 pfet_05v0 W=18.95u L=8.0u
MMPSINK_12 vbn_sink vbp_i vdd_5v0 vdd_5v0 pfet_05v0 W=18.95u L=8.0u
MMPSINK_13 vbn_sink vbp_i vdd_5v0 vdd_5v0 pfet_05v0 W=18.95u L=8.0u
MMPSINK_14 vbn_sink vbp_i vdd_5v0 vdd_5v0 pfet_05v0 W=18.95u L=8.0u
MMPSINK_15 vbn_sink vbp_i vdd_5v0 vdd_5v0 pfet_05v0 W=18.95u L=8.0u
MMPSINK_16 vbn_sink vbp_i vdd_5v0 vdd_5v0 pfet_05v0 W=18.95u L=8.0u
MDUM_MPSINK_13 vdd_5v0 vdd_5v0 vdd_5v0 vdd_5v0 pfet_05v0 W=18.95u L=8.0u
MDUM_MPSINK_14 vdd_5v0 vdd_5v0 vdd_5v0 vdd_5v0 pfet_05v0 W=18.95u L=8.0u
MDUM_MPSINK_15 vdd_5v0 vdd_5v0 vdd_5v0 vdd_5v0 pfet_05v0 W=18.95u L=8.0u
MDUM_MPSINK_16 vdd_5v0 vdd_5v0 vdd_5v0 vdd_5v0 pfet_05v0 W=18.95u L=8.0u
MDUM_MPSINK_17 vdd_5v0 vdd_5v0 vdd_5v0 vdd_5v0 pfet_05v0 W=18.95u L=8.0u
MDUM_MPSINK_18 vdd_5v0 vdd_5v0 vdd_5v0 vdd_5v0 pfet_05v0 W=18.95u L=8.0u
MDUM_MPSINK_19 vdd_5v0 vdd_5v0 vdd_5v0 vdd_5v0 pfet_05v0 W=18.95u L=8.0u
MDUM_MPSINK_20 vdd_5v0 vdd_5v0 vdd_5v0 vdd_5v0 pfet_05v0 W=18.95u L=8.0u
MDUM_MPSINK_21 vdd_5v0 vdd_5v0 vdd_5v0 vdd_5v0 pfet_05v0 W=18.95u L=8.0u
MDUM_MPSINK_22 vdd_5v0 vdd_5v0 vdd_5v0 vdd_5v0 pfet_05v0 W=18.95u L=8.0u
MDUM_MPFOLD_0 vdd_5v0 vdd_5v0 vdd_5v0 vdd_5v0 pfet_05v0 W=18.99u L=8.0u
MDUM_MPFOLD_1 vdd_5v0 vdd_5v0 vdd_5v0 vdd_5v0 pfet_05v0 W=18.99u L=8.0u
MDUM_MPFOLD_2 vdd_5v0 vdd_5v0 vdd_5v0 vdd_5v0 pfet_05v0 W=18.99u L=8.0u
MDUM_MPFOLD_3 vdd_5v0 vdd_5v0 vdd_5v0 vdd_5v0 pfet_05v0 W=18.99u L=8.0u
MDUM_MPFOLD_4 vdd_5v0 vdd_5v0 vdd_5v0 vdd_5v0 pfet_05v0 W=18.99u L=8.0u
MDUM_MPFOLD_5 vdd_5v0 vdd_5v0 vdd_5v0 vdd_5v0 pfet_05v0 W=18.99u L=8.0u
MDUM_MPFOLD_6 vdd_5v0 vdd_5v0 vdd_5v0 vdd_5v0 pfet_05v0 W=18.99u L=8.0u
MDUM_MPFOLD_7 vdd_5v0 vdd_5v0 vdd_5v0 vdd_5v0 pfet_05v0 W=18.99u L=8.0u
MDUM_MPFOLD_8 vdd_5v0 vdd_5v0 vdd_5v0 vdd_5v0 pfet_05v0 W=18.99u L=8.0u
MMPFOLD_0 vbn_fold vbp_i vdd_5v0 vdd_5v0 pfet_05v0 W=18.99u L=8.0u
MMPFOLD_1 vbn_fold vbp_i vdd_5v0 vdd_5v0 pfet_05v0 W=18.99u L=8.0u
MMPFOLD_2 vbn_fold vbp_i vdd_5v0 vdd_5v0 pfet_05v0 W=18.99u L=8.0u
MMPFOLD_3 vbn_fold vbp_i vdd_5v0 vdd_5v0 pfet_05v0 W=18.99u L=8.0u
MMPFOLD_4 vbn_fold vbp_i vdd_5v0 vdd_5v0 pfet_05v0 W=18.99u L=8.0u
MMPFOLD_5 vbn_fold vbp_i vdd_5v0 vdd_5v0 pfet_05v0 W=18.99u L=8.0u
MDUM_MPFOLD_9 vdd_5v0 vdd_5v0 vdd_5v0 vdd_5v0 pfet_05v0 W=18.99u L=8.0u
MDUM_MPFOLD_10 vdd_5v0 vdd_5v0 vdd_5v0 vdd_5v0 pfet_05v0 W=18.99u L=8.0u
MMPFOLD_6 vbn_fold vbp_i vdd_5v0 vdd_5v0 pfet_05v0 W=18.99u L=8.0u
MMPFOLD_7 vbn_fold vbp_i vdd_5v0 vdd_5v0 pfet_05v0 W=18.99u L=8.0u
MMPFOLD_8 vbn_fold vbp_i vdd_5v0 vdd_5v0 pfet_05v0 W=18.99u L=8.0u
MMPFOLD_9 vbn_fold vbp_i vdd_5v0 vdd_5v0 pfet_05v0 W=18.99u L=8.0u
MMPFOLD_10 vbn_fold vbp_i vdd_5v0 vdd_5v0 pfet_05v0 W=18.99u L=8.0u
MMPFOLD_11 vbn_fold vbp_i vdd_5v0 vdd_5v0 pfet_05v0 W=18.99u L=8.0u
MDUM_MPFOLD_11 vdd_5v0 vdd_5v0 vdd_5v0 vdd_5v0 pfet_05v0 W=18.99u L=8.0u
MDUM_MPFOLD_12 vdd_5v0 vdd_5v0 vdd_5v0 vdd_5v0 pfet_05v0 W=18.99u L=8.0u
MDUM_MPFOLD_13 vdd_5v0 vdd_5v0 vdd_5v0 vdd_5v0 pfet_05v0 W=18.99u L=8.0u
MDUM_MPFOLD_14 vdd_5v0 vdd_5v0 vdd_5v0 vdd_5v0 pfet_05v0 W=18.99u L=8.0u
MDUM_MPFOLD_15 vdd_5v0 vdd_5v0 vdd_5v0 vdd_5v0 pfet_05v0 W=18.99u L=8.0u
MDUM_MPFOLD_16 vdd_5v0 vdd_5v0 vdd_5v0 vdd_5v0 pfet_05v0 W=18.99u L=8.0u
MDUM_MPFOLD_17 vdd_5v0 vdd_5v0 vdd_5v0 vdd_5v0 pfet_05v0 W=18.99u L=8.0u
MDUM_MPFOLD_18 vdd_5v0 vdd_5v0 vdd_5v0 vdd_5v0 pfet_05v0 W=18.99u L=8.0u
MDUM_MPFOLD_19 vdd_5v0 vdd_5v0 vdd_5v0 vdd_5v0 pfet_05v0 W=18.99u L=8.0u
MDUM_PREF_0 vdd_5v0 vdd_5v0 vdd_5v0 vdd_5v0 pfet_05v0 W=18.75u L=8.0u
MDUM_PREF_1 vdd_5v0 vdd_5v0 vdd_5v0 vdd_5v0 pfet_05v0 W=18.75u L=8.0u
MDUM_PREF_2 vdd_5v0 vdd_5v0 vdd_5v0 vdd_5v0 pfet_05v0 W=18.75u L=8.0u
MDUM_PREF_3 vdd_5v0 vdd_5v0 vdd_5v0 vdd_5v0 pfet_05v0 W=18.75u L=8.0u
MDUM_PREF_4 vdd_5v0 vdd_5v0 vdd_5v0 vdd_5v0 pfet_05v0 W=18.75u L=8.0u
MDUM_PREF_5 vdd_5v0 vdd_5v0 vdd_5v0 vdd_5v0 pfet_05v0 W=18.75u L=8.0u
MDUM_PREF_6 vdd_5v0 vdd_5v0 vdd_5v0 vdd_5v0 pfet_05v0 W=18.75u L=8.0u
MDUM_PREF_7 vdd_5v0 vdd_5v0 vdd_5v0 vdd_5v0 pfet_05v0 W=18.75u L=8.0u
MDUM_PREF_8 vdd_5v0 vdd_5v0 vdd_5v0 vdd_5v0 pfet_05v0 W=18.75u L=8.0u
MDUM_PREF_9 vdd_5v0 vdd_5v0 vdd_5v0 vdd_5v0 pfet_05v0 W=18.75u L=8.0u
MDUM_PREF_10 vdd_5v0 vdd_5v0 vdd_5v0 vdd_5v0 pfet_05v0 W=18.75u L=8.0u
MDUM_PREF_11 vdd_5v0 vdd_5v0 vdd_5v0 vdd_5v0 pfet_05v0 W=18.75u L=8.0u
MDUM_PREF_12 vdd_5v0 vdd_5v0 vdd_5v0 vdd_5v0 pfet_05v0 W=18.75u L=8.0u
MDUM_PREF_13 vdd_5v0 vdd_5v0 vdd_5v0 vdd_5v0 pfet_05v0 W=18.75u L=8.0u
MPRMIR_0 vbn_i vbp_i vdd_5v0 vdd_5v0 pfet_05v0 W=18.75u L=8.0u
MPREF_0 vbp_i vbp_i vdd_5v0 vdd_5v0 pfet_05v0 W=18.75u L=8.0u
MPRMIR_1 vbn_i vbp_i vdd_5v0 vdd_5v0 pfet_05v0 W=18.75u L=8.0u
MPREF_1 vbp_i vbp_i vdd_5v0 vdd_5v0 pfet_05v0 W=18.75u L=8.0u
MPREF_2 vbp_i vbp_i vdd_5v0 vdd_5v0 pfet_05v0 W=18.75u L=8.0u
MDUM_PREF_14 vdd_5v0 vdd_5v0 vdd_5v0 vdd_5v0 pfet_05v0 W=18.75u L=8.0u
MPRMIR_2 vbn_i vbp_i vdd_5v0 vdd_5v0 pfet_05v0 W=18.75u L=8.0u
MPRMIR_3 vbn_i vbp_i vdd_5v0 vdd_5v0 pfet_05v0 W=18.75u L=8.0u
MPREF_3 vbp_i vbp_i vdd_5v0 vdd_5v0 pfet_05v0 W=18.75u L=8.0u
MPREF_4 vbp_i vbp_i vdd_5v0 vdd_5v0 pfet_05v0 W=18.75u L=8.0u
MPRMIR_4 vbn_i vbp_i vdd_5v0 vdd_5v0 pfet_05v0 W=18.75u L=8.0u
MDUM_PREF_15 vdd_5v0 vdd_5v0 vdd_5v0 vdd_5v0 pfet_05v0 W=18.75u L=8.0u
MDUM_PREF_16 vdd_5v0 vdd_5v0 vdd_5v0 vdd_5v0 pfet_05v0 W=18.75u L=8.0u
MDUM_PREF_17 vdd_5v0 vdd_5v0 vdd_5v0 vdd_5v0 pfet_05v0 W=18.75u L=8.0u
MDUM_PREF_18 vdd_5v0 vdd_5v0 vdd_5v0 vdd_5v0 pfet_05v0 W=18.75u L=8.0u
MDUM_PREF_19 vdd_5v0 vdd_5v0 vdd_5v0 vdd_5v0 pfet_05v0 W=18.75u L=8.0u
MDUM_PREF_20 vdd_5v0 vdd_5v0 vdd_5v0 vdd_5v0 pfet_05v0 W=18.75u L=8.0u
MDUM_PREF_21 vdd_5v0 vdd_5v0 vdd_5v0 vdd_5v0 pfet_05v0 W=18.75u L=8.0u
MDUM_PREF_22 vdd_5v0 vdd_5v0 vdd_5v0 vdd_5v0 pfet_05v0 W=18.75u L=8.0u
MDUM_PREF_23 vdd_5v0 vdd_5v0 vdd_5v0 vdd_5v0 pfet_05v0 W=18.75u L=8.0u
MDUM_PREF_24 vdd_5v0 vdd_5v0 vdd_5v0 vdd_5v0 pfet_05v0 W=18.75u L=8.0u
MDUM_PREF_25 vdd_5v0 vdd_5v0 vdd_5v0 vdd_5v0 pfet_05v0 W=18.75u L=8.0u
MDUM_PREF_26 vdd_5v0 vdd_5v0 vdd_5v0 vdd_5v0 pfet_05v0 W=18.75u L=8.0u
MDUM_PREF_27 vdd_5v0 vdd_5v0 vdd_5v0 vdd_5v0 pfet_05v0 W=18.75u L=8.0u
MDUM_PREF_28 vdd_5v0 vdd_5v0 vdd_5v0 vdd_5v0 pfet_05v0 W=18.75u L=8.0u
MVBPCASLOW_0 vbp_cas vbp_cas vbp_bias vdd_5v0 pfet_05v0 W=18.93u L=8.0u
MVBPCASLOW_1 vbp_cas vbp_cas vbp_bias vdd_5v0 pfet_05v0 W=18.93u L=8.0u
MVBPCASLOW_2 vbp_cas vbp_cas vbp_bias vdd_5v0 pfet_05v0 W=18.93u L=8.0u
MVBPCASLOW_3 vbp_cas vbp_cas vbp_bias vdd_5v0 pfet_05v0 W=18.93u L=8.0u
MVBPCASLOW_4 vbp_cas vbp_cas vbp_bias vdd_5v0 pfet_05v0 W=18.93u L=8.0u
MVBPCASLOW_5 vbp_cas vbp_cas vbp_bias vdd_5v0 pfet_05v0 W=18.93u L=8.0u
MVBPCASLOW_6 vbp_cas vbp_cas vbp_bias vdd_5v0 pfet_05v0 W=18.93u L=8.0u
MVBPCASLOW_7 vbp_cas vbp_cas vbp_bias vdd_5v0 pfet_05v0 W=18.93u L=8.0u
MVBPCASLOW_8 vbp_cas vbp_cas vbp_bias vdd_5v0 pfet_05v0 W=18.93u L=8.0u
MVBPCASLOW_9 vbp_cas vbp_cas vbp_bias vdd_5v0 pfet_05v0 W=18.93u L=8.0u
MVBPCASHIGHER_0 vbp_bias vbp_bias vdd_5v0 vdd_5v0 pfet_03v3 W=19.06u L=8.0u
MVBPCASHIGHER_1 vbp_bias vbp_bias vdd_5v0 vdd_5v0 pfet_03v3 W=19.06u L=8.0u
MVBPCASHIGHER_2 vbp_bias vbp_bias vdd_5v0 vdd_5v0 pfet_03v3 W=19.06u L=8.0u
MVBPCASHIGHER_3 vbp_bias vbp_bias vdd_5v0 vdd_5v0 pfet_03v3 W=19.06u L=8.0u
MVBPCASHIGHER_4 vbp_bias vbp_bias vdd_5v0 vdd_5v0 pfet_03v3 W=19.06u L=8.0u
MVBPCASHIGHER_5 vbp_bias vbp_bias vdd_5v0 vdd_5v0 pfet_03v3 W=19.06u L=8.0u
MVBPCASHIGHER_6 vbp_bias vbp_bias vdd_5v0 vdd_5v0 pfet_03v3 W=19.06u L=8.0u
MVBPCASHIGHER_7 vbp_bias vbp_bias vdd_5v0 vdd_5v0 pfet_03v3 W=19.06u L=8.0u
MVBPCASHIGHER_8 vbp_bias vbp_bias vdd_5v0 vdd_5v0 pfet_03v3 W=19.06u L=8.0u
MSUPPDET_0 iref_gate vbp_i vdd_5v0 vdd_5v0 pfet_05v0 W=80.0u L=1.0u
MSUPPDET_1 iref_gate vbp_i vdd_5v0 vdd_5v0 pfet_05v0 W=80.0u L=1.0u
RR4 vss_5v0 net3 vdd_5v0 pplus_u W=1.0u L=232.53u
MRB_P_0 psrg_vnc vbp_i vdd_5v0 vdd_5v0 pfet_05v0 W=17.74u L=4.0u
MRB_P_1 psrg_vnc vbp_i vdd_5v0 vdd_5v0 pfet_05v0 W=17.74u L=4.0u
MRB_P_2 psrg_vnc vbp_i vdd_5v0 vdd_5v0 pfet_05v0 W=17.74u L=4.0u
MRB_P_3 psrg_vnc vbp_i vdd_5v0 vdd_5v0 pfet_05v0 W=17.74u L=4.0u
MRB_P_4 psrg_vnc vbp_i vdd_5v0 vdd_5v0 pfet_05v0 W=17.74u L=4.0u
MRB_P_5 psrg_vnc vbp_i vdd_5v0 vdd_5v0 pfet_05v0 W=17.74u L=4.0u
MRB_P_6 psrg_vnc vbp_i vdd_5v0 vdd_5v0 pfet_05v0 W=17.74u L=4.0u
MM24_0 rbit1top b0_b rbit0top vdd_3v3 pfet_03v3 W=40.0u L=0.28u
MM24_1 rbit1top b0_b rbit0top vdd_3v3 pfet_03v3 W=40.0u L=0.28u
MM24_2 rbit1top b0_b rbit0top vdd_3v3 pfet_03v3 W=40.0u L=0.28u
MM24_3 rbit1top b0_b rbit0top vdd_3v3 pfet_03v3 W=40.0u L=0.28u
MM24_4 rbit1top b0_b rbit0top vdd_3v3 pfet_03v3 W=40.0u L=0.28u
MM24_5 rbit1top b0_b rbit0top vdd_3v3 pfet_03v3 W=40.0u L=0.28u
MM26_0 rbit2top b1_b rbit1top vdd_3v3 pfet_03v3 W=40.0u L=0.28u
MM26_1 rbit2top b1_b rbit1top vdd_3v3 pfet_03v3 W=40.0u L=0.28u
MM26_2 rbit2top b1_b rbit1top vdd_3v3 pfet_03v3 W=40.0u L=0.28u
MM25_0 rbit0top dig_in[0] rbit1top vss_3v3 nfet_03v3 W=40.0u L=0.28u
MM25_1 rbit0top dig_in[0] rbit1top vss_3v3 nfet_03v3 W=40.0u L=0.28u
MM27 rbit1top dig_in[1] rbit2top vss_3v3 nfet_03v3 W=40.0u L=0.28u
MM30 rbit4top b3_b rbit3top vdd_3v3 pfet_03v3 W=30.0u L=0.28u
MM28_0 rbit3top b2_b rbit2top vdd_3v3 pfet_03v3 W=20.0u L=0.28u
MM28_1 rbit3top b2_b rbit2top vdd_3v3 pfet_03v3 W=20.0u L=0.28u
MM28_2 rbit3top b2_b rbit2top vdd_3v3 pfet_03v3 W=20.0u L=0.28u
MM29 rbit2top dig_in[2] rbit3top vss_3v3 nfet_03v3 W=20.0u L=0.28u
MM32 rbit5top b4_b rbit4top vdd_3v3 pfet_03v3 W=15.0u L=0.28u
MM31 rbit3top dig_in[3] rbit4top vss_3v3 nfet_03v3 W=10.0u L=0.28u
MM34 rbit6top b5_b rbit5top vdd_3v3 pfet_03v3 W=7.5u L=0.28u
MM33 rbit4top dig_in[4] rbit5top vss_3v3 nfet_03v3 W=5.0u L=0.28u
MM36 vq3 b6_b rbit6top vdd_3v3 pfet_03v3 W=3.75u L=0.28u
MM39 b0_b dig_in[0] vdd_3v3 vdd_3v3 pfet_03v3 W=3.0u L=0.5u
MM41 b1_b dig_in[1] vdd_3v3 vdd_3v3 pfet_03v3 W=3.0u L=0.5u
MM43 b2_b dig_in[2] vdd_3v3 vdd_3v3 pfet_03v3 W=3.0u L=0.5u
MM45 b3_b dig_in[3] vdd_3v3 vdd_3v3 pfet_03v3 W=3.0u L=0.5u
MM47 b4_b dig_in[4] vdd_3v3 vdd_3v3 pfet_03v3 W=3.0u L=0.5u
MM49 b5_b dig_in[5] vdd_3v3 vdd_3v3 pfet_03v3 W=3.0u L=0.5u
MM51 b6_b dig_in[6] vdd_3v3 vdd_3v3 pfet_03v3 W=3.0u L=0.5u
MM35 rbit5top dig_in[5] rbit6top vss_3v3 nfet_03v3 W=2.5u L=0.28u
MM37 rbit6top dig_in[6] vq3 vss_3v3 nfet_03v3 W=1.25u L=0.28u
MM38 b0_b dig_in[0] vss_3v3 vss_3v3 nfet_03v3 W=1.0u L=0.5u
MM40 b1_b dig_in[1] vss_3v3 vss_3v3 nfet_03v3 W=1.0u L=0.5u
MM42 b2_b dig_in[2] vss_3v3 vss_3v3 nfet_03v3 W=1.0u L=0.5u
MM44 b3_b dig_in[3] vss_3v3 vss_3v3 nfet_03v3 W=1.0u L=0.5u
MM46 b4_b dig_in[4] vss_3v3 vss_3v3 nfet_03v3 W=1.0u L=0.5u
MM48 b5_b dig_in[5] vss_3v3 vss_3v3 nfet_03v3 W=1.0u L=0.5u
MM50 b6_b dig_in[6] vss_3v3 vss_3v3 nfet_03v3 W=1.0u L=0.5u
RRFIXED rfix0 s4_an[0] vss_5v0 ppolyf_u_1k W=6.6000000000000005u L=128.0u
RRB6 vq3 rbit6top vss_5v0 ppolyf_u_1k W=6.6000000000000005u L=128.0u
RRFIXED1 rfix1 rfix0 vss_5v0 ppolyf_u_1k W=6.6000000000000005u L=128.0u
RRFIXED2 rfix2 rfix1 vss_5v0 ppolyf_u_1k W=6.6000000000000005u L=128.0u
RRFIXED3 rbit0top rfix2 vss_5v0 ppolyf_u_1k W=6.6000000000000005u L=128.0u
RRB5 rbit6top rbit5top vss_5v0 ppolyf_u_1k W=6.6000000000000005u L=64.0u
RRB4 rbit5top rbit4top vss_5v0 ppolyf_u_1k W=6.6000000000000005u L=32.0u
RRB3 rbit4top rbit3top vss_5v0 ppolyf_u_1k W=6.6000000000000005u L=16.0u
RRB2 rbit3top rbit2top vss_5v0 ppolyf_u_1k W=6.6000000000000005u L=8.0u
RRB0 rbit1top rbit0top vss_5v0 ppolyf_u_1k W=6.6000000000000005u L=2.0u
RRB1 rbit2top rbit1top vss_5v0 ppolyf_u_1k W=6.6000000000000005u L=4.0u
MSUPN2 vsu1 vbp_i vsu2 vss_5v0 nfet_05v0 W=0.5u L=50.0u
MSUPN3 vsu2 vbp_i vss_5v0 vss_5v0 nfet_05v0 W=0.5u L=50.0u
MSUPN1 iref_gate vbp_i vsu1 vss_5v0 nfet_05v0 W=0.5u L=50.0u
MNTAIL vbp_tail vbn_i vss_5v0 vss_5v0 nfet_05v0 W=13.95u L=8.0u
MN2 vbp_i vbn_i net4 vss_5v0 nfet_05v0 W=9.13u L=8.0u
MN1 vbn_i vbn_i vss_5v0 vss_5v0 nfet_05v0 W=7.78u L=8.0u
MN3 vbp_cas vbn_i vss_5v0 vss_5v0 nfet_05v0 W=0.65u L=8.0u
MVBPTAIL_0 vbp_tail vbp_tail vdd_5v0 vdd_5v0 pfet_03v3 W=13.75u L=6.0u
MVBPTAIL_1 vbp_tail vbp_tail vdd_5v0 vdd_5v0 pfet_03v3 W=13.75u L=6.0u
MVBPTAIL_2 vbp_tail vbp_tail vdd_5v0 vdd_5v0 pfet_03v3 W=13.75u L=6.0u
RR3 net3 net4 vss_5v0 nwell W=2.0u L=20.19u
MRB_NU psrg_vnc psrg_vnc rb_mid vss_5v0 nfet_05v0 W=0.71u L=20.0u
MRB_NL rb_mid rb_mid vss_5v0 vss_5v0 nfet_05v0 W=0.54u L=20.0u
MAP aux_gate vcasp vdd_5v0 vdd_5v0 pfet_05v0 W=0.5u L=10.0u
MMSU_LOAD su_state vbp_tail vdd_5v0 vdd_5v0 pfet_05v0 W=1.0u L=8.0u
MMSU_HYS su_state vsu vdd_5v0 vdd_5v0 pfet_05v0 W=1.0u L=8.0u
MM20 vbn aux_gate vdd_5v0 vdd_5v0 pfet_05v0 W=0.5u L=8.0u
MSUPINJ vbn_i iref_gate vdd_5v0 vdd_5v0 pfet_05v0 W=0.5u L=8.0u
MAN aux_gate vbn_i vss_5v0 vss_5v0 nfet_05v0 W=1.0u L=8.0u
MVBNFOLDLOW vnx_bias vnx_bias vss_5v0 vss_5v0 nfet_03v3 W=1.62u L=8.0u
MVBNFOLDHIGH vbn_fold vbn_fold vnx_bias vss_5v0 nfet_05v0 W=4.62u L=6.0u
MM6 vsu psrg_m3_feed vdd_5v0 vdd_5v0 pfet_05v0 W=2.0u L=2.0u
MM19 vsua vcasp vdd_5v0 vdd_5v0 pfet_05v0 W=2.0u L=2.0u
MM7 vgn1 aux_gate psrg_m3_feed vdd_5v0 pfet_05v0 W=2.0u L=2.0u
MM17 vcasp vcasp vdd_5v0 vdd_5v0 pfet_05v0 W=0.9u L=2.0u
MM8 vsu vsu bgsu1 vss_5v0 nfet_05v0 W=1.0u L=2.0u
MM21 vsua vsua auxsu1 vss_5v0 nfet_05v0 W=1.0u L=2.0u
MM9 bgsu1 bgsu1 bgsu2 vss_5v0 nfet_03v3 W=1.0u L=2.0u
MM10 bgsu2 bgsu2 vss_5v0 vss_5v0 nfet_03v3 W=1.0u L=2.0u
MM22 auxsu1 auxsu1 auxsu2 vss_5v0 nfet_03v3 W=1.0u L=2.0u
MM23 auxsu2 auxsu2 vss_5v0 vss_5v0 nfet_03v3 W=1.0u L=2.0u
.ends slot_4
