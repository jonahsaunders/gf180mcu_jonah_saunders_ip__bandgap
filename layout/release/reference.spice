* Original schematic dimensions; ideal 0 V probes are net aliases.
.subckt Bandgap_Core_Res avdd avss vref b0 b1 b2 b3 b4 b5 b6 dvss dvdd
CC2 vref avss cap_mim_2f0fF W=70.7u L=70.7u
CC3 vref avss cap_mim_2f0fF W=70.7u L=70.7u
CC4 vref avss cap_mim_2f0fF W=70.7u L=70.7u
CC5 vref avss cap_mim_2f0fF W=70.7u L=70.7u
CC6 vref avss cap_mim_2f0fF W=70.7u L=70.7u
CC7 vref avss cap_mim_2f0fF W=70.7u L=70.7u
CC8 vref avss cap_mim_2f0fF W=70.7u L=70.7u
CC9 vref avss cap_mim_2f0fF W=70.7u L=70.7u
CC10 vref avss cap_mim_2f0fF W=70.7u L=70.7u
CC11 vref avss cap_mim_2f0fF W=70.7u L=70.7u
CC1 vgn2 avss cap_mim_2f0fF W=59.0u L=59.0u
MM24_0 rbit1top b0_b rbit0top dvdd pfet_03v3 W=40.0u L=0.28u
MM24_1 rbit1top b0_b rbit0top dvdd pfet_03v3 W=40.0u L=0.28u
MM24_2 rbit1top b0_b rbit0top dvdd pfet_03v3 W=40.0u L=0.28u
MM24_3 rbit1top b0_b rbit0top dvdd pfet_03v3 W=40.0u L=0.28u
MM24_4 rbit1top b0_b rbit0top dvdd pfet_03v3 W=40.0u L=0.28u
MM24_5 rbit1top b0_b rbit0top dvdd pfet_03v3 W=40.0u L=0.28u
MM26_0 rbit2top b1_b rbit1top dvdd pfet_03v3 W=40.0u L=0.28u
MM26_1 rbit2top b1_b rbit1top dvdd pfet_03v3 W=40.0u L=0.28u
MM26_2 rbit2top b1_b rbit1top dvdd pfet_03v3 W=40.0u L=0.28u
MM25_0 rbit0top b0 rbit1top dvss nfet_03v3 W=40.0u L=0.28u
MM25_1 rbit0top b0 rbit1top dvss nfet_03v3 W=40.0u L=0.28u
MM27 rbit1top b1 rbit2top dvss nfet_03v3 W=40.0u L=0.28u
MM30 rbit4top b3_b rbit3top dvdd pfet_03v3 W=30.0u L=0.28u
MM28_0 rbit3top b2_b rbit2top dvdd pfet_03v3 W=20.0u L=0.28u
MM28_1 rbit3top b2_b rbit2top dvdd pfet_03v3 W=20.0u L=0.28u
MM28_2 rbit3top b2_b rbit2top dvdd pfet_03v3 W=20.0u L=0.28u
MM29 rbit2top b2 rbit3top dvss nfet_03v3 W=20.0u L=0.28u
MM32 rbit5top b4_b rbit4top dvdd pfet_03v3 W=15.0u L=0.28u
MM31 rbit3top b3 rbit4top dvss nfet_03v3 W=10.0u L=0.28u
MM34 rbit6top b5_b rbit5top dvdd pfet_03v3 W=7.5u L=0.28u
MM33 rbit4top b4 rbit5top dvss nfet_03v3 W=5.0u L=0.28u
MM36 vq3 b6_b rbit6top dvdd pfet_03v3 W=3.75u L=0.28u
MM39 b0_b b0 dvdd dvdd pfet_03v3 W=3.0u L=0.5u
MM41 b1_b b1 dvdd dvdd pfet_03v3 W=3.0u L=0.5u
MM43 b2_b b2 dvdd dvdd pfet_03v3 W=3.0u L=0.5u
MM45 b3_b b3 dvdd dvdd pfet_03v3 W=3.0u L=0.5u
MM47 b4_b b4 dvdd dvdd pfet_03v3 W=3.0u L=0.5u
MM49 b5_b b5 dvdd dvdd pfet_03v3 W=3.0u L=0.5u
MM51 b6_b b6 dvdd dvdd pfet_03v3 W=3.0u L=0.5u
MM35 rbit5top b5 rbit6top dvss nfet_03v3 W=2.5u L=0.28u
MM37 rbit6top b6 vq3 dvss nfet_03v3 W=1.25u L=0.28u
MM38 b0_b b0 dvss dvss nfet_03v3 W=1.0u L=0.5u
MM40 b1_b b1 dvss dvss nfet_03v3 W=1.0u L=0.5u
MM42 b2_b b2 dvss dvss nfet_03v3 W=1.0u L=0.5u
MM44 b3_b b3 dvss dvss nfet_03v3 W=1.0u L=0.5u
MM46 b4_b b4 dvss dvss nfet_03v3 W=1.0u L=0.5u
MM48 b5_b b5 dvss dvss nfet_03v3 W=1.0u L=0.5u
MM50 b6_b b6 dvss dvss nfet_03v3 W=1.0u L=0.5u
RRFIXED rfix0 vref avss ppolyf_u_1k W=6.6000000000000005u L=128.0u
RRB6 vq3 rbit6top avss ppolyf_u_1k W=6.6000000000000005u L=128.0u
RRFIXED1 rfix1 rfix0 avss ppolyf_u_1k W=6.6000000000000005u L=128.0u
RRFIXED2 rfix2 rfix1 avss ppolyf_u_1k W=6.6000000000000005u L=128.0u
RRFIXED3 rbit0top rfix2 avss ppolyf_u_1k W=6.6000000000000005u L=128.0u
RRB5 rbit6top rbit5top avss ppolyf_u_1k W=6.6000000000000005u L=64.0u
RRB4 rbit5top rbit4top avss ppolyf_u_1k W=6.6000000000000005u L=32.0u
RRB3 rbit4top rbit3top avss ppolyf_u_1k W=6.6000000000000005u L=16.0u
RRB2 rbit3top rbit2top avss ppolyf_u_1k W=6.6000000000000005u L=8.0u
RRB0 rbit1top rbit0top avss ppolyf_u_1k W=6.6000000000000005u L=2.0u
RRB1 rbit2top rbit1top avss ppolyf_u_1k W=6.6000000000000005u L=4.0u
RR4 avss net3 avdd pplus_u W=1.0u L=232.53u
MPRMIR_0 vbn_i vbp_i avdd avdd pfet_05v0 W=18.75u L=8.0u
MPREF_0 vbp_i vbp_i avdd avdd pfet_05v0 W=18.75u L=8.0u
MPRMIR_1 vbn_i vbp_i avdd avdd pfet_05v0 W=18.75u L=8.0u
MPREF_1 vbp_i vbp_i avdd avdd pfet_05v0 W=18.75u L=8.0u
MPREF_2 vbp_i vbp_i avdd avdd pfet_05v0 W=18.75u L=8.0u
MPRMIR_2 vbn_i vbp_i avdd avdd pfet_05v0 W=18.75u L=8.0u
MPRMIR_3 vbn_i vbp_i avdd avdd pfet_05v0 W=18.75u L=8.0u
MPREF_3 vbp_i vbp_i avdd avdd pfet_05v0 W=18.75u L=8.0u
MPREF_4 vbp_i vbp_i avdd avdd pfet_05v0 W=18.75u L=8.0u
MPRMIR_4 vbn_i vbp_i avdd avdd pfet_05v0 W=18.75u L=8.0u
MMINN_0 xf2 v2 vsp avdd pfet_05v0 W=54.89u L=4.0u
MMINP_0 xf1 v1 vsp avdd pfet_05v0 W=54.89u L=4.0u
MMINN_1 xf2 v2 vsp avdd pfet_05v0 W=54.89u L=4.0u
MMINP_1 xf1 v1 vsp avdd pfet_05v0 W=54.89u L=4.0u
MMINP_2 xf1 v1 vsp avdd pfet_05v0 W=54.89u L=4.0u
MMINN_2 xf2 v2 vsp avdd pfet_05v0 W=54.89u L=4.0u
MMINN_3 xf2 v2 vsp avdd pfet_05v0 W=54.89u L=4.0u
MMINP_3 xf1 v1 vsp avdd pfet_05v0 W=54.89u L=4.0u
MMINP_4 xf1 v1 vsp avdd pfet_05v0 W=54.89u L=4.0u
MMINN_4 xf2 v2 vsp avdd pfet_05v0 W=54.89u L=4.0u
MSUPPDET_0 iref_gate vbp_i avdd avdd pfet_05v0 W=80.0u L=1.0u
MSUPPDET_1 iref_gate vbp_i avdd avdd pfet_05v0 W=80.0u L=1.0u
MPCAS1_0 y1 vbp_cas pm1 avdd pfet_05v0 W=22.21u L=8.0u
MPCAS2_0 vgn2 vbp_cas pm2 avdd pfet_05v0 W=22.21u L=8.0u
MPCAS2_1 vgn2 vbp_cas pm2 avdd pfet_05v0 W=22.21u L=8.0u
MPCAS1_1 y1 vbp_cas pm1 avdd pfet_05v0 W=22.21u L=8.0u
MPCAS1_2 y1 vbp_cas pm1 avdd pfet_05v0 W=22.21u L=8.0u
MPCAS2_2 vgn2 vbp_cas pm2 avdd pfet_05v0 W=22.21u L=8.0u
MPCAS2_3 vgn2 vbp_cas pm2 avdd pfet_05v0 W=22.21u L=8.0u
MPCAS1_3 y1 vbp_cas pm1 avdd pfet_05v0 W=22.21u L=8.0u
MPCAS1_4 y1 vbp_cas pm1 avdd pfet_05v0 W=22.21u L=8.0u
MPCAS2_4 vgn2 vbp_cas pm2 avdd pfet_05v0 W=22.21u L=8.0u
MPCAS2_5 vgn2 vbp_cas pm2 avdd pfet_05v0 W=22.21u L=8.0u
MPCAS1_5 y1 vbp_cas pm1 avdd pfet_05v0 W=22.21u L=8.0u
MMSINK1_0 xf1 vbn_sink avss avss nfet_05v0 W=16.34u L=8.0u
MMSINK2_0 xf2 vbn_sink avss avss nfet_05v0 W=16.34u L=8.0u
MMSINK2_1 xf2 vbn_sink avss avss nfet_05v0 W=16.34u L=8.0u
MMSINK1_1 xf1 vbn_sink avss avss nfet_05v0 W=16.34u L=8.0u
MMSINK1_2 xf1 vbn_sink avss avss nfet_05v0 W=16.34u L=8.0u
MMSINK2_2 xf2 vbn_sink avss avss nfet_05v0 W=16.34u L=8.0u
MMSINK2_3 xf2 vbn_sink avss avss nfet_05v0 W=16.34u L=8.0u
MMSINK1_3 xf1 vbn_sink avss avss nfet_05v0 W=16.34u L=8.0u
MMSINK1_4 xf1 vbn_sink avss avss nfet_05v0 W=16.34u L=8.0u
MMSINK2_4 xf2 vbn_sink avss avss nfet_05v0 W=16.34u L=8.0u
MMSINK2_5 xf2 vbn_sink avss avss nfet_05v0 W=16.34u L=8.0u
MMSINK1_5 xf1 vbn_sink avss avss nfet_05v0 W=16.34u L=8.0u
MMPSINK_0 vbn_sink vbp_i avdd avdd pfet_05v0 W=18.95u L=8.0u
MMPSINK_1 vbn_sink vbp_i avdd avdd pfet_05v0 W=18.95u L=8.0u
MMPSINK_2 vbn_sink vbp_i avdd avdd pfet_05v0 W=18.95u L=8.0u
MMPSINK_3 vbn_sink vbp_i avdd avdd pfet_05v0 W=18.95u L=8.0u
MMPSINK_4 vbn_sink vbp_i avdd avdd pfet_05v0 W=18.95u L=8.0u
MMPSINK_5 vbn_sink vbp_i avdd avdd pfet_05v0 W=18.95u L=8.0u
MMPSINK_6 vbn_sink vbp_i avdd avdd pfet_05v0 W=18.95u L=8.0u
MMPSINK_7 vbn_sink vbp_i avdd avdd pfet_05v0 W=18.95u L=8.0u
MMPSINK_8 vbn_sink vbp_i avdd avdd pfet_05v0 W=18.95u L=8.0u
MMPSINK_9 vbn_sink vbp_i avdd avdd pfet_05v0 W=18.95u L=8.0u
MMPSINK_10 vbn_sink vbp_i avdd avdd pfet_05v0 W=18.95u L=8.0u
MMPSINK_11 vbn_sink vbp_i avdd avdd pfet_05v0 W=18.95u L=8.0u
MMPSINK_12 vbn_sink vbp_i avdd avdd pfet_05v0 W=18.95u L=8.0u
MMPSINK_13 vbn_sink vbp_i avdd avdd pfet_05v0 W=18.95u L=8.0u
MMPSINK_14 vbn_sink vbp_i avdd avdd pfet_05v0 W=18.95u L=8.0u
MMPSINK_15 vbn_sink vbp_i avdd avdd pfet_05v0 W=18.95u L=8.0u
MMPSINK_16 vbn_sink vbp_i avdd avdd pfet_05v0 W=18.95u L=8.0u
MMPFOLD_0 vbn_fold vbp_i avdd avdd pfet_05v0 W=18.99u L=8.0u
MMPFOLD_1 vbn_fold vbp_i avdd avdd pfet_05v0 W=18.99u L=8.0u
MMPFOLD_2 vbn_fold vbp_i avdd avdd pfet_05v0 W=18.99u L=8.0u
MMPFOLD_3 vbn_fold vbp_i avdd avdd pfet_05v0 W=18.99u L=8.0u
MMPFOLD_4 vbn_fold vbp_i avdd avdd pfet_05v0 W=18.99u L=8.0u
MMPFOLD_5 vbn_fold vbp_i avdd avdd pfet_05v0 W=18.99u L=8.0u
MMPFOLD_6 vbn_fold vbp_i avdd avdd pfet_05v0 W=18.99u L=8.0u
MMPFOLD_7 vbn_fold vbp_i avdd avdd pfet_05v0 W=18.99u L=8.0u
MMPFOLD_8 vbn_fold vbp_i avdd avdd pfet_05v0 W=18.99u L=8.0u
MMPFOLD_9 vbn_fold vbp_i avdd avdd pfet_05v0 W=18.99u L=8.0u
MMPFOLD_10 vbn_fold vbp_i avdd avdd pfet_05v0 W=18.99u L=8.0u
MMPFOLD_11 vbn_fold vbp_i avdd avdd pfet_05v0 W=18.99u L=8.0u
MVBPCASLOW_0 vbp_cas vbp_cas vbp_bias avdd pfet_05v0 W=18.93u L=8.0u
MVBPCASLOW_1 vbp_cas vbp_cas vbp_bias avdd pfet_05v0 W=18.93u L=8.0u
MVBPCASLOW_2 vbp_cas vbp_cas vbp_bias avdd pfet_05v0 W=18.93u L=8.0u
MVBPCASLOW_3 vbp_cas vbp_cas vbp_bias avdd pfet_05v0 W=18.93u L=8.0u
MVBPCASLOW_4 vbp_cas vbp_cas vbp_bias avdd pfet_05v0 W=18.93u L=8.0u
MVBPCASLOW_5 vbp_cas vbp_cas vbp_bias avdd pfet_05v0 W=18.93u L=8.0u
MVBPCASLOW_6 vbp_cas vbp_cas vbp_bias avdd pfet_05v0 W=18.93u L=8.0u
MVBPCASLOW_7 vbp_cas vbp_cas vbp_bias avdd pfet_05v0 W=18.93u L=8.0u
MVBPCASLOW_8 vbp_cas vbp_cas vbp_bias avdd pfet_05v0 W=18.93u L=8.0u
MVBPCASLOW_9 vbp_cas vbp_cas vbp_bias avdd pfet_05v0 W=18.93u L=8.0u
MVBPCASHIGHER_0 vbp_bias vbp_bias avdd avdd pfet_03v3 W=19.06u L=8.0u
MVBPCASHIGHER_1 vbp_bias vbp_bias avdd avdd pfet_03v3 W=19.06u L=8.0u
MVBPCASHIGHER_2 vbp_bias vbp_bias avdd avdd pfet_03v3 W=19.06u L=8.0u
MVBPCASHIGHER_3 vbp_bias vbp_bias avdd avdd pfet_03v3 W=19.06u L=8.0u
MVBPCASHIGHER_4 vbp_bias vbp_bias avdd avdd pfet_03v3 W=19.06u L=8.0u
MVBPCASHIGHER_5 vbp_bias vbp_bias avdd avdd pfet_03v3 W=19.06u L=8.0u
MVBPCASHIGHER_6 vbp_bias vbp_bias avdd avdd pfet_03v3 W=19.06u L=8.0u
MVBPCASHIGHER_7 vbp_bias vbp_bias avdd avdd pfet_03v3 W=19.06u L=8.0u
MVBPCASHIGHER_8 vbp_bias vbp_bias avdd avdd pfet_03v3 W=19.06u L=8.0u
MM1_0 vx2 psrg_m3_feed avdd avdd pfet_05v0 W=16.75u L=2.0u
MM2_0 vx1 psrg_m3_feed avdd avdd pfet_05v0 W=16.75u L=2.0u
MM5_0 vx3 psrg_m3_feed avdd avdd pfet_05v0 W=16.75u L=2.0u
MM5_1 vx3 psrg_m3_feed avdd avdd pfet_05v0 W=16.75u L=2.0u
MM2_1 vx1 psrg_m3_feed avdd avdd pfet_05v0 W=16.75u L=2.0u
MM1_1 vx2 psrg_m3_feed avdd avdd pfet_05v0 W=16.75u L=2.0u
MM1_2 vx2 psrg_m3_feed avdd avdd pfet_05v0 W=16.75u L=2.0u
MM2_2 vx1 psrg_m3_feed avdd avdd pfet_05v0 W=16.75u L=2.0u
MM5_2 vx3 psrg_m3_feed avdd avdd pfet_05v0 W=16.75u L=2.0u
MM5_3 vx3 psrg_m3_feed avdd avdd pfet_05v0 W=16.75u L=2.0u
MM2_3 vx1 psrg_m3_feed avdd avdd pfet_05v0 W=16.75u L=2.0u
MM1_3 vx2 psrg_m3_feed avdd avdd pfet_05v0 W=16.75u L=2.0u
MM1_4 vx2 psrg_m3_feed avdd avdd pfet_05v0 W=16.75u L=2.0u
MM2_4 vx1 psrg_m3_feed avdd avdd pfet_05v0 W=16.75u L=2.0u
MM5_4 vx3 psrg_m3_feed avdd avdd pfet_05v0 W=16.75u L=2.0u
MM5_5 vx3 psrg_m3_feed avdd avdd pfet_05v0 W=16.75u L=2.0u
MM2_5 vx1 psrg_m3_feed avdd avdd pfet_05v0 W=16.75u L=2.0u
MM1_5 vx2 psrg_m3_feed avdd avdd pfet_05v0 W=16.75u L=2.0u
MM11_0 vgn1 vcasp vx1 avdd pfet_05v0 W=16.42u L=4.0u
MM11_1 vgn1 vcasp vx1 avdd pfet_05v0 W=16.42u L=4.0u
MM12_0 psrg_m3_feed vcasp vx2 avdd pfet_05v0 W=16.42u L=4.0u
MM12_1 psrg_m3_feed vcasp vx2 avdd pfet_05v0 W=16.42u L=4.0u
MM13_0 vref vcasp vx3 avdd pfet_05v0 W=16.42u L=4.0u
MM13_1 vref vcasp vx3 avdd pfet_05v0 W=16.42u L=4.0u
MM13_2 vref vcasp vx3 avdd pfet_05v0 W=16.42u L=4.0u
MM11_2 vgn1 vcasp vx1 avdd pfet_05v0 W=16.42u L=4.0u
MM12_2 psrg_m3_feed vcasp vx2 avdd pfet_05v0 W=16.42u L=4.0u
MM13_3 vref vcasp vx3 avdd pfet_05v0 W=16.42u L=4.0u
MM12_3 psrg_m3_feed vcasp vx2 avdd pfet_05v0 W=16.42u L=4.0u
MM13_4 vref vcasp vx3 avdd pfet_05v0 W=16.42u L=4.0u
MM12_4 psrg_m3_feed vcasp vx2 avdd pfet_05v0 W=16.42u L=4.0u
MM11_3 vgn1 vcasp vx1 avdd pfet_05v0 W=16.42u L=4.0u
MM11_4 vgn1 vcasp vx1 avdd pfet_05v0 W=16.42u L=4.0u
MMTAIL_0 vsp vbp_tail avdd avdd pfet_03v3 W=28.91u L=6.0u
MMTAIL_1 vsp vbp_tail avdd avdd pfet_03v3 W=28.91u L=6.0u
MMTAIL_2 vsp vbp_tail avdd avdd pfet_03v3 W=28.91u L=6.0u
MMTAIL_3 vsp vbp_tail avdd avdd pfet_03v3 W=28.91u L=6.0u
MMTAIL_4 vsp vbp_tail avdd avdd pfet_03v3 W=28.91u L=6.0u
MMTAIL_5 vsp vbp_tail avdd avdd pfet_03v3 W=28.91u L=6.0u
MSUPN2 vsu1 vbp_i vsu2 avss nfet_05v0 W=0.5u L=50.0u
MSUPN3 vsu2 vbp_i avss avss nfet_05v0 W=0.5u L=50.0u
MSUPN1 iref_gate vbp_i vsu1 avss nfet_05v0 W=0.5u L=50.0u
MPLOAD1_0 pm1 y1 avdd avdd pfet_05v0 W=20.76u L=4.0u
MPLOAD2_0 pm2 y1 avdd avdd pfet_05v0 W=20.76u L=4.0u
MPLOAD2_1 pm2 y1 avdd avdd pfet_05v0 W=20.76u L=4.0u
MPLOAD1_1 pm1 y1 avdd avdd pfet_05v0 W=20.76u L=4.0u
MPLOAD1_2 pm1 y1 avdd avdd pfet_05v0 W=20.76u L=4.0u
MPLOAD2_2 pm2 y1 avdd avdd pfet_05v0 W=20.76u L=4.0u
MPLOAD2_3 pm2 y1 avdd avdd pfet_05v0 W=20.76u L=4.0u
MPLOAD1_3 pm1 y1 avdd avdd pfet_05v0 W=20.76u L=4.0u
MPLOAD1_4 pm1 y1 avdd avdd pfet_05v0 W=20.76u L=4.0u
MPLOAD2_4 pm2 y1 avdd avdd pfet_05v0 W=20.76u L=4.0u
MPLOAD2_5 pm2 y1 avdd avdd pfet_05v0 W=20.76u L=4.0u
MPLOAD1_5 pm1 y1 avdd avdd pfet_05v0 W=20.76u L=4.0u
MRB_P_0 psrg_vnc vbp_i avdd avdd pfet_05v0 W=17.74u L=4.0u
MRB_P_1 psrg_vnc vbp_i avdd avdd pfet_05v0 W=17.74u L=4.0u
MRB_P_2 psrg_vnc vbp_i avdd avdd pfet_05v0 W=17.74u L=4.0u
MRB_P_3 psrg_vnc vbp_i avdd avdd pfet_05v0 W=17.74u L=4.0u
MRB_P_4 psrg_vnc vbp_i avdd avdd pfet_05v0 W=17.74u L=4.0u
MRB_P_5 psrg_vnc vbp_i avdd avdd pfet_05v0 W=17.74u L=4.0u
MRB_P_6 psrg_vnc vbp_i avdd avdd pfet_05v0 W=17.74u L=4.0u
RR1 vq2 v2 avss ppolyf_u_1k W=4.0u L=42.1u
QQ2_0_0 avss avss vq2 pnp_05p00x05p00
QQ2_0_1 avss avss vq2 pnp_05p00x05p00
QQ2_0_2 avss avss vq2 pnp_05p00x05p00
QQ2_1_0 avss avss vq2 pnp_05p00x05p00
QQ1_1_1 avss avss v1 pnp_05p00x05p00
QQ2_1_2 avss avss vq2 pnp_05p00x05p00
QQ2_2_0 avss avss vq2 pnp_05p00x05p00
QQ2_2_1 avss avss vq2 pnp_05p00x05p00
QQ2_2_2 avss avss vq2 pnp_05p00x05p00
QQ3 avss avss vq3 pnp_05p00x05p00
MVBPTAIL_0 vbp_tail vbp_tail avdd avdd pfet_03v3 W=13.75u L=6.0u
MVBPTAIL_1 vbp_tail vbp_tail avdd avdd pfet_03v3 W=13.75u L=6.0u
MVBPTAIL_2 vbp_tail vbp_tail avdd avdd pfet_03v3 W=13.75u L=6.0u
RR3 net3 net4 avss nwell W=2.0u L=20.19u
MVBNSINK_0 vbn_sink vbn_sink avss avss nfet_05v0 W=12.31u L=8.0u
MVBNSINK_1 vbn_sink vbn_sink avss avss nfet_05v0 W=12.31u L=8.0u
MRB_NU psrg_vnc psrg_vnc rb_mid avss nfet_05v0 W=0.71u L=20.0u
MRB_NL rb_mid rb_mid avss avss nfet_05v0 W=0.54u L=20.0u
MMFOLD2 vgn2 vbn_fold xf2 avss nfet_05v0 W=18.49u L=6.0u
MMFOLD1 psrg_mf1_protected vbn_fold xf1 avss nfet_05v0 W=18.49u L=6.0u
MMFOLD1C y1 psrg_vnc psrg_mf1_protected avss nfet_05v0 W=18.49u L=6.0u
MM15 vbn vcasp vaux avdd pfet_05v0 W=16.0u L=4.0u
MM4_0 vgn1 vgn1 v1 avss nfet_05v0 W=14.6u L=4.0u
MM4_1 vgn1 vgn1 v1 avss nfet_05v0 W=14.6u L=4.0u
MM3_0 psrg_m3_protected vgn2 v2 avss nfet_05v0 W=14.6u L=4.0u
MM3_1 psrg_m3_protected vgn2 v2 avss nfet_05v0 W=14.6u L=4.0u
MM3C_0 psrg_m3_feed psrg_vnc psrg_m3_protected avss nfet_05v0 W=14.6u L=4.0u
MM3C_1 psrg_m3_feed psrg_vnc psrg_m3_protected avss nfet_05v0 W=14.6u L=4.0u
MNTAIL vbp_tail vbn_i avss avss nfet_05v0 W=13.95u L=8.0u
MM14_0 vaux psrg_m3_feed avdd avdd pfet_05v0 W=10.0u L=2.0u
MM14_1 vaux psrg_m3_feed avdd avdd pfet_05v0 W=10.0u L=2.0u
MAP aux_gate vcasp avdd avdd pfet_05v0 W=0.5u L=10.0u
MN2 vbp_i vbn_i net4 avss nfet_05v0 W=9.13u L=8.0u
MN1 vbn_i vbn_i avss avss nfet_05v0 W=7.78u L=8.0u
MM16 vbn vbn avss avss nfet_05v0 W=7.55u L=4.0u
MM18 vcasp vbn avss avss nfet_05v0 W=7.55u L=4.0u
MN3 vbp_cas vbn_i avss avss nfet_05v0 W=0.65u L=8.0u
MMSU_LOAD su_state vbp_tail avdd avdd pfet_05v0 W=1.0u L=8.0u
MMSU_HYS su_state vsu avdd avdd pfet_05v0 W=1.0u L=8.0u
MM20 vbn aux_gate avdd avdd pfet_05v0 W=0.5u L=8.0u
MSUPINJ vbn_i iref_gate avdd avdd pfet_05v0 W=0.5u L=8.0u
MAN aux_gate vbn_i avss avss nfet_05v0 W=1.0u L=8.0u
MVBNFOLDLOW vnx_bias vnx_bias avss avss nfet_03v3 W=1.62u L=8.0u
MVBNFOLDHIGH vbn_fold vbn_fold vnx_bias avss nfet_05v0 W=4.62u L=6.0u
MMSU_SENSE su_state vgn2 avss avss nfet_05v0 W=4.0u L=1.0u
MM6 vsu psrg_m3_feed avdd avdd pfet_05v0 W=2.0u L=2.0u
MM19 vsua vcasp avdd avdd pfet_05v0 W=2.0u L=2.0u
MM7 vgn1 aux_gate psrg_m3_feed avdd pfet_05v0 W=2.0u L=2.0u
MM17 vcasp vcasp avdd avdd pfet_05v0 W=0.9u L=2.0u
MM8 vsu vsu bgsu1 avss nfet_05v0 W=1.0u L=2.0u
MM21 vsua vsua auxsu1 avss nfet_05v0 W=1.0u L=2.0u
MM9 bgsu1 bgsu1 bgsu2 avss nfet_03v3 W=1.0u L=2.0u
MM10 bgsu2 bgsu2 avss avss nfet_03v3 W=1.0u L=2.0u
MM22 auxsu1 auxsu1 auxsu2 avss nfet_03v3 W=1.0u L=2.0u
MM23 auxsu2 auxsu2 avss avss nfet_03v3 W=1.0u L=2.0u
.ends Bandgap_Core_Res
