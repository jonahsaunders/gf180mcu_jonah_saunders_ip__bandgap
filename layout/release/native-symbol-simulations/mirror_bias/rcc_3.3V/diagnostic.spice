* Capacitance-conserving approximation; see conserve_pex_capacitance.py.
* Raw Magic exports remain available for independent review.
* NGSPICE file created from Bandgap_Core_Res.ext - technology: gf180mcuD
.subckt Bandgap_Core_Res avdd avss vref b0 b1 b2 b3 b4 b5 b6 dvss dvdd
Xpnp_05p00x05p00_0 avss avss vq3 pnp_05p00x05p00
Xpnp_05p00x05p00_1 avss avss vq2 pnp_05p00x05p00
Xpnp_05p00x05p00_2 avss avss vq2 pnp_05p00x05p00
Xpnp_05p00x05p00_4 avss avss vq2 pnp_05p00x05p00
Xpnp_05p00x05p00_3 avss avss vq2 pnp_05p00x05p00
Xpnp_05p00x05p00_5 avss avss v1 pnp_05p00x05p00
Xpnp_05p00x05p00_6 avss avss vq2 pnp_05p00x05p00
Xpnp_05p00x05p00_7 avss avss vq2 pnp_05p00x05p00
Xpnp_05p00x05p00_8 avss avss vq2 pnp_05p00x05p00
Xpnp_05p00x05p00_9 avss avss vq2 pnp_05p00x05p00
Xnwell_0 net3 net4 avss nwell r_length=20.19u r_width=2u
VAUD0 rbit0top.t9 audit_d0 0
X0 audit_d0 b0.t2 rbit1top.t8 dvss nfet_03v3 ad=17.6p pd=80.88u as=17.6p ps=80.88u w=40u l=0.28u
VAUD1 avdd.t745 audit_d1 0
X1 audit_d1 avdd.t742 avdd.t744 avdd.t743 pfet_05v0 ad=24.1516p pd=0.11066m as=0 ps=0 w=54.89u l=4u
VAUD2 avss audit_d2 0
X2 audit_d2 avss avss avss nfet_05v0 ad=3.322p pd=15.98u as=0.92119n ps=4.32012m w=7.55u l=4u M=10
VAUD3 avss audit_d3 0
X3 audit_d3 avss avss avss nfet_05v0 ad=7.1896p pd=33.56u as=0 ps=0 w=16.34u l=8u M=20
VAUD4 avdd.t394 audit_d4 0
X4 audit_d4 avdd.t391 avdd.t393 avdd.t392 pfet_05v0 ad=7.2248p pd=33.72u as=0 ps=0 w=16.42u l=4u
VAUD5 vbn_sink.t11 audit_d5 0
X5 audit_d5 vbp_i.t32 avdd.t61 avdd.t60 pfet_05v0 ad=8.338p pd=38.78u as=8.338p ps=38.78u w=18.95u l=8u
VAUD6 vbn_sink.t13 audit_d6 0
X6 audit_d6 vbp_i.t24 avdd.t69 avdd.t68 pfet_05v0 ad=8.338p pd=38.78u as=8.338p ps=38.78u w=18.95u l=8u
VAUD7 avdd.t450 audit_d7 0
X7 audit_d7 avdd.t447 avdd.t449 avdd.t448 pfet_05v0 ad=7.37p pd=34.38u as=0 ps=0 w=16.75u l=2u
VAUD8 avdd.t474 audit_d8 0
X8 audit_d8 avdd.t471 avdd.t473 avdd.t472 pfet_05v0 ad=7.37p pd=34.38u as=0 ps=0 w=16.75u l=2u
VAUD9 vbn_sink.t12 audit_d9 0
X9 audit_d9 vbp_i.t33 avdd.t63 avdd.t62 pfet_05v0 ad=8.338p pd=38.78u as=8.338p ps=38.78u w=18.95u l=8u
VAUD10 avdd.t278 audit_d10 0
X10 audit_d10 avdd.t275 avdd.t277 avdd.t276 pfet_05v0 ad=8.3556p pd=38.86u as=0 ps=0 w=18.99u l=8u
VAUD11 vbn_fold.t11 audit_d11 0
X11 audit_d11 vbp_i.t47 avdd.t892 avdd.t891 pfet_05v0 ad=8.3556p pd=38.86u as=8.3556p ps=38.86u w=18.99u l=8u
VAUD12 b3_b.t0 audit_d12 0
X12 audit_d12 b3.t0 dvdd.t27 dvdd.t26 pfet_03v3 ad=1.32p pd=6.88u as=1.32p ps=6.88u w=3u l=0.5u
VAUD13 vx1.t4 audit_d13 0
X13 audit_d13 psrg_m3_feed.t13 avdd.t1048 avdd.t1047 pfet_05v0 ad=7.37p pd=34.38u as=7.37p ps=34.38u w=16.75u l=2u
VAUD14 rbit3top.t4 audit_d14 0
X14 audit_d14 b2_b.t3 rbit2top.t4 dvdd.t23 pfet_03v3 ad=8.8p pd=40.88u as=8.8p ps=40.88u w=20u l=0.28u
VAUD15 pm1.t6 audit_d15 0
X15 audit_d15 y1.t13 avdd.t948 avdd.t947 pfet_05v0 ad=9.1344p pd=42.4u as=9.1344p ps=42.4u w=20.76u l=4u
VAUD16 vbn.t1 audit_d16 0
X16 audit_d16 vbn.t0 avss avss nfet_05v0 ad=3.322p pd=15.98u as=3.322p ps=15.98u w=7.55u l=4u
VAUD17 avdd.t210 audit_d17 0
X17 audit_d17 avdd.t207 avdd.t209 avdd.t208 pfet_05v0 ad=8.25p pd=38.38u as=0 ps=0 w=18.75u l=8u
VAUD18 avdd.t298 audit_d18 0
X18 audit_d18 avdd.t295 avdd.t297 avdd.t296 pfet_05v0 ad=8.338p pd=38.78u as=0 ps=0 w=18.95u l=8u
VAUD19 vgn2.t0 audit_d19 0
X19 audit_d19 vbn_fold.t14 xf2.t0 avss nfet_05v0 ad=8.1356p pd=37.86u as=8.1356p ps=37.86u w=18.49u l=6u
VAUD20 vbp_cas.t20 audit_d20 0
X20 audit_d20 vbn_i.t11 avss avss nfet_05v0 ad=0.286p pd=2.18u as=0.286p ps=2.18u w=0.65u l=8u
VAUD21 vbn_i.t6 audit_d21 0
X21 audit_d21 vbp_i.t52 avdd.t894 avdd.t893 pfet_05v0 ad=8.25p pd=38.38u as=8.25p ps=38.38u w=18.75u l=8u
VAUD22 avdd.t442 audit_d22 0
X22 audit_d22 avdd.t439 avdd.t441 avdd.t440 pfet_05v0 ad=7.2248p pd=33.72u as=0 ps=0 w=16.42u l=4u
VAUD23 vgn2.t1 audit_d23 0
X23 audit_d23 vbp_cas.t32 pm2.t2 avdd.t966 pfet_05v0 ad=9.7724p pd=45.3u as=9.7724p ps=45.3u w=22.21u l=8u
VAUD24 avdd.t626 audit_d24 0
X24 audit_d24 avdd.t623 avdd.t625 avdd.t624 pfet_05v0 ad=7.2248p pd=33.72u as=0 ps=0 w=16.42u l=4u
VAUD25 avdd.t861 audit_d25 0
X25 audit_d25 avdd.t858 avdd.t860 avdd.t859 pfet_05v0 ad=9.1344p pd=42.4u as=0 ps=0 w=20.76u l=4u
VAUD26 avdd.t638 audit_d26 0
X26 audit_d26 avdd.t635 avdd.t637 avdd.t636 pfet_05v0 ad=7.37p pd=34.38u as=0 ps=0 w=16.75u l=2u
VAUD27 avdd.t206 audit_d27 0
X27 audit_d27 avdd.t203 avdd.t205 avdd.t204 pfet_05v0 ad=8.25p pd=38.38u as=0 ps=0 w=18.75u l=8u
VAUD28 avdd.t294 audit_d28 0
X28 audit_d28 avdd.t291 avdd.t293 avdd.t292 pfet_05v0 ad=8.338p pd=38.78u as=0 ps=0 w=18.95u l=8u
VAUD29 avdd.t514 audit_d29 0
X29 audit_d29 avdd.t511 avdd.t513 avdd.t512 pfet_05v0 ad=24.1516p pd=0.11066m as=0 ps=0 w=54.89u l=4u
VAUD30 vbn_fold.t13 audit_d30 0
X30 audit_d30 vbn_fold.t12 vnx_bias avss nfet_05v0 ad=2.0328p pd=10.12u as=2.0328p ps=10.12u w=4.62u l=6u
VAUD31 xf1.t5 audit_d31 0
X31 audit_d31 vbn_sink.t23 avss avss nfet_05v0 ad=7.1896p pd=33.56u as=7.1896p ps=33.56u w=16.34u l=8u
VAUD32 vgn1.t9 audit_d32 0
X32 audit_d32 aux_gate psrg_m3_feed.t7 avdd.t1013 pfet_05v0 ad=0.88p pd=4.88u as=0.88p ps=4.88u w=2u l=2u
VAUD33 rbit6top.t2 audit_d33 0
X33 audit_d33 b5_b.t2 rbit5top.t2 dvdd.t5 pfet_03v3 ad=3.3p pd=15.88u as=3.3p ps=15.88u w=7.5u l=0.28u
VAUD34 avdd.t757 audit_d34 0
X34 audit_d34 avdd.t754 avdd.t756 avdd.t755 pfet_05v0 ad=9.7724p pd=45.3u as=0 ps=0 w=22.21u l=8u
VAUD35 avdd.t106 audit_d35 0
X35 audit_d35 avdd.t103 avdd.t105 avdd.t104 pfet_05v0 ad=8.25p pd=38.38u as=0 ps=0 w=18.75u l=8u
X36 rbit4top.t4 rbit3top.t6 avss ppolyf_u_1k r_width=6.6u r_length=16u
VAUD36 avss audit_d36 0
X37 audit_d36 avss avss avss nfet_05v0 ad=6.424p pd=30.08u as=0 ps=0 w=14.6u l=4u M=14
VAUD37 vx3.t2 audit_d37 0
X38 audit_d37 psrg_m3_feed.t26 avdd.t896 avdd.t895 pfet_05v0 ad=7.37p pd=34.38u as=7.37p ps=34.38u w=16.75u l=2u
VAUD38 avdd.t821 audit_d38 0
X39 audit_d38 avdd.t818 avdd.t820 avdd.t819 pfet_05v0 ad=9.7724p pd=45.3u as=0 ps=0 w=22.21u l=8u
VAUD39 avdd.t550 audit_d39 0
X40 audit_d39 avdd.t547 avdd.t549 avdd.t548 pfet_05v0 ad=7.37p pd=34.38u as=0 ps=0 w=16.75u l=2u
VAUD40 avdd.t102 audit_d40 0
X41 audit_d40 avdd.t99 avdd.t101 avdd.t100 pfet_05v0 ad=8.25p pd=38.38u as=0 ps=0 w=18.75u l=8u
VAUD41 avdd.t454 audit_d41 0
X42 audit_d41 avdd.t451 avdd.t453 avdd.t452 pfet_05v0 ad=7.37p pd=34.38u as=0 ps=0 w=16.75u l=2u
VAUD42 vaux.t1 audit_d42 0
X43 audit_d42 psrg_m3_feed.t28 avdd.t900 avdd.t899 pfet_05v0 ad=4.4p pd=20.88u as=4.4p ps=20.88u w=10u l=2u
VAUD43 vbn.t3 audit_d43 0
X44 audit_d43 aux_gate avdd.t1012 avdd.t1011 pfet_05v0 ad=0.22p pd=1.88u as=0.22p ps=1.88u w=0.5u l=8u
VAUD44 avdd.t709 audit_d44 0
X45 audit_d44 avdd.t706 avdd.t708 avdd.t707 pfet_05v0 ad=24.1516p pd=0.11066m as=0 ps=0 w=54.89u l=4u
VAUD45 avdd.t506 audit_d45 0
X46 audit_d45 avdd.t503 avdd.t505 avdd.t504 pfet_05v0 ad=24.1516p pd=0.11066m as=0 ps=0 w=54.89u l=4u
X47 rfix2 rfix1 avss ppolyf_u_1k r_width=6.6u r_length=0.128m
VAUD46 avdd.t218 audit_d46 0
X48 audit_d46 avdd.t215 avdd.t217 avdd.t216 pfet_05v0 ad=8.25p pd=38.38u as=0 ps=0 w=18.75u l=8u
VAUD47 avdd.t853 audit_d47 0
X49 audit_d47 avdd.t850 avdd.t852 avdd.t851 pfet_05v0 ad=9.1344p pd=42.4u as=0 ps=0 w=20.76u l=4u
VAUD48 vref.t0 audit_d48 0
X50 audit_d48 vcasp vx3.t5 avdd.t995 pfet_05v0 ad=7.2248p pd=33.72u as=7.2248p ps=33.72u w=16.42u l=4u
VAUD49 avdd.t406 audit_d49 0
X51 audit_d49 avdd.t403 avdd.t405 avdd.t404 pfet_05v0 ad=7.2248p pd=33.72u as=0 ps=0 w=16.42u l=4u
X52 rbit6top.t3 rbit5top.t5 avss ppolyf_u_1k r_width=6.6u r_length=64u
VAUD50 psrg_vnc.t8 audit_d50 0
X53 audit_d50 psrg_vnc.t7 rb_mid avss nfet_05v0 ad=0.3124p pd=2.3u as=0.3124p ps=2.3u w=0.71u l=20u
VAUD51 avdd.t713 audit_d51 0
X54 audit_d51 avdd.t710 avdd.t712 avdd.t711 pfet_05v0 ad=24.1516p pd=0.11066m as=0 ps=0 w=54.89u l=4u
VAUD52 vx2.t2 audit_d52 0
X55 audit_d52 psrg_m3_feed.t18 avdd.t3 avdd.t2 pfet_05v0 ad=7.37p pd=34.38u as=7.37p ps=34.38u w=16.75u l=2u
VAUD53 avdd.t114 audit_d53 0
X56 audit_d53 avdd.t111 avdd.t113 avdd.t112 pfet_05v0 ad=8.25p pd=38.38u as=0 ps=0 w=18.75u l=8u
VAUD54 avdd.t690 audit_d54 0
X57 audit_d54 avdd.t687 avdd.t689 avdd.t688 pfet_05v0 ad=9.7724p pd=45.3u as=0 ps=0 w=22.21u l=8u
VAUD55 pm1.t8 audit_d55 0
X58 audit_d55 y1.t9 avdd.t928 avdd.t927 pfet_05v0 ad=9.1344p pd=42.4u as=9.1344p ps=42.4u w=20.76u l=4u
VAUD56 avdd.t594 audit_d56 0
X59 audit_d56 avdd.t591 avdd.t593 avdd.t592 pfet_05v0 ad=7.37p pd=34.38u as=0 ps=0 w=16.75u l=2u
VAUD57 avdd.t274 audit_d57 0
X60 audit_d57 avdd.t271 avdd.t273 avdd.t272 pfet_05v0 ad=8.3556p pd=38.86u as=0 ps=0 w=18.99u l=8u
VAUD58 avdd.t322 audit_d58 0
X61 audit_d58 avdd.t319 avdd.t321 avdd.t320 pfet_05v0 ad=8.338p pd=38.78u as=0 ps=0 w=18.95u l=8u
VAUD59 avdd.t358 audit_d59 0
X62 audit_d59 avdd.t355 avdd.t357 avdd.t356 pfet_05v0 ad=8.338p pd=38.78u as=0 ps=0 w=18.95u l=8u
VAUD60 avdd.t610 audit_d60 0
X63 audit_d60 avdd.t607 avdd.t609 avdd.t608 pfet_05v0 ad=7.2248p pd=33.72u as=0 ps=0 w=16.42u l=4u
VAUD61 psrg_m3_feed.t3 audit_d61 0
X64 audit_d61 vcasp vx2.t6 avdd.t992 pfet_05v0 ad=7.2248p pd=33.72u as=7.2248p ps=33.72u w=16.42u l=4u
VAUD62 pm1.t7 audit_d62 0
X65 audit_d62 y1.t12 avdd.t946 avdd.t945 pfet_05v0 ad=9.1344p pd=42.4u as=9.1344p ps=42.4u w=20.76u l=4u
VAUD63 vx2.t0 audit_d63 0
X66 audit_d63 psrg_m3_feed.t25 avdd.t888 avdd.t887 pfet_05v0 ad=7.37p pd=34.38u as=7.37p ps=34.38u w=16.75u l=2u
VAUD64 avdd.t538 audit_d64 0
X67 audit_d64 avdd.t535 avdd.t537 avdd.t536 pfet_05v0 ad=7.2248p pd=33.72u as=0 ps=0 w=16.42u l=4u
VAUD65 avdd.t270 audit_d65 0
X68 audit_d65 avdd.t267 avdd.t269 avdd.t268 pfet_05v0 ad=8.3556p pd=38.86u as=0 ps=0 w=18.99u l=8u
VAUD66 avdd.t318 audit_d66 0
X69 audit_d66 avdd.t315 avdd.t317 avdd.t316 pfet_05v0 ad=8.338p pd=38.78u as=0 ps=0 w=18.95u l=8u
VAUD67 avdd.t354 audit_d67 0
X70 audit_d67 avdd.t351 avdd.t353 avdd.t352 pfet_05v0 ad=8.338p pd=38.78u as=0 ps=0 w=18.95u l=8u
VAUD68 b2_b.t0 audit_d68 0
X71 audit_d68 b2.t0 dvdd.t9 dvdd.t8 pfet_03v3 ad=1.32p pd=6.88u as=1.32p ps=6.88u w=3u l=0.5u
VAUD69 avdd.t630 audit_d69 0
X72 audit_d69 avdd.t627 avdd.t629 avdd.t628 pfet_05v0 ad=7.37p pd=34.38u as=0 ps=0 w=16.75u l=2u
VAUD70 avdd.t670 audit_d70 0
X73 audit_d70 avdd.t667 avdd.t669 avdd.t668 pfet_05v0 ad=24.1516p pd=0.11066m as=0 ps=0 w=54.89u l=4u
VAUD71 y1.t0 audit_d71 0
X74 audit_d71 vbp_cas.t26 pm1.t0 avdd.t953 pfet_05v0 ad=9.7724p pd=45.3u as=9.7724p ps=45.3u w=22.21u l=8u
VAUD72 avdd.t833 audit_d72 0
X75 audit_d72 avdd.t830 avdd.t832 avdd.t831 pfet_05v0 ad=9.7724p pd=45.3u as=0 ps=0 w=22.21u l=8u
VAUD73 avss audit_d73 0
X76 audit_d73 avss avss avss nfet_05v0 ad=5.4164p pd=25.5u as=0 ps=0 w=12.31u l=8u M=10
VAUD74 b5_b.t0 audit_d74 0
X77 audit_d74 b5.t0 dvdd.t1 dvdd.t0 pfet_03v3 ad=1.32p pd=6.88u as=1.32p ps=6.88u w=3u l=0.5u
VAUD75 avss audit_d75 0
X78 audit_d75 avss avss avss nfet_05v0 ad=8.1356p pd=37.86u as=0 ps=0 w=18.49u l=6u M=10
VAUD76 avdd.t494 audit_d76 0
X79 audit_d76 avdd.t491 avdd.t493 avdd.t492 pfet_05v0 ad=24.1516p pd=0.11066m as=0 ps=0 w=54.89u l=4u
VAUD77 vbp_i.t10 audit_d77 0
X80 audit_d77 vbp_i.t9 avdd.t1033 avdd.t1032 pfet_05v0 ad=8.25p pd=38.38u as=8.25p ps=38.38u w=18.75u l=8u
VAUD78 vbp_bias.t11 audit_d78 0
X81 audit_d78 vbp_bias.t10 avdd.t9 avdd.t8 pfet_03v3 ad=8.3864p pd=39u as=8.3864p ps=39u w=19.06u l=8u
VAUD79 avdd.t202 audit_d79 0
X82 audit_d79 avdd.t199 avdd.t201 avdd.t200 pfet_05v0 ad=8.25p pd=38.38u as=0 ps=0 w=18.75u l=8u
VAUD80 avdd.t777 audit_d80 0
X83 audit_d80 avdd.t774 avdd.t776 avdd.t775 pfet_05v0 ad=9.1344p pd=42.4u as=0 ps=0 w=20.76u l=4u
VAUD81 vbp_bias.t27 audit_d81 0
X84 audit_d81 vbp_bias.t26 avdd.t912 avdd.t911 pfet_03v3 ad=8.3864p pd=39u as=8.3864p ps=39u w=19.06u l=8u
VAUD82 xf2.t10 audit_d82 0
X85 audit_d82 vbn_sink.t24 avss avss nfet_05v0 ad=7.1896p pd=33.56u as=7.1896p ps=33.56u w=16.34u l=8u
X86 vref.t11 avss cap_mim_2f0fF c_width=70.7u c_length=70.7u
VAUD83 vbn_sink.t0 audit_d83 0
X87 audit_d83 vbp_i.t28 avdd.t19 avdd.t18 pfet_05v0 ad=8.338p pd=38.78u as=8.338p ps=38.78u w=18.95u l=8u
VAUD84 vbn_fold.t1 audit_d84 0
X88 audit_d84 vbp_i.t41 avdd.t13 avdd.t12 pfet_05v0 ad=8.3556p pd=38.86u as=8.3556p ps=38.86u w=18.99u l=8u
VAUD85 rbit1top.t5 audit_d85 0
X89 audit_d85 b0_b.t3 rbit0top.t2 dvdd.t15 pfet_03v3 ad=17.6p pd=80.88u as=17.6p ps=80.88u w=40u l=0.28u
VAUD86 avdd.t865 audit_d86 0
X90 audit_d86 avdd.t862 avdd.t864 avdd.t863 pfet_05v0 ad=9.1344p pd=42.4u as=0 ps=0 w=20.76u l=4u
VAUD87 vbn_i.t5 audit_d87 0
X91 audit_d87 iref_gate.t3 avdd.t932 avdd.t931 pfet_05v0 ad=0.22p pd=1.88u as=0.22p ps=1.88u w=0.5u l=8u
X92 vref.t6 avss cap_mim_2f0fF c_width=70.7u c_length=70.7u
VAUD88 avdd.t310 audit_d88 0
X93 audit_d88 avdd.t307 avdd.t309 avdd.t308 pfet_05v0 ad=8.338p pd=38.78u as=0 ps=0 w=18.95u l=8u
VAUD89 avdd.t346 audit_d89 0
X94 audit_d89 avdd.t343 avdd.t345 avdd.t344 pfet_05v0 ad=8.338p pd=38.78u as=0 ps=0 w=18.95u l=8u
VAUD90 avdd.t98 audit_d90 0
X95 audit_d90 avdd.t95 avdd.t97 avdd.t96 pfet_05v0 ad=8.25p pd=38.38u as=0 ps=0 w=18.75u l=8u
VAUD91 iref_gate.t1 audit_d91 0
X96 audit_d91 vbp_i.t21 vsu1 avss nfet_05v0 ad=0.22p pd=1.88u as=0.22p ps=1.88u w=0.5u l=50u
VAUD92 vgn2.t2 audit_d92 0
X97 audit_d92 vbp_cas.t29 pm2.t1 avdd.t956 pfet_05v0 ad=9.7724p pd=45.3u as=9.7724p ps=45.3u w=22.21u l=8u
VAUD93 vbn_fold.t4 audit_d93 0
X98 audit_d93 vbp_i.t51 avdd.t59 avdd.t58 pfet_05v0 ad=8.3556p pd=38.86u as=8.3556p ps=38.86u w=18.99u l=8u
X99 rbit0top.t0 rfix2 avss ppolyf_u_1k r_width=6.6u r_length=0.128m
VAUD94 vsp.t4 audit_d94 0
X100 audit_d94 vbp_tail.t12 avdd.t916 avdd.t915 pfet_03v3 ad=12.7204p pd=58.7u as=12.7204p ps=58.7u w=28.91u l=6u
VAUD95 avdd.t606 audit_d95 0
X101 audit_d95 avdd.t603 avdd.t605 avdd.t604 pfet_05v0 ad=7.2248p pd=33.72u as=0 ps=0 w=16.42u l=4u
VAUD96 rbit4top.t2 audit_d96 0
X102 audit_d96 b3_b.t2 rbit3top.t1 dvdd.t2 pfet_03v3 ad=13.2p pd=60.88u as=13.2p ps=60.88u w=30u l=0.28u
VAUD97 avdd.t438 audit_d97 0
X103 audit_d97 avdd.t435 avdd.t437 avdd.t436 pfet_05v0 ad=7.2248p pd=33.72u as=0 ps=0 w=16.42u l=4u
VAUD98 su_state.t0 audit_d98 0
X104 audit_d98 vsu avdd.t88 avdd.t87 pfet_05v0 ad=0.44p pd=2.88u as=0.44p ps=2.88u w=1u l=8u
VAUD99 xf1.t3 audit_d99 0
X105 audit_d99 vbn_sink.t27 avss avss nfet_05v0 ad=7.1896p pd=33.56u as=7.1896p ps=33.56u w=16.34u l=8u
VAUD100 avdd.t194 audit_d100 0
X106 audit_d100 avdd.t191 avdd.t193 avdd.t192 pfet_05v0 ad=8.3556p pd=38.86u as=0 ps=0 w=18.99u l=8u
VAUD101 rbit5top.t1 audit_d101 0
X107 audit_d101 b4_b.t2 rbit4top.t0 dvdd.t4 pfet_03v3 ad=6.6p pd=30.88u as=6.6p ps=30.88u w=15u l=0.28u
VAUD102 avdd.t382 audit_d102 0
X108 audit_d102 avdd.t379 avdd.t381 avdd.t380 pfet_05v0 ad=8.338p pd=38.78u as=0 ps=0 w=18.95u l=8u
VAUD103 vbn_i.t4 audit_d103 0
X109 audit_d103 vbp_i.t54 avdd.t77 avdd.t76 pfet_05v0 ad=8.25p pd=38.38u as=8.25p ps=38.38u w=18.75u l=8u
VAUD104 xf2.t4 audit_d104 0
X110 audit_d104 vbn_sink.t28 avss avss nfet_05v0 ad=7.1896p pd=33.56u as=7.1896p ps=33.56u w=16.34u l=8u
VAUD105 avdd.t881 audit_d105 0
X111 audit_d105 avdd.t878 avdd.t880 avdd.t879 pfet_05v0 ad=9.1344p pd=42.4u as=0 ps=0 w=20.76u l=4u
VAUD106 avdd.t618 audit_d106 0
X112 audit_d106 avdd.t615 avdd.t617 avdd.t616 pfet_05v0 ad=7.2248p pd=33.72u as=0 ps=0 w=16.42u l=4u
VAUD107 xf1.t8 audit_d107 0
X113 audit_d107 v1.t3 vsp.t11 avdd.t1028 pfet_05v0 ad=24.1516p pd=0.11066m as=24.1516p ps=0.11066m w=54.89u l=4u
VAUD108 rbit2top.t7 audit_d108 0
X114 audit_d108 b1_b.t4 rbit1top.t12 dvdd.t12 pfet_03v3 ad=17.6p pd=80.88u as=17.6p ps=80.88u w=40u l=0.28u
VAUD109 psrg_m3_feed.t1 audit_d109 0
X115 audit_d109 psrg_vnc.t10 psrg_m3_protected.t2 avss nfet_05v0 ad=6.424p pd=30.08u as=6.424p ps=30.08u w=14.6u l=4u
VAUD110 avdd.t378 audit_d110 0
X116 audit_d110 avdd.t375 avdd.t377 avdd.t376 pfet_05v0 ad=8.338p pd=38.78u as=0 ps=0 w=18.95u l=8u
VAUD111 rbit4top.t1 audit_d111 0
X117 audit_d111 b4.t2 rbit5top.t3 dvss nfet_03v3 ad=2.2p pd=10.88u as=2.2p ps=10.88u w=5u l=0.28u
VAUD112 avdd.t170 audit_d112 0
X118 audit_d112 avdd.t167 avdd.t169 avdd.t168 pfet_05v0 ad=8.3556p pd=38.86u as=0 ps=0 w=18.99u l=8u
VAUD113 vbn_sink.t18 audit_d113 0
X119 audit_d113 vbn_sink.t17 avss avss nfet_05v0 ad=5.4164p pd=25.5u as=5.4164p ps=25.5u w=12.31u l=8u
VAUD114 avdd.t522 audit_d114 0
X120 audit_d114 avdd.t519 avdd.t521 avdd.t520 pfet_05v0 ad=24.1516p pd=0.11066m as=0 ps=0 w=54.89u l=4u
VAUD115 avdd.t426 audit_d115 0
X121 audit_d115 avdd.t423 avdd.t425 avdd.t424 pfet_05v0 ad=7.2248p pd=33.72u as=0 ps=0 w=16.42u l=4u
VAUD116 vbp_tail.t3 audit_d116 0
X122 audit_d116 vbp_tail.t2 avdd.t920 avdd.t919 pfet_03v3 ad=6.05p pd=28.38u as=6.05p ps=28.38u w=13.75u l=6u
VAUD117 avdd.t542 audit_d117 0
X123 audit_d117 avdd.t539 avdd.t541 avdd.t540 pfet_05v0 ad=7.2248p pd=33.72u as=0 ps=0 w=16.42u l=4u
VAUD118 avdd.t717 audit_d118 0
X124 audit_d118 avdd.t714 avdd.t716 avdd.t715 pfet_05v0 ad=24.1516p pd=0.11066m as=0 ps=0 w=54.89u l=4u
VAUD119 vbp_cas.t17 audit_d119 0
X125 audit_d119 vbp_cas.t16 vbp_bias.t4 avdd.t974 pfet_05v0 ad=8.3292p pd=38.74u as=8.3292p ps=38.74u w=18.93u l=8u
VAUD120 pm2.t3 audit_d120 0
X126 audit_d120 y1.t18 avdd.t963 avdd.t962 pfet_05v0 ad=9.1344p pd=42.4u as=9.1344p ps=42.4u w=20.76u l=4u
VAUD121 avdd.t458 audit_d121 0
X127 audit_d121 avdd.t455 avdd.t457 avdd.t456 pfet_05v0 ad=7.37p pd=34.38u as=0 ps=0 w=16.75u l=2u
VAUD122 xf2.t2 audit_d122 0
X128 audit_d122 v2.t5 vsp.t1 avdd.t65 pfet_05v0 ad=24.1516p pd=0.11066m as=24.1516p ps=0.11066m w=54.89u l=4u
VAUD123 vaux.t0 audit_d123 0
X129 audit_d123 psrg_m3_feed.t27 avdd.t898 avdd.t897 pfet_05v0 ad=4.4p pd=20.88u as=4.4p ps=20.88u w=10u l=2u
VAUD124 avdd.t825 audit_d124 0
X130 audit_d124 avdd.t822 avdd.t824 avdd.t823 pfet_05v0 ad=9.7724p pd=45.3u as=0 ps=0 w=22.21u l=8u
VAUD125 su_state.t1 audit_d125 0
X131 audit_d125 vbp_tail.t13 avdd.t92 avdd.t91 pfet_05v0 ad=0.44p pd=2.88u as=0.44p ps=2.88u w=1u l=8u
VAUD126 avdd.t705 audit_d126 0
X132 audit_d126 avdd.t703 avdd.t705 avdd.t704 pfet_05v0 ad=24.1516p pd=0.11066m as=0 ps=0 w=54.89u l=4u
VAUD127 avdd.t390 audit_d127 0
X133 audit_d127 avdd.t387 avdd.t389 avdd.t388 pfet_05v0 ad=7.2248p pd=33.72u as=0 ps=0 w=16.42u l=4u
VAUD128 avdd.t873 audit_d128 0
X134 audit_d128 avdd.t870 avdd.t872 avdd.t871 pfet_05v0 ad=9.1344p pd=42.4u as=0 ps=0 w=20.76u l=4u
VAUD129 avdd.t350 audit_d129 0
X135 audit_d129 avdd.t347 avdd.t349 avdd.t348 pfet_05v0 ad=8.338p pd=38.78u as=0 ps=0 w=18.95u l=8u
VAUD130 pm2.t6 audit_d130 0
X136 audit_d130 y1.t11 avdd.t976 avdd.t975 pfet_05v0 ad=9.1344p pd=42.4u as=9.1344p ps=42.4u w=20.76u l=4u
VAUD131 avdd.t554 audit_d131 0
X137 audit_d131 avdd.t551 avdd.t553 avdd.t552 pfet_05v0 ad=7.2248p pd=33.72u as=0 ps=0 w=16.42u l=4u
VAUD132 avdd.t602 audit_d132 0
X138 audit_d132 avdd.t599 avdd.t601 avdd.t600 pfet_05v0 ad=7.2248p pd=33.72u as=0 ps=0 w=16.42u l=4u
VAUD133 psrg_vnc.t0 audit_d133 0
X139 audit_d133 vbp_i.t18 avdd.t15 avdd.t14 pfet_05v0 ad=7.8056p pd=36.36u as=7.8056p ps=36.36u w=17.74u l=4u
VAUD134 avdd.t246 audit_d134 0
X140 audit_d134 avdd.t243 avdd.t245 avdd.t244 pfet_05v0 ad=8.25p pd=38.38u as=0 ps=0 w=18.75u l=8u
VAUD135 avdd.t370 audit_d135 0
X141 audit_d135 avdd.t367 avdd.t369 avdd.t368 pfet_05v0 ad=8.338p pd=38.78u as=0 ps=0 w=18.95u l=8u
VAUD136 xf1.t2 audit_d136 0
X142 audit_d136 vbn_sink.t31 avss avss nfet_05v0 ad=7.1896p pd=33.56u as=7.1896p ps=33.56u w=16.34u l=8u
VAUD137 vbn_sink.t6 audit_d137 0
X143 audit_d137 vbp_i.t23 avdd.t49 avdd.t48 pfet_05v0 ad=8.338p pd=38.78u as=8.338p ps=38.78u w=18.95u l=8u
VAUD138 vcasp audit_d138 0
X144 audit_d138 vcasp avdd.t1010 avdd.t1009 pfet_05v0 ad=0.396p pd=2.68u as=0.396p ps=2.68u w=0.9u l=2u
VAUD139 avdd.t198 audit_d139 0
X145 audit_d139 avdd.t195 avdd.t197 avdd.t196 pfet_05v0 ad=8.3556p pd=38.86u as=0 ps=0 w=18.99u l=8u
VAUD140 vx2.t3 audit_d140 0
X146 audit_d140 psrg_m3_feed.t17 avdd.t1 avdd.t0 pfet_05v0 ad=7.37p pd=34.38u as=7.37p ps=34.38u w=16.75u l=2u
VAUD141 vbp_bias.t13 audit_d141 0
X147 audit_d141 vbp_bias.t12 avdd.t1022 avdd.t1021 pfet_03v3 ad=8.3864p pd=39u as=8.3864p ps=39u w=19.06u l=8u
VAUD142 avdd.t614 audit_d142 0
X148 audit_d142 avdd.t611 avdd.t613 avdd.t612 pfet_05v0 ad=7.2248p pd=33.72u as=0 ps=0 w=16.42u l=4u
X149 rfix0 vref.t5 avss ppolyf_u_1k r_width=6.6u r_length=0.128m
VAUD143 avdd.t578 audit_d143 0
X150 audit_d143 avdd.t575 avdd.t577 avdd.t576 pfet_05v0 ad=7.2248p pd=33.72u as=0 ps=0 w=16.42u l=4u
VAUD144 avdd.t418 audit_d144 0
X151 audit_d144 avdd.t415 avdd.t417 avdd.t416 pfet_05v0 ad=7.2248p pd=33.72u as=0 ps=0 w=16.42u l=4u
VAUD145 vbn_fold.t10 audit_d145 0
X152 audit_d145 vbp_i.t46 avdd.t890 avdd.t889 pfet_05v0 ad=8.3556p pd=38.86u as=8.3556p ps=38.86u w=18.99u l=8u
VAUD146 pm2.t5 audit_d146 0
X153 audit_d146 y1.t14 avdd.t950 avdd.t949 pfet_05v0 ad=9.1344p pd=42.4u as=9.1344p ps=42.4u w=20.76u l=4u
VAUD147 vref.t1 audit_d147 0
X154 audit_d147 vcasp vx3.t6 avdd.t997 pfet_05v0 ad=7.2248p pd=33.72u as=7.2248p ps=33.72u w=16.42u l=4u
VAUD148 avdd.t142 audit_d148 0
X155 audit_d148 avdd.t139 avdd.t141 avdd.t140 pfet_05v0 ad=8.25p pd=38.38u as=0 ps=0 w=18.75u l=8u
VAUD149 y1.t6 audit_d149 0
X156 audit_d149 vbp_cas.t23 pm1.t11 avdd.t978 pfet_05v0 ad=9.7724p pd=45.3u as=9.7724p ps=45.3u w=22.21u l=8u
VAUD150 avdd.t306 audit_d150 0
X157 audit_d150 avdd.t303 avdd.t305 avdd.t304 pfet_05v0 ad=8.338p pd=38.78u as=0 ps=0 w=18.95u l=8u
VAUD151 vsu2 audit_d151 0
X158 audit_d151 vbp_i.t20 avss avss nfet_05v0 ad=0.22p pd=1.88u as=0.22p ps=1.88u w=0.5u l=50u
VAUD152 vbn_sink.t20 audit_d152 0
X159 audit_d152 vbp_i.t35 avdd.t938 avdd.t937 pfet_05v0 ad=8.338p pd=38.78u as=8.338p ps=38.78u w=18.95u l=8u
VAUD153 avdd.t813 audit_d153 0
X160 audit_d153 avdd.t810 avdd.t812 avdd.t811 pfet_05v0 ad=9.7724p pd=45.3u as=0 ps=0 w=22.21u l=8u
VAUD154 avdd.t845 audit_d154 0
X161 audit_d154 avdd.t842 avdd.t844 avdd.t843 pfet_05v0 ad=9.1344p pd=42.4u as=0 ps=0 w=20.76u l=4u
VAUD155 vx1.t0 audit_d155 0
X162 audit_d155 psrg_m3_feed.t24 avdd.t886 avdd.t885 pfet_05v0 ad=7.37p pd=34.38u as=7.37p ps=34.38u w=16.75u l=2u
VAUD156 avdd.t510 audit_d156 0
X163 audit_d156 avdd.t507 avdd.t509 avdd.t508 pfet_05v0 ad=24.1516p pd=0.11066m as=0 ps=0 w=54.89u l=4u
VAUD157 avdd.t302 audit_d157 0
X164 audit_d157 avdd.t299 avdd.t301 avdd.t300 pfet_05v0 ad=8.338p pd=38.78u as=0 ps=0 w=18.95u l=8u
VAUD158 vsp.t6 audit_d158 0
X165 audit_d158 vbp_tail.t9 avdd.t988 avdd.t987 pfet_03v3 ad=12.7204p pd=58.7u as=12.7204p ps=58.7u w=28.91u l=6u
X166 rbit3top.t2 rbit2top.t1 avss ppolyf_u_1k r_width=6.6u r_length=8u
VAUD159 avdd.t793 audit_d159 0
X167 audit_d159 avdd.t790 avdd.t792 avdd.t791 pfet_05v0 ad=9.1344p pd=42.4u as=0 ps=0 w=20.76u l=4u
VAUD160 vbn_sink.t14 audit_d160 0
X168 audit_d160 vbp_i.t25 avdd.t71 avdd.t70 pfet_05v0 ad=8.338p pd=38.78u as=8.338p ps=38.78u w=18.95u l=8u
VAUD161 xf1.t7 audit_d161 0
X169 audit_d161 v1.t5 vsp.t9 avdd.t1026 pfet_05v0 ad=24.1516p pd=0.11066m as=24.1516p ps=0.11066m w=54.89u l=4u
VAUD162 avdd.t837 audit_d162 0
X170 audit_d162 avdd.t834 avdd.t836 avdd.t835 pfet_05v0 ad=9.7724p pd=45.3u as=0 ps=0 w=22.21u l=8u
X171 vref.t13 avss cap_mim_2f0fF c_width=70.7u c_length=70.7u
VAUD163 avdd.t186 audit_d163 0
X172 audit_d163 avdd.t183 avdd.t185 avdd.t184 pfet_05v0 ad=8.25p pd=38.38u as=0 ps=0 w=18.75u l=8u
X173 vref.t8 avss cap_mim_2f0fF c_width=70.7u c_length=70.7u
VAUD164 avdd.t502 audit_d164 0
X174 audit_d164 avdd.t499 avdd.t501 avdd.t500 pfet_05v0 ad=24.1516p pd=0.11066m as=0 ps=0 w=54.89u l=4u
VAUD165 vbn_fold.t6 audit_d165 0
X175 audit_d165 vbp_i.t48 avdd.t75 avdd.t74 pfet_05v0 ad=8.3556p pd=38.86u as=8.3556p ps=38.86u w=18.99u l=8u
VAUD166 vbp_cas.t13 audit_d166 0
X176 audit_d166 vbp_cas.t12 vbp_bias.t9 avdd.t968 pfet_05v0 ad=8.3292p pd=38.74u as=8.3292p ps=38.74u w=18.93u l=8u
VAUD167 vbp_i.t6 audit_d167 0
X177 audit_d167 vbp_i.t5 avdd.t934 avdd.t933 pfet_05v0 ad=8.25p pd=38.38u as=8.25p ps=38.38u w=18.75u l=8u
VAUD168 vbn_sink.t16 audit_d168 0
X178 audit_d168 vbn_sink.t15 avss avss nfet_05v0 ad=5.4164p pd=25.5u as=5.4164p ps=25.5u w=12.31u l=8u
VAUD169 vbn_fold.t9 audit_d169 0
X179 audit_d169 vbp_i.t45 avdd.t86 avdd.t85 pfet_05v0 ad=8.3556p pd=38.86u as=8.3556p ps=38.86u w=18.99u l=8u
VAUD170 psrg_m3_feed.t6 audit_d170 0
X180 audit_d170 vcasp vx2.t9 avdd.t1001 pfet_05v0 ad=7.2248p pd=33.72u as=7.2248p ps=33.72u w=16.42u l=4u
VAUD171 psrg_m3_feed.t4 audit_d171 0
X181 audit_d171 vcasp vx2.t7 avdd.t994 pfet_05v0 ad=7.2248p pd=33.72u as=7.2248p ps=33.72u w=16.42u l=4u
VAUD172 psrg_vnc.t4 audit_d172 0
X182 audit_d172 vbp_i.t15 avdd.t45 avdd.t44 pfet_05v0 ad=7.8056p pd=36.36u as=7.8056p ps=36.36u w=17.74u l=4u
VAUD173 vsp.t3 audit_d173 0
X183 audit_d173 vbp_tail.t11 avdd.t914 avdd.t913 pfet_03v3 ad=12.7204p pd=58.7u as=12.7204p ps=58.7u w=28.91u l=6u
VAUD174 avdd.t254 audit_d174 0
X184 audit_d174 avdd.t251 avdd.t253 avdd.t252 pfet_05v0 ad=8.3556p pd=38.86u as=0 ps=0 w=18.99u l=8u
VAUD175 avdd.t598 audit_d175 0
X185 audit_d175 avdd.t595 avdd.t597 avdd.t596 pfet_05v0 ad=7.37p pd=34.38u as=0 ps=0 w=16.75u l=2u
VAUD176 vbp_tail.t1 audit_d176 0
X186 audit_d176 vbp_tail.t0 avdd.t1037 avdd.t1036 pfet_03v3 ad=6.05p pd=28.38u as=6.05p ps=28.38u w=13.75u l=6u
VAUD177 vbp_bias.t17 audit_d177 0
X187 audit_d177 vbp_bias.t16 avdd.t82 avdd.t81 pfet_03v3 ad=8.3864p pd=39u as=8.3864p ps=39u w=19.06u l=8u
VAUD178 avdd.t721 audit_d178 0
X188 audit_d178 avdd.t718 avdd.t720 avdd.t719 pfet_05v0 ad=24.1516p pd=0.11066m as=0 ps=0 w=54.89u l=4u
VAUD179 vbp_cas.t11 audit_d179 0
X189 audit_d179 vbp_cas.t10 vbp_bias.t8 avdd.t967 pfet_05v0 ad=8.3292p pd=38.74u as=8.3292p ps=38.74u w=18.93u l=8u
VAUD180 psrg_m3_feed.t2 audit_d180 0
X190 audit_d180 vcasp vx2.t10 avdd.t1004 pfet_05v0 ad=7.2248p pd=33.72u as=7.2248p ps=33.72u w=16.42u l=4u
VAUD181 avdd.t658 audit_d181 0
X191 audit_d181 avdd.t655 avdd.t657 avdd.t656 pfet_05v0 ad=7.37p pd=34.38u as=0 ps=0 w=16.75u l=2u
X192 rfix1 rfix0 avss ppolyf_u_1k r_width=6.6u r_length=0.128m
VAUD182 vbp_cas.t15 audit_d182 0
X193 audit_d182 vbp_cas.t14 vbp_bias.t7 avdd.t973 pfet_05v0 ad=8.3292p pd=38.74u as=8.3292p ps=38.74u w=18.93u l=8u
VAUD183 vbp_cas.t5 audit_d183 0
X194 audit_d183 vbp_cas.t4 vbp_bias.t0 avdd.t972 pfet_05v0 ad=8.3292p pd=38.74u as=8.3292p ps=38.74u w=18.93u l=8u
VAUD184 avdd.t242 audit_d184 0
X195 audit_d184 avdd.t239 avdd.t241 avdd.t240 pfet_05v0 ad=8.25p pd=38.38u as=0 ps=0 w=18.75u l=8u
VAUD185 avdd.t366 audit_d185 0
X196 audit_d185 avdd.t363 avdd.t365 avdd.t364 pfet_05v0 ad=8.338p pd=38.78u as=0 ps=0 w=18.95u l=8u
VAUD186 xf2.t3 audit_d186 0
X197 audit_d186 vbn_sink.t32 avss avss nfet_05v0 ad=7.1896p pd=33.56u as=7.1896p ps=33.56u w=16.34u l=8u
VAUD187 avdd.t518 audit_d187 0
X198 audit_d187 avdd.t515 avdd.t517 avdd.t516 pfet_05v0 ad=24.1516p pd=0.11066m as=0 ps=0 w=54.89u l=4u
VAUD188 avdd.t422 audit_d188 0
X199 audit_d188 avdd.t419 avdd.t421 avdd.t420 pfet_05v0 ad=7.2248p pd=33.72u as=0 ps=0 w=16.42u l=4u
VAUD189 avdd.t877 audit_d189 0
X200 audit_d189 avdd.t874 avdd.t876 avdd.t875 pfet_05v0 ad=9.1344p pd=42.4u as=0 ps=0 w=20.76u l=4u
X201 avss net3.t0 avdd.t78 pplus_u r_width=1u r_length=0.23253m
VAUD190 vbn_i.t2 audit_d190 0
X202 audit_d190 vbn_i.t1 avss avss nfet_05v0 ad=3.4232p pd=16.44u as=3.4232p ps=16.44u w=7.78u l=8u
VAUD191 psrg_m3_feed.t5 audit_d191 0
X203 audit_d191 vcasp vx2.t8 avdd.t999 pfet_05v0 ad=7.2248p pd=33.72u as=7.2248p ps=33.72u w=16.42u l=4u
VAUD192 y1.t4 audit_d192 0
X204 audit_d192 psrg_vnc.t9 psrg_mf1_protected.t1 avss nfet_05v0 ad=8.1356p pd=37.86u as=8.1356p ps=37.86u w=18.49u l=6u
VAUD193 avdd.t558 audit_d193 0
X205 audit_d193 avdd.t555 avdd.t557 avdd.t556 pfet_05v0 ad=7.2248p pd=33.72u as=0 ps=0 w=16.42u l=4u
VAUD194 avdd.t781 audit_d194 0
X206 audit_d194 avdd.t778 avdd.t780 avdd.t779 pfet_05v0 ad=9.1344p pd=42.4u as=0 ps=0 w=20.76u l=4u
VAUD195 pm2.t7 audit_d195 0
X207 audit_d195 y1.t10 avdd.t926 avdd.t925 pfet_05v0 ad=9.1344p pd=42.4u as=9.1344p ps=42.4u w=20.76u l=4u
VAUD196 avdd.t805 audit_d196 0
X208 audit_d196 avdd.t802 avdd.t804 avdd.t803 pfet_05v0 ad=9.1344p pd=42.4u as=0 ps=0 w=20.76u l=4u
X209 vq2.t0 v2.t0 avss ppolyf_u_1k r_width=4u r_length=42.1u
VAUD197 avdd.t362 audit_d197 0
X210 audit_d197 avdd.t359 avdd.t361 avdd.t360 pfet_05v0 ad=8.338p pd=38.78u as=0 ps=0 w=18.95u l=8u
VAUD198 xf2.t1 audit_d198 0
X211 audit_d198 v2.t3 vsp.t0 avdd.t64 pfet_05v0 ad=24.1516p pd=0.11066m as=24.1516p ps=0.11066m w=54.89u l=4u
VAUD199 vbp_i.t0 audit_d199 0
X212 audit_d199 vbn_i.t10 net4.t0 avss nfet_05v0 ad=4.0172p pd=19.14u as=4.0172p ps=19.14u w=9.13u l=8u
VAUD200 psrg_vnc.t6 audit_d200 0
X213 audit_d200 vbp_i.t17 avdd.t942 avdd.t941 pfet_05v0 ad=7.8056p pd=36.36u as=7.8056p ps=36.36u w=17.74u l=4u
VAUD201 avdd.t154 audit_d201 0
X214 audit_d201 avdd.t151 avdd.t153 avdd.t152 pfet_05v0 ad=8.3556p pd=38.86u as=0 ps=0 w=18.99u l=8u
VAUD202 avdd.t138 audit_d202 0
X215 audit_d202 avdd.t135 avdd.t137 avdd.t136 pfet_05v0 ad=8.25p pd=38.38u as=0 ps=0 w=18.75u l=8u
VAUD203 rbit3top.t7 audit_d203 0
X216 audit_d203 b3.t2 rbit4top.t5 dvss nfet_03v3 ad=4.4p pd=20.88u as=4.4p ps=20.88u w=10u l=0.28u
VAUD204 avdd.t737 audit_d204 0
X217 audit_d204 avdd.t734 avdd.t736 avdd.t735 pfet_05v0 ad=24.1516p pd=0.11066m as=0 ps=0 w=54.89u l=4u
VAUD205 avdd.t490 audit_d205 0
X218 audit_d205 avdd.t487 avdd.t489 avdd.t488 pfet_05v0 ad=24.1516p pd=0.11066m as=0 ps=0 w=54.89u l=4u
VAUD206 avdd.t190 audit_d206 0
X219 audit_d206 avdd.t187 avdd.t189 avdd.t188 pfet_05v0 ad=8.25p pd=38.38u as=0 ps=0 w=18.75u l=8u
VAUD207 avdd.t150 audit_d207 0
X220 audit_d207 avdd.t147 avdd.t149 avdd.t148 pfet_05v0 ad=8.3556p pd=38.86u as=0 ps=0 w=18.99u l=8u
VAUD208 avdd.t462 audit_d208 0
X221 audit_d208 avdd.t459 avdd.t461 avdd.t460 pfet_05v0 ad=7.37p pd=34.38u as=0 ps=0 w=16.75u l=2u
VAUD209 avdd.t582 audit_d209 0
X222 audit_d209 avdd.t579 avdd.t581 avdd.t580 pfet_05v0 ad=7.2248p pd=33.72u as=0 ps=0 w=16.42u l=4u
VAUD210 vbp_tail.t6 audit_d210 0
X223 audit_d210 vbn_i.t9 avss avss nfet_05v0 ad=6.138p pd=28.78u as=6.138p ps=28.78u w=13.95u l=8u
VAUD211 vbp_bias.t15 audit_d211 0
X224 audit_d211 vbp_bias.t14 avdd.t1024 avdd.t1023 pfet_03v3 ad=8.3864p pd=39u as=8.3864p ps=39u w=19.06u l=8u
VAUD212 avdd.t725 audit_d212 0
X225 audit_d212 avdd.t722 avdd.t724 avdd.t723 pfet_05v0 ad=24.1516p pd=0.11066m as=0 ps=0 w=54.89u l=4u
VAUD213 avdd.t773 audit_d213 0
X226 audit_d213 avdd.t770 avdd.t772 avdd.t771 pfet_05v0 ad=9.1344p pd=42.4u as=0 ps=0 w=20.76u l=4u
VAUD214 vsua audit_d214 0
X227 audit_d214 vsua auxsu1 avss nfet_05v0 ad=0.44p pd=2.88u as=0.44p ps=2.88u w=1u l=2u
VAUD215 avdd.t849 audit_d215 0
X228 audit_d215 avdd.t846 avdd.t848 avdd.t847 pfet_05v0 ad=9.1344p pd=42.4u as=0 ps=0 w=20.76u l=4u
X229 vgn2.t7 avss cap_mim_2f0fF c_width=59u c_length=59u
VAUD216 vbn_sink.t9 audit_d216 0
X230 audit_d216 vbp_i.t26 avdd.t55 avdd.t54 pfet_05v0 ad=8.338p pd=38.78u as=8.338p ps=38.78u w=18.95u l=8u
VAUD217 avdd.t258 audit_d217 0
X231 audit_d217 avdd.t255 avdd.t257 avdd.t256 pfet_05v0 ad=8.3556p pd=38.86u as=0 ps=0 w=18.99u l=8u
VAUD218 rbit1top.t1 audit_d218 0
X232 audit_d218 b0_b.t7 rbit0top.t5 dvdd.t19 pfet_03v3 ad=17.6p pd=80.88u as=17.6p ps=80.88u w=40u l=0.28u
VAUD219 rbit1top.t4 audit_d219 0
X233 audit_d219 b0_b.t4 rbit0top.t6 dvdd.t18 pfet_03v3 ad=17.6p pd=80.88u as=17.6p ps=80.88u w=40u l=0.28u
VAUD220 b3_b.t1 audit_d220 0
X234 audit_d220 b3.t1 dvss dvss nfet_03v3 ad=0.44p pd=2.88u as=0.44p ps=2.88u w=1u l=0.5u
VAUD221 avdd.t230 audit_d221 0
X235 audit_d221 avdd.t227 avdd.t229 avdd.t228 pfet_05v0 ad=8.25p pd=38.38u as=0 ps=0 w=18.75u l=8u
VAUD222 vbn_sink.t10 audit_d222 0
X236 audit_d222 vbp_i.t27 avdd.t57 avdd.t56 pfet_05v0 ad=8.338p pd=38.78u as=8.338p ps=38.78u w=18.95u l=8u
VAUD223 vbn_fold.t0 audit_d223 0
X237 audit_d223 vbp_i.t40 avdd.t11 avdd.t10 pfet_05v0 ad=8.3556p pd=38.86u as=8.3556p ps=38.86u w=18.99u l=8u
VAUD224 vbn_fold.t5 audit_d224 0
X238 audit_d224 vbp_i.t49 avdd.t67 avdd.t66 pfet_05v0 ad=8.3556p pd=38.86u as=8.3556p ps=38.86u w=18.99u l=8u
VAUD225 vx1.t5 audit_d225 0
X239 audit_d225 psrg_m3_feed.t10 avdd.t94 avdd.t93 pfet_05v0 ad=7.37p pd=34.38u as=7.37p ps=34.38u w=16.75u l=2u
VAUD226 b5_b.t1 audit_d226 0
X240 audit_d226 b5.t2 dvss dvss nfet_03v3 ad=0.44p pd=2.88u as=0.44p ps=2.88u w=1u l=0.5u
VAUD227 vbn_fold.t7 audit_d227 0
X241 audit_d227 vbp_i.t50 avdd.t80 avdd.t79 pfet_05v0 ad=8.3556p pd=38.86u as=8.3556p ps=38.86u w=18.99u l=8u
VAUD228 avdd.t126 audit_d228 0
X242 audit_d228 avdd.t123 avdd.t125 avdd.t124 pfet_05v0 ad=8.25p pd=38.38u as=0 ps=0 w=18.75u l=8u
VAUD229 vbn_sink.t2 audit_d229 0
X243 audit_d229 vbp_i.t30 avdd.t23 avdd.t22 pfet_05v0 ad=8.338p pd=38.78u as=8.338p ps=38.78u w=18.95u l=8u
VAUD230 avdd.t801 audit_d230 0
X244 audit_d230 avdd.t798 avdd.t800 avdd.t799 pfet_05v0 ad=9.7724p pd=45.3u as=0 ps=0 w=22.21u l=8u
VAUD231 vbp_i.t8 audit_d231 0
X245 audit_d231 vbp_i.t7 avdd.t908 avdd.t907 pfet_05v0 ad=8.25p pd=38.38u as=8.25p ps=38.38u w=18.75u l=8u
VAUD232 vbn_sink.t5 audit_d232 0
X246 audit_d232 vbp_i.t39 avdd.t35 avdd.t34 pfet_05v0 ad=8.338p pd=38.78u as=8.338p ps=38.78u w=18.95u l=8u
VAUD233 avdd.t789 audit_d233 0
X247 audit_d233 avdd.t786 avdd.t788 avdd.t787 pfet_05v0 ad=9.1344p pd=42.4u as=0 ps=0 w=20.76u l=4u
VAUD234 xf2.t6 audit_d234 0
X248 audit_d234 v2.t4 vsp.t2 avdd.t882 pfet_05v0 ad=24.1516p pd=0.11066m as=24.1516p ps=0.11066m w=54.89u l=4u
VAUD235 avdd.t650 audit_d235 0
X249 audit_d235 avdd.t647 avdd.t649 avdd.t648 pfet_05v0 ad=7.37p pd=34.38u as=0 ps=0 w=16.75u l=2u
VAUD236 b6_b.t0 audit_d236 0
X250 audit_d236 b6.t0 dvdd.t29 dvdd.t28 pfet_03v3 ad=1.32p pd=6.88u as=1.32p ps=6.88u w=3u l=0.5u
VAUD237 psrg_mf1_protected.t0 audit_d237 0
X251 audit_d237 vbn_fold.t15 xf1.t0 avss nfet_05v0 ad=8.1356p pd=37.86u as=8.1356p ps=37.86u w=18.49u l=6u
VAUD238 pm1.t9 audit_d238 0
X252 audit_d238 y1.t8 avdd.t922 avdd.t921 pfet_05v0 ad=9.1344p pd=42.4u as=9.1344p ps=42.4u w=20.76u l=4u
VAUD239 bgsu1 audit_d239 0
X253 audit_d239 bgsu1 bgsu2 avss nfet_03v3 ad=0.44p pd=2.88u as=0.44p ps=2.88u w=1u l=2u
VAUD240 psrg_m3_feed.t0 audit_d240 0
X254 audit_d240 psrg_vnc.t11 psrg_m3_protected.t3 avss nfet_05v0 ad=6.424p pd=30.08u as=6.424p ps=30.08u w=14.6u l=4u
VAUD241 vx1.t1 audit_d241 0
X255 audit_d241 psrg_m3_feed.t23 avdd.t884 avdd.t883 pfet_05v0 ad=7.37p pd=34.38u as=7.37p ps=34.38u w=16.75u l=2u
VAUD242 vgn1.t8 audit_d242 0
X256 audit_d242 vcasp vx1.t9 avdd.t1002 pfet_05v0 ad=7.2248p pd=33.72u as=7.2248p ps=33.72u w=16.42u l=4u
VAUD243 avdd.t817 audit_d243 0
X257 audit_d243 avdd.t814 avdd.t816 avdd.t815 pfet_05v0 ad=9.7724p pd=45.3u as=0 ps=0 w=22.21u l=8u
VAUD244 vbp_bias.t19 audit_d244 0
X258 audit_d244 vbp_bias.t18 avdd.t904 avdd.t903 pfet_03v3 ad=8.3864p pd=39u as=8.3864p ps=39u w=19.06u l=8u
VAUD245 avdd.t402 audit_d245 0
X259 audit_d245 avdd.t399 avdd.t401 avdd.t400 pfet_05v0 ad=7.2248p pd=33.72u as=0 ps=0 w=16.42u l=4u
VAUD246 avdd.t326 audit_d246 0
X260 audit_d246 avdd.t323 avdd.t325 avdd.t324 pfet_05v0 ad=8.338p pd=38.78u as=0 ps=0 w=18.95u l=8u
VAUD247 psrg_vnc.t3 audit_d247 0
X261 audit_d247 vbp_i.t14 avdd.t43 avdd.t42 pfet_05v0 ad=7.8056p pd=36.36u as=7.8056p ps=36.36u w=17.74u l=4u
VAUD248 avdd.t178 audit_d248 0
X262 audit_d248 avdd.t175 avdd.t177 avdd.t176 pfet_05v0 ad=8.3556p pd=38.86u as=0 ps=0 w=18.99u l=8u
VAUD249 vbn_fold.t2 audit_d249 0
X263 audit_d249 vbp_i.t42 avdd.t39 avdd.t38 pfet_05v0 ad=8.3556p pd=38.86u as=8.3556p ps=38.86u w=18.99u l=8u
VAUD250 avdd.t566 audit_d250 0
X264 audit_d250 avdd.t563 avdd.t565 avdd.t564 pfet_05v0 ad=7.2248p pd=33.72u as=0 ps=0 w=16.42u l=4u
VAUD251 b1_b.t0 audit_d251 0
X265 audit_d251 b1.t2 dvdd.t25 dvdd.t24 pfet_03v3 ad=1.32p pd=6.88u as=1.32p ps=6.88u w=3u l=0.5u
VAUD252 iref_gate.t0 audit_d252 0
X266 audit_d252 vbp_i.t12 avdd.t27 avdd.t26 pfet_05v0 ad=35.2p pd=0.16088m as=35.2p ps=0.16088m w=80u l=1u
VAUD253 vbp_cas.t1 audit_d253 0
X267 audit_d253 vbp_cas.t0 vbp_bias.t6 avdd.t1043 pfet_05v0 ad=8.3292p pd=38.74u as=8.3292p ps=38.74u w=18.93u l=8u
X268 vq3.t0 rbit6top.t0 avss ppolyf_u_1k r_width=6.6u r_length=0.128m
VAUD254 vgn1.t3 audit_d254 0
X269 audit_d254 vgn1.t2 v1.t0 avss nfet_05v0 ad=6.424p pd=30.08u as=6.424p ps=30.08u w=14.6u l=4u
VAUD255 avdd.t174 audit_d255 0
X270 audit_d255 avdd.t171 avdd.t173 avdd.t172 pfet_05v0 ad=8.3556p pd=38.86u as=0 ps=0 w=18.99u l=8u
VAUD256 avdd.t666 audit_d256 0
X271 audit_d256 avdd.t663 avdd.t665 avdd.t664 pfet_05v0 ad=24.1516p pd=0.11066m as=0 ps=0 w=54.89u l=4u
VAUD257 vq3.t1 audit_d257 0
X272 audit_d257 b6_b.t2 rbit6top.t4 dvdd.t17 pfet_03v3 ad=1.65p pd=8.38u as=1.65p ps=8.38u w=3.75u l=0.28u
VAUD258 avdd.t586 audit_d258 0
X273 audit_d258 avdd.t583 avdd.t585 avdd.t584 pfet_05v0 ad=7.2248p pd=33.72u as=0 ps=0 w=16.42u l=4u
VAUD259 vbp_cas.t19 audit_d259 0
X274 audit_d259 vbp_cas.t18 vbp_bias.t5 avdd.t970 pfet_05v0 ad=8.3292p pd=38.74u as=8.3292p ps=38.74u w=18.93u l=8u
VAUD260 avdd.t386 audit_d260 0
X275 audit_d260 avdd.t383 avdd.t385 avdd.t384 pfet_05v0 ad=7.2248p pd=33.72u as=0 ps=0 w=16.42u l=4u
VAUD261 rbit3top.t3 audit_d261 0
X276 audit_d261 b2_b.t4 rbit2top.t3 dvdd.t20 pfet_03v3 ad=8.8p pd=40.88u as=8.8p ps=40.88u w=20u l=0.28u
VAUD262 avdd.t590 audit_d262 0
X277 audit_d262 avdd.t587 avdd.t589 avdd.t588 pfet_05v0 ad=7.2248p pd=33.72u as=0 ps=0 w=16.42u l=4u
VAUD263 vref.t4 audit_d263 0
X278 audit_d263 vcasp vx3.t7 avdd.t1000 pfet_05v0 ad=7.2248p pd=33.72u as=7.2248p ps=33.72u w=16.42u l=4u
VAUD264 vbp_cas.t3 audit_d264 0
X279 audit_d264 vbp_cas.t2 vbp_bias.t3 avdd.t957 pfet_05v0 ad=8.3292p pd=38.74u as=8.3292p ps=38.74u w=18.93u l=8u
VAUD265 psrg_vnc.t5 audit_d265 0
X280 audit_d265 vbp_i.t16 avdd.t940 avdd.t939 pfet_05v0 ad=7.8056p pd=36.36u as=7.8056p ps=36.36u w=17.74u l=4u
VAUD266 psrg_m3_protected.t0 audit_d266 0
X281 audit_d266 vgn2.t8 v2.t2 avss nfet_05v0 ad=6.424p pd=30.08u as=6.424p ps=30.08u w=14.6u l=4u
VAUD267 vx3.t1 audit_d267 0
X282 audit_d267 psrg_m3_feed.t11 avdd.t31 avdd.t30 pfet_05v0 ad=7.37p pd=34.38u as=7.37p ps=34.38u w=16.75u l=2u
VAUD268 xf2.t5 audit_d268 0
X283 audit_d268 vbn_sink.t29 avss avss nfet_05v0 ad=7.1896p pd=33.56u as=7.1896p ps=33.56u w=16.34u l=8u
VAUD269 vx3.t9 audit_d269 0
X284 audit_d269 psrg_m3_feed.t16 avdd.t1019 avdd.t1018 pfet_05v0 ad=7.37p pd=34.38u as=7.37p ps=34.38u w=16.75u l=2u
VAUD270 avdd.t741 audit_d270 0
X285 audit_d270 avdd.t738 avdd.t740 avdd.t739 pfet_05v0 ad=24.1516p pd=0.11066m as=0 ps=0 w=54.89u l=4u
VAUD271 avdd.t482 audit_d271 0
X286 audit_d271 avdd.t479 avdd.t481 avdd.t480 pfet_05v0 ad=24.1516p pd=0.11066m as=0 ps=0 w=54.89u l=4u
VAUD272 psrg_m3_protected.t1 audit_d272 0
X287 audit_d272 vgn2.t9 v2.t1 avss nfet_05v0 ad=6.424p pd=30.08u as=6.424p ps=30.08u w=14.6u l=4u
VAUD273 vgn1.t6 audit_d273 0
X288 audit_d273 vcasp vx1.t6 avdd.t991 pfet_05v0 ad=7.2248p pd=33.72u as=7.2248p ps=33.72u w=16.42u l=4u
VAUD274 avdd.t166 audit_d274 0
X289 audit_d274 avdd.t163 avdd.t165 avdd.t164 pfet_05v0 ad=8.3556p pd=38.86u as=0 ps=0 w=18.99u l=8u
VAUD275 avdd.t646 audit_d275 0
X290 audit_d275 avdd.t643 avdd.t645 avdd.t644 pfet_05v0 ad=7.37p pd=34.38u as=0 ps=0 w=16.75u l=2u
VAUD276 vgn1.t5 audit_d276 0
X291 audit_d276 vcasp vx1.t10 avdd.t1003 pfet_05v0 ad=7.2248p pd=33.72u as=7.2248p ps=33.72u w=16.42u l=4u
VAUD277 avdd.t534 audit_d277 0
X292 audit_d277 avdd.t531 avdd.t533 avdd.t532 pfet_05v0 ad=7.2248p pd=33.72u as=0 ps=0 w=16.42u l=4u
VAUD278 avdd.t729 audit_d278 0
X293 audit_d278 avdd.t726 avdd.t728 avdd.t727 pfet_05v0 ad=24.1516p pd=0.11066m as=0 ps=0 w=54.89u l=4u
VAUD279 rbit2top.t0 audit_d279 0
X294 audit_d279 b2.t2 rbit3top.t0 dvss nfet_03v3 ad=8.8p pd=40.88u as=8.8p ps=40.88u w=20u l=0.28u
VAUD280 xf1.t9 audit_d280 0
X295 audit_d280 v1.t2 vsp.t12 avdd.t1029 pfet_05v0 ad=24.1516p pd=0.11066m as=24.1516p ps=0.11066m w=54.89u l=4u
VAUD281 avdd.t226 audit_d281 0
X296 audit_d281 avdd.t223 avdd.t225 avdd.t224 pfet_05v0 ad=8.25p pd=38.38u as=0 ps=0 w=18.75u l=8u
VAUD282 avdd.t334 audit_d282 0
X297 audit_d282 avdd.t331 avdd.t333 avdd.t332 pfet_05v0 ad=8.338p pd=38.78u as=0 ps=0 w=18.95u l=8u
VAUD283 vx2.t5 audit_d283 0
X298 audit_d283 psrg_m3_feed.t9 avdd.t1031 avdd.t1030 pfet_05v0 ad=7.37p pd=34.38u as=7.37p ps=34.38u w=16.75u l=2u
VAUD284 vsu audit_d284 0
X299 audit_d284 psrg_m3_feed.t8 avdd.t902 avdd.t901 pfet_05v0 ad=0.88p pd=4.88u as=0.88p ps=4.88u w=2u l=2u
VAUD285 avdd.t222 audit_d285 0
X300 audit_d285 avdd.t219 avdd.t221 avdd.t220 pfet_05v0 ad=8.25p pd=38.38u as=0 ps=0 w=18.75u l=8u
X301 vref.t12 avss cap_mim_2f0fF c_width=70.7u c_length=70.7u
VAUD286 avdd.t330 audit_d286 0
X302 audit_d286 avdd.t327 avdd.t329 avdd.t328 pfet_05v0 ad=8.338p pd=38.78u as=0 ps=0 w=18.95u l=8u
VAUD287 rbit5top.t0 audit_d287 0
X303 audit_d287 b5.t1 rbit6top.t1 dvss nfet_03v3 ad=1.1p pd=5.88u as=1.1p ps=5.88u w=2.5u l=0.28u
VAUD288 avdd.t702 audit_d288 0
X304 audit_d288 avdd.t699 avdd.t701 avdd.t700 pfet_05v0 ad=9.7724p pd=45.3u as=0 ps=0 w=22.21u l=8u
VAUD289 xf2.t9 audit_d289 0
X305 audit_d289 v2.t6 vsp.t14 avdd.t1040 pfet_05v0 ad=24.1516p pd=0.11066m as=24.1516p ps=0.11066m w=54.89u l=4u
VAUD290 avdd.t122 audit_d290 0
X306 audit_d290 avdd.t119 avdd.t121 avdd.t120 pfet_05v0 ad=8.25p pd=38.38u as=0 ps=0 w=18.75u l=8u
X307 vref.t7 avss cap_mim_2f0fF c_width=70.7u c_length=70.7u
VAUD291 avdd.t654 audit_d291 0
X308 audit_d291 avdd.t651 avdd.t653 avdd.t652 pfet_05v0 ad=7.37p pd=34.38u as=0 ps=0 w=16.75u l=2u
VAUD292 vbp_bias.t23 audit_d292 0
X309 audit_d292 vbp_bias.t22 avdd.t7 avdd.t6 pfet_03v3 ad=8.3864p pd=39u as=8.3864p ps=39u w=19.06u l=8u
X310 rbit1top.t0 rbit0top.t1 avss ppolyf_u_1k r_width=6.6u r_length=2u
VAUD293 vgn1.t4 audit_d293 0
X311 audit_d293 vcasp vx1.t7 avdd.t996 pfet_05v0 ad=7.2248p pd=33.72u as=7.2248p ps=33.72u w=16.42u l=4u
X312 vref.t15 avss cap_mim_2f0fF c_width=70.7u c_length=70.7u
VAUD294 vbn_i.t7 audit_d294 0
X313 audit_d294 vbp_i.t53 avdd.t1046 avdd.t1045 pfet_05v0 ad=8.25p pd=38.38u as=8.25p ps=38.38u w=18.75u l=8u
VAUD295 avdd.t118 audit_d295 0
X314 audit_d295 avdd.t115 avdd.t117 avdd.t116 pfet_05v0 ad=8.25p pd=38.38u as=0 ps=0 w=18.75u l=8u
VAUD296 avdd.t498 audit_d296 0
X315 audit_d296 avdd.t495 avdd.t497 avdd.t496 pfet_05v0 ad=24.1516p pd=0.11066m as=0 ps=0 w=54.89u l=4u
VAUD297 vbn_i.t0 audit_d297 0
X316 audit_d297 vbp_i.t55 avdd.t37 avdd.t36 pfet_05v0 ad=8.25p pd=38.38u as=8.25p ps=38.38u w=18.75u l=8u
VAUD298 avdd.t282 audit_d298 0
X317 audit_d298 avdd.t279 avdd.t281 avdd.t280 pfet_05v0 ad=8.3556p pd=38.86u as=0 ps=0 w=18.99u l=8u
X318 vref.t10 avss cap_mim_2f0fF c_width=70.7u c_length=70.7u
VAUD299 avdd.t570 audit_d299 0
X319 audit_d299 avdd.t567 avdd.t569 avdd.t568 pfet_05v0 ad=7.37p pd=34.38u as=0 ps=0 w=16.75u l=2u
VAUD300 b4_b.t0 audit_d300 0
X320 audit_d300 b4.t0 dvdd.t7 dvdd.t6 pfet_03v3 ad=1.32p pd=6.88u as=1.32p ps=6.88u w=3u l=0.5u
VAUD301 vnx_bias audit_d301 0
X321 audit_d301 vnx_bias avss avss nfet_03v3 ad=0.7128p pd=4.12u as=0.7128p ps=4.12u w=1.62u l=8u
VAUD302 vbn.t2 audit_d302 0
X322 audit_d302 vcasp vaux.t2 avdd.t1006 pfet_05v0 ad=7.04p pd=32.88u as=7.04p ps=32.88u w=16u l=4u
VAUD303 vx1.t3 audit_d303 0
X323 audit_d303 psrg_m3_feed.t15 avdd.t1017 avdd.t1016 pfet_05v0 ad=7.37p pd=34.38u as=7.37p ps=34.38u w=16.75u l=2u
VAUD304 rbit2top.t9 audit_d304 0
X324 audit_d304 b1_b.t2 rbit1top.t11 dvdd.t14 pfet_03v3 ad=17.6p pd=80.88u as=17.6p ps=80.88u w=40u l=0.28u
VAUD305 vbn_fold.t3 audit_d305 0
X325 audit_d305 vbp_i.t43 avdd.t41 avdd.t40 pfet_05v0 ad=8.3556p pd=38.86u as=8.3556p ps=38.86u w=18.99u l=8u
VAUD306 pm2.t8 audit_d306 0
X326 audit_d306 y1.t7 avdd.t924 avdd.t923 pfet_05v0 ad=9.1344p pd=42.4u as=9.1344p ps=42.4u w=20.76u l=4u
VAUD307 avdd.t430 audit_d307 0
X327 audit_d307 avdd.t427 avdd.t429 avdd.t428 pfet_05v0 ad=7.2248p pd=33.72u as=0 ps=0 w=16.42u l=4u
VAUD308 vbn_sink.t7 audit_d308 0
X328 audit_d308 vbp_i.t36 avdd.t51 avdd.t50 pfet_05v0 ad=8.338p pd=38.78u as=8.338p ps=38.78u w=18.95u l=8u
VAUD309 vbn_fold.t8 audit_d309 0
X329 audit_d309 vbp_i.t44 avdd.t84 avdd.t83 pfet_05v0 ad=8.3556p pd=38.86u as=8.3556p ps=38.86u w=18.99u l=8u
VAUD310 b1_b.t1 audit_d310 0
X330 audit_d310 b1.t1 dvss dvss nfet_03v3 ad=0.44p pd=2.88u as=0.44p ps=2.88u w=1u l=0.5u
VAUD311 vbp_bias.t21 audit_d311 0
X331 audit_d311 vbp_bias.t20 avdd.t906 avdd.t905 pfet_03v3 ad=8.3864p pd=39u as=8.3864p ps=39u w=19.06u l=8u
VAUD312 xf2.t7 audit_d312 0
X332 audit_d312 vbn_sink.t21 avss avss nfet_05v0 ad=7.1896p pd=33.56u as=7.1896p ps=33.56u w=16.34u l=8u
VAUD313 rbit1top.t10 audit_d313 0
X333 audit_d313 b1.t0 rbit2top.t6 dvss nfet_03v3 ad=17.6p pd=80.88u as=17.6p ps=80.88u w=40u l=0.28u
VAUD314 pm1.t5 audit_d314 0
X334 audit_d314 y1.t16 avdd.t959 avdd.t958 pfet_05v0 ad=9.1344p pd=42.4u as=9.1344p ps=42.4u w=20.76u l=4u
VAUD315 vsu audit_d315 0
X335 audit_d315 vsu bgsu1 avss nfet_05v0 ad=0.44p pd=2.88u as=0.44p ps=2.88u w=1u l=2u
VAUD316 vgn2.t4 audit_d316 0
X336 audit_d316 vbp_cas.t25 pm2.t11 avdd.t980 pfet_05v0 ad=9.7724p pd=45.3u as=9.7724p ps=45.3u w=22.21u l=8u
VAUD317 avdd.t829 audit_d317 0
X337 audit_d317 avdd.t826 avdd.t828 avdd.t827 pfet_05v0 ad=9.7724p pd=45.3u as=0 ps=0 w=22.21u l=8u
VAUD318 xf1.t4 audit_d318 0
X338 audit_d318 vbn_sink.t22 avss avss nfet_05v0 ad=7.1896p pd=33.56u as=7.1896p ps=33.56u w=16.34u l=8u
VAUD319 b4_b.t1 audit_d319 0
X339 audit_d319 b4.t1 dvss dvss nfet_03v3 ad=0.44p pd=2.88u as=0.44p ps=2.88u w=1u l=0.5u
VAUD320 vbn_sink.t19 audit_d320 0
X340 audit_d320 vbp_i.t34 avdd.t936 avdd.t935 pfet_05v0 ad=8.338p pd=38.78u as=8.338p ps=38.78u w=18.95u l=8u
VAUD321 vbp_cas.t7 audit_d321 0
X341 audit_d321 vbp_cas.t6 vbp_bias.t2 avdd.t969 pfet_05v0 ad=8.3292p pd=38.74u as=8.3292p ps=38.74u w=18.93u l=8u
VAUD322 avdd.t250 audit_d322 0
X342 audit_d322 avdd.t247 avdd.t249 avdd.t248 pfet_05v0 ad=8.25p pd=38.38u as=0 ps=0 w=18.75u l=8u
VAUD323 xf1.t1 audit_d323 0
X343 audit_d323 vbn_sink.t30 avss avss nfet_05v0 ad=7.1896p pd=33.56u as=7.1896p ps=33.56u w=16.34u l=8u
VAUD324 avdd.t761 audit_d324 0
X344 audit_d324 avdd.t758 avdd.t760 avdd.t759 pfet_05v0 ad=9.7724p pd=45.3u as=0 ps=0 w=22.21u l=8u
VAUD325 vsp.t13 audit_d325 0
X345 audit_d325 vbp_tail.t7 avdd.t1035 avdd.t1034 pfet_03v3 ad=12.7204p pd=58.7u as=12.7204p ps=58.7u w=28.91u l=6u
VAUD326 avdd.t338 audit_d326 0
X346 audit_d326 avdd.t335 avdd.t337 avdd.t336 pfet_05v0 ad=8.338p pd=38.78u as=0 ps=0 w=18.95u l=8u
VAUD327 vbp_cas.t9 audit_d327 0
X347 audit_d327 vbp_cas.t8 vbp_bias.t1 avdd.t1044 pfet_05v0 ad=8.3292p pd=38.74u as=8.3292p ps=38.74u w=18.93u l=8u
VAUD328 aux_gate audit_d328 0
X348 audit_d328 vbn_i.t8 avss avss nfet_05v0 ad=0.44p pd=2.88u as=0.44p ps=2.88u w=1u l=8u
VAUD329 avdd.t162 audit_d329 0
X349 audit_d329 avdd.t159 avdd.t161 avdd.t160 pfet_05v0 ad=8.3556p pd=38.86u as=0 ps=0 w=18.99u l=8u
VAUD330 avdd.t146 audit_d330 0
X350 audit_d330 avdd.t143 avdd.t145 avdd.t144 pfet_05v0 ad=8.25p pd=38.38u as=0 ps=0 w=18.75u l=8u
VAUD331 avdd.t562 audit_d331 0
X351 audit_d331 avdd.t559 avdd.t561 avdd.t560 pfet_05v0 ad=7.2248p pd=33.72u as=0 ps=0 w=16.42u l=4u
VAUD332 avdd.t466 audit_d332 0
X352 audit_d332 avdd.t463 avdd.t465 avdd.t464 pfet_05v0 ad=7.37p pd=34.38u as=0 ps=0 w=16.75u l=2u
VAUD333 avdd.t486 audit_d333 0
X353 audit_d333 avdd.t483 avdd.t485 avdd.t484 pfet_05v0 ad=24.1516p pd=0.11066m as=0 ps=0 w=54.89u l=4u
VAUD334 avdd.t158 audit_d334 0
X354 audit_d334 avdd.t155 avdd.t157 avdd.t156 pfet_05v0 ad=8.3556p pd=38.86u as=0 ps=0 w=18.99u l=8u
VAUD335 vgn1.t1 audit_d335 0
X355 audit_d335 vgn1.t0 v1.t1 avss nfet_05v0 ad=6.424p pd=30.08u as=6.424p ps=30.08u w=14.6u l=4u
VAUD336 rb_mid audit_d336 0
X356 audit_d336 rb_mid avss avss nfet_05v0 ad=0.2376p pd=1.96u as=0.2376p ps=1.96u w=0.54u l=20u
VAUD337 avdd.t769 audit_d337 0
X357 audit_d337 avdd.t766 avdd.t768 avdd.t767 pfet_05v0 ad=9.1344p pd=42.4u as=0 ps=0 w=20.76u l=4u
VAUD338 avdd.t733 audit_d338 0
X358 audit_d338 avdd.t730 avdd.t732 avdd.t731 pfet_05v0 ad=24.1516p pd=0.11066m as=0 ps=0 w=54.89u l=4u
VAUD339 avdd.t698 audit_d339 0
X359 audit_d339 avdd.t695 avdd.t697 avdd.t696 pfet_05v0 ad=9.7724p pd=45.3u as=0 ps=0 w=22.21u l=8u
VAUD340 rbit1top.t3 audit_d340 0
X360 audit_d340 b0_b.t5 rbit0top.t4 dvdd.t3 pfet_03v3 ad=17.6p pd=80.88u as=17.6p ps=80.88u w=40u l=0.28u
VAUD341 vref.t3 audit_d341 0
X361 audit_d341 vcasp vx3.t8 avdd.t1005 pfet_05v0 ad=7.2248p pd=33.72u as=7.2248p ps=33.72u w=16.42u l=4u
VAUD342 xf2.t11 audit_d342 0
X362 audit_d342 vbn_sink.t25 avss avss nfet_05v0 ad=7.1896p pd=33.56u as=7.1896p ps=33.56u w=16.34u l=8u
VAUD343 avdd.t478 audit_d343 0
X363 audit_d343 avdd.t475 avdd.t477 avdd.t476 pfet_05v0 ad=24.1516p pd=0.11066m as=0 ps=0 w=54.89u l=4u
VAUD344 avdd.t238 audit_d344 0
X364 audit_d344 avdd.t235 avdd.t237 avdd.t236 pfet_05v0 ad=8.25p pd=38.38u as=0 ps=0 w=18.75u l=8u
VAUD345 avdd.t694 audit_d345 0
X365 audit_d345 avdd.t691 avdd.t693 avdd.t692 pfet_05v0 ad=9.7724p pd=45.3u as=0 ps=0 w=22.21u l=8u
VAUD346 b0_b.t1 audit_d346 0
X366 audit_d346 b0.t0 dvss dvss nfet_03v3 ad=0.44p pd=2.88u as=0.44p ps=2.88u w=1u l=0.5u
VAUD347 y1.t5 audit_d347 0
X367 audit_d347 vbp_cas.t22 pm1.t10 avdd.t977 pfet_05v0 ad=9.7724p pd=45.3u as=9.7724p ps=45.3u w=22.21u l=8u
VAUD348 vbp_tail.t5 audit_d348 0
X368 audit_d348 vbp_tail.t4 avdd.t918 avdd.t917 pfet_03v3 ad=6.05p pd=28.38u as=6.05p ps=28.38u w=13.75u l=6u
VAUD349 rbit6top.t5 audit_d349 0
X369 audit_d349 b6.t1 vq3.t2 dvss nfet_03v3 ad=0.55p pd=3.38u as=0.55p ps=3.38u w=1.25u l=0.28u
VAUD350 xf2.t8 audit_d350 0
X370 audit_d350 v2.t7 vsp.t7 avdd.t1020 pfet_05v0 ad=24.1516p pd=0.11066m as=24.1516p ps=0.11066m w=54.89u l=4u
VAUD351 vbp_i.t2 audit_d351 0
X371 audit_d351 vbp_i.t1 avdd.t47 avdd.t46 pfet_05v0 ad=8.25p pd=38.38u as=8.25p ps=38.38u w=18.75u l=8u
VAUD352 avdd.t749 audit_d352 0
X372 audit_d352 avdd.t746 avdd.t748 avdd.t747 pfet_05v0 ad=24.1516p pd=0.11066m as=0 ps=0 w=54.89u l=4u
VAUD353 vbp_bias.t25 audit_d353 0
X373 audit_d353 vbp_bias.t24 avdd.t910 avdd.t909 pfet_03v3 ad=8.3864p pd=39u as=8.3864p ps=39u w=19.06u l=8u
VAUD354 vbn_i.t3 audit_d354 0
X374 audit_d354 vbp_i.t56 avdd.t73 avdd.t72 pfet_05v0 ad=8.25p pd=38.38u as=8.25p ps=38.38u w=18.75u l=8u
X375 vref.t14 avss cap_mim_2f0fF c_width=70.7u c_length=70.7u
VAUD355 avdd.t134 audit_d355 0
X376 audit_d355 avdd.t131 avdd.t133 avdd.t132 pfet_05v0 ad=8.25p pd=38.38u as=0 ps=0 w=18.75u l=8u
VAUD356 avdd.t342 audit_d356 0
X377 audit_d356 avdd.t339 avdd.t341 avdd.t340 pfet_05v0 ad=8.338p pd=38.78u as=0 ps=0 w=18.95u l=8u
VAUD357 vbn_sink.t8 audit_d357 0
X378 audit_d357 vbp_i.t37 avdd.t53 avdd.t52 pfet_05v0 ad=8.338p pd=38.78u as=8.338p ps=38.78u w=18.95u l=8u
VAUD358 vx3.t10 audit_d358 0
X379 audit_d358 psrg_m3_feed.t12 avdd.t1039 avdd.t1038 pfet_05v0 ad=7.37p pd=34.38u as=7.37p ps=34.38u w=16.75u l=2u
VAUD359 vx2.t1 audit_d359 0
X380 audit_d359 psrg_m3_feed.t22 avdd.t986 avdd.t985 pfet_05v0 ad=7.37p pd=34.38u as=7.37p ps=34.38u w=16.75u l=2u
VAUD360 avdd.t446 audit_d360 0
X381 audit_d360 avdd.t443 avdd.t445 avdd.t444 pfet_05v0 ad=7.37p pd=34.38u as=0 ps=0 w=16.75u l=2u
VAUD361 avdd.t785 audit_d361 0
X382 audit_d361 avdd.t782 avdd.t784 avdd.t783 pfet_05v0 ad=9.1344p pd=42.4u as=0 ps=0 w=20.76u l=4u
X383 vref.t9 avss cap_mim_2f0fF c_width=70.7u c_length=70.7u
VAUD362 iref_gate.t2 audit_d362 0
X384 audit_d362 vbp_i.t11 avdd.t930 avdd.t929 pfet_05v0 ad=35.2p pd=0.16088m as=35.2p ps=0.16088m w=80u l=1u
VAUD363 avdd.t470 audit_d363 0
X385 audit_d363 avdd.t467 avdd.t469 avdd.t468 pfet_05v0 ad=7.37p pd=34.38u as=0 ps=0 w=16.75u l=2u
VAUD364 vsua audit_d364 0
X386 audit_d364 vcasp avdd.t1008 avdd.t1007 pfet_05v0 ad=0.88p pd=4.88u as=0.88p ps=4.88u w=2u l=2u
VAUD365 avdd.t398 audit_d365 0
X387 audit_d365 avdd.t395 avdd.t397 avdd.t396 pfet_05v0 ad=7.2248p pd=33.72u as=0 ps=0 w=16.42u l=4u
VAUD366 vbn_sink.t1 audit_d366 0
X388 audit_d366 vbp_i.t29 avdd.t21 avdd.t20 pfet_05v0 ad=8.338p pd=38.78u as=8.338p ps=38.78u w=18.95u l=8u
VAUD367 vbn_sink.t4 audit_d367 0
X389 audit_d367 vbp_i.t38 avdd.t33 avdd.t32 pfet_05v0 ad=8.338p pd=38.78u as=8.338p ps=38.78u w=18.95u l=8u
VAUD368 psrg_vnc.t2 audit_d368 0
X390 audit_d368 vbp_i.t13 avdd.t29 avdd.t28 pfet_05v0 ad=7.8056p pd=36.36u as=7.8056p ps=36.36u w=17.74u l=4u
VAUD369 b6_b.t1 audit_d369 0
X391 audit_d369 b6.t2 dvss dvss nfet_03v3 ad=0.44p pd=2.88u as=0.44p ps=2.88u w=1u l=0.5u
VAUD370 avdd.t686 audit_d370 0
X392 audit_d370 avdd.t683 avdd.t685 avdd.t684 pfet_05v0 ad=9.7724p pd=45.3u as=0 ps=0 w=22.21u l=8u
VAUD371 vsu1 audit_d371 0
X393 audit_d371 vbp_i.t22 vsu2 avss nfet_05v0 ad=0.22p pd=1.88u as=0.22p ps=1.88u w=0.5u l=50u
VAUD372 avdd.t642 audit_d372 0
X394 audit_d372 avdd.t639 avdd.t641 avdd.t640 pfet_05v0 ad=7.37p pd=34.38u as=0 ps=0 w=16.75u l=2u
VAUD373 vbp_i.t4 audit_d373 0
X395 audit_d373 vbp_i.t3 avdd.t90 avdd.t89 pfet_05v0 ad=8.25p pd=38.38u as=8.25p ps=38.38u w=18.75u l=8u
VAUD374 avdd.t682 audit_d374 0
X396 audit_d374 avdd.t679 avdd.t681 avdd.t680 pfet_05v0 ad=9.7724p pd=45.3u as=0 ps=0 w=22.21u l=8u
VAUD375 bgsu2 audit_d375 0
X397 audit_d375 bgsu2 avss avss nfet_03v3 ad=0.44p pd=2.88u as=0.44p ps=2.88u w=1u l=2u
VAUD376 y1.t1 audit_d376 0
X398 audit_d376 vbp_cas.t27 pm1.t1 avdd.t954 pfet_05v0 ad=9.7724p pd=45.3u as=9.7724p ps=45.3u w=22.21u l=8u
VAUD377 xf1.t10 audit_d377 0
X399 audit_d377 v1.t4 vsp.t10 avdd.t1027 pfet_05v0 ad=24.1516p pd=0.11066m as=24.1516p ps=0.11066m w=54.89u l=4u
VAUD378 vcasp audit_d378 0
X400 audit_d378 vbn.t4 avss avss nfet_05v0 ad=3.322p pd=15.98u as=3.322p ps=15.98u w=7.55u l=4u
VAUD379 b2_b.t1 audit_d379 0
X401 audit_d379 b2.t1 dvss dvss nfet_03v3 ad=0.44p pd=2.88u as=0.44p ps=2.88u w=1u l=0.5u
VAUD380 avdd.t314 audit_d380 0
X402 audit_d380 avdd.t311 avdd.t313 avdd.t312 pfet_05v0 ad=8.338p pd=38.78u as=0 ps=0 w=18.95u l=8u
VAUD381 avdd.t266 audit_d381 0
X403 audit_d381 avdd.t263 avdd.t265 avdd.t264 pfet_05v0 ad=8.3556p pd=38.86u as=0 ps=0 w=18.99u l=8u
VAUD382 vx1.t2 audit_d382 0
X404 audit_d382 psrg_m3_feed.t20 avdd.t982 avdd.t981 pfet_05v0 ad=7.37p pd=34.38u as=7.37p ps=34.38u w=16.75u l=2u
VAUD383 su_state.t2 audit_d383 0
X405 audit_d383 vgn2.t10 avss avss nfet_05v0 ad=1.76p pd=8.88u as=1.76p ps=8.88u w=4u l=1u
VAUD384 vgn2.t3 audit_d384 0
X406 audit_d384 vbp_cas.t28 pm2.t0 avdd.t955 pfet_05v0 ad=9.7724p pd=45.3u as=9.7724p ps=45.3u w=22.21u l=8u
VAUD385 avdd.t574 audit_d385 0
X407 audit_d385 avdd.t571 avdd.t573 avdd.t572 pfet_05v0 ad=7.37p pd=34.38u as=0 ps=0 w=16.75u l=2u
VAUD386 vref.t2 audit_d386 0
X408 audit_d386 vcasp vx3.t4 avdd.t993 pfet_05v0 ad=7.2248p pd=33.72u as=7.2248p ps=33.72u w=16.42u l=4u
VAUD387 rbit3top.t5 audit_d387 0
X409 audit_d387 b2_b.t2 rbit2top.t2 dvdd.t16 pfet_03v3 ad=8.8p pd=40.88u as=8.8p ps=40.88u w=20u l=0.28u
X410 rbit5top.t4 rbit4top.t3 avss ppolyf_u_1k r_width=6.6u r_length=32u
VAUD388 avdd.t809 audit_d388 0
X411 audit_d388 avdd.t806 avdd.t808 avdd.t807 pfet_05v0 ad=9.1344p pd=42.4u as=0 ps=0 w=20.76u l=4u
VAUD389 auxsu1 audit_d389 0
X412 audit_d389 auxsu1 auxsu2 avss nfet_03v3 ad=0.44p pd=2.88u as=0.44p ps=2.88u w=1u l=2u
VAUD390 vgn1.t7 audit_d390 0
X413 audit_d390 vcasp vx1.t8 avdd.t998 pfet_05v0 ad=7.2248p pd=33.72u as=7.2248p ps=33.72u w=16.42u l=4u
VAUD391 vsp.t5 audit_d391 0
X414 audit_d391 vbp_tail.t8 avdd.t944 avdd.t943 pfet_03v3 ad=12.7204p pd=58.7u as=12.7204p ps=58.7u w=28.91u l=6u
VAUD392 avdd.t262 audit_d392 0
X415 audit_d392 avdd.t259 avdd.t261 avdd.t260 pfet_05v0 ad=8.3556p pd=38.86u as=0 ps=0 w=18.99u l=8u
VAUD393 vbn_sink.t3 audit_d393 0
X416 audit_d393 vbp_i.t31 avdd.t25 avdd.t24 pfet_05v0 ad=8.338p pd=38.78u as=8.338p ps=38.78u w=18.95u l=8u
VAUD394 b0_b.t0 audit_d394 0
X417 audit_d394 b0.t1 dvdd.t11 dvdd.t10 pfet_03v3 ad=1.32p pd=6.88u as=1.32p ps=6.88u w=3u l=0.5u
VAUD395 avdd.t622 audit_d395 0
X418 audit_d395 avdd.t619 avdd.t621 avdd.t620 pfet_05v0 ad=7.2248p pd=33.72u as=0 ps=0 w=16.42u l=4u
X419 rbit2top.t5 rbit1top.t9 avss ppolyf_u_1k r_width=6.6u r_length=4u
VAUD396 avdd.t546 audit_d396 0
X420 audit_d396 avdd.t543 avdd.t545 avdd.t544 pfet_05v0 ad=7.37p pd=34.38u as=0 ps=0 w=16.75u l=2u
VAUD397 aux_gate audit_d397 0
X421 audit_d397 vcasp avdd.t990 avdd.t989 pfet_05v0 ad=0.22p pd=1.88u as=0.22p ps=1.88u w=0.5u l=10u
VAUD398 vx3.t3 audit_d398 0
X422 audit_d398 psrg_m3_feed.t21 avdd.t984 avdd.t983 pfet_05v0 ad=7.37p pd=34.38u as=7.37p ps=34.38u w=16.75u l=2u
VAUD399 avdd.t414 audit_d399 0
X423 audit_d399 avdd.t411 avdd.t413 avdd.t412 pfet_05v0 ad=7.2248p pd=33.72u as=0 ps=0 w=16.42u l=4u
VAUD400 avdd.t869 audit_d400 0
X424 audit_d400 avdd.t866 avdd.t868 avdd.t867 pfet_05v0 ad=9.1344p pd=42.4u as=0 ps=0 w=20.76u l=4u
VAUD401 avdd.t530 audit_d401 0
X425 audit_d401 avdd.t527 avdd.t529 avdd.t528 pfet_05v0 ad=7.2248p pd=33.72u as=0 ps=0 w=16.42u l=4u
VAUD402 xf1.t11 audit_d402 0
X426 audit_d402 vbn_sink.t26 avss avss nfet_05v0 ad=7.1896p pd=33.56u as=7.1896p ps=33.56u w=16.34u l=8u
VAUD403 vgn2.t5 audit_d403 0
X427 audit_d403 vbp_cas.t24 pm2.t10 avdd.t979 pfet_05v0 ad=9.7724p pd=45.3u as=9.7724p ps=45.3u w=22.21u l=8u
VAUD404 avdd.t841 audit_d404 0
X428 audit_d404 avdd.t838 avdd.t840 avdd.t839 pfet_05v0 ad=9.7724p pd=45.3u as=0 ps=0 w=22.21u l=8u
VAUD405 avdd.t234 audit_d405 0
X429 audit_d405 avdd.t231 avdd.t233 avdd.t232 pfet_05v0 ad=8.25p pd=38.38u as=0 ps=0 w=18.75u l=8u
VAUD406 avdd.t857 audit_d406 0
X430 audit_d406 avdd.t854 avdd.t856 avdd.t855 pfet_05v0 ad=9.1344p pd=42.4u as=0 ps=0 w=20.76u l=4u
VAUD407 rbit1top.t6 audit_d407 0
X431 audit_d407 b0_b.t2 rbit0top.t7 dvdd.t21 pfet_03v3 ad=17.6p pd=80.88u as=17.6p ps=80.88u w=40u l=0.28u
VAUD408 y1.t2 audit_d408 0
X432 audit_d408 vbp_cas.t30 pm1.t2 avdd.t964 pfet_05v0 ad=9.7724p pd=45.3u as=9.7724p ps=45.3u w=22.21u l=8u
VAUD409 vsp.t15 audit_d409 0
X433 audit_d409 vbp_tail.t10 avdd.t1042 avdd.t1041 pfet_03v3 ad=12.7204p pd=58.7u as=12.7204p ps=58.7u w=28.91u l=6u
VAUD410 avdd.t214 audit_d410 0
X434 audit_d410 avdd.t211 avdd.t213 avdd.t212 pfet_05v0 ad=8.25p pd=38.38u as=0 ps=0 w=18.75u l=8u
VAUD411 vx2.t4 audit_d411 0
X435 audit_d411 psrg_m3_feed.t14 avdd.t1015 avdd.t1014 pfet_05v0 ad=7.37p pd=34.38u as=7.37p ps=34.38u w=16.75u l=2u
VAUD412 y1.t3 audit_d412 0
X436 audit_d412 vbp_cas.t31 pm1.t3 avdd.t965 pfet_05v0 ad=9.7724p pd=45.3u as=9.7724p ps=45.3u w=22.21u l=8u
VAUD413 avdd.t182 audit_d413 0
X437 audit_d413 avdd.t179 avdd.t181 avdd.t180 pfet_05v0 ad=8.25p pd=38.38u as=0 ps=0 w=18.75u l=8u
VAUD414 avdd.t765 audit_d414 0
X438 audit_d414 avdd.t762 avdd.t764 avdd.t763 pfet_05v0 ad=9.1344p pd=42.4u as=0 ps=0 w=20.76u l=4u
VAUD415 xf1.t6 audit_d415 0
X439 audit_d415 v1.t6 vsp.t8 avdd.t1025 pfet_05v0 ad=24.1516p pd=0.11066m as=24.1516p ps=0.11066m w=54.89u l=4u
VAUD416 vx3.t0 audit_d416 0
X440 audit_d416 psrg_m3_feed.t19 avdd.t5 avdd.t4 pfet_05v0 ad=7.37p pd=34.38u as=7.37p ps=34.38u w=16.75u l=2u
VAUD417 avdd.t130 audit_d417 0
X441 audit_d417 avdd.t127 avdd.t129 avdd.t128 pfet_05v0 ad=8.25p pd=38.38u as=0 ps=0 w=18.75u l=8u
VAUD418 avdd.t410 audit_d418 0
X442 audit_d418 avdd.t407 avdd.t409 avdd.t408 pfet_05v0 ad=7.2248p pd=33.72u as=0 ps=0 w=16.42u l=4u
VAUD419 avdd.t634 audit_d419 0
X443 audit_d419 avdd.t631 avdd.t633 avdd.t632 pfet_05v0 ad=7.37p pd=34.38u as=0 ps=0 w=16.75u l=2u
VAUD420 avdd.t434 audit_d420 0
X444 audit_d420 avdd.t431 avdd.t433 avdd.t432 pfet_05v0 ad=7.2248p pd=33.72u as=0 ps=0 w=16.42u l=4u
VAUD421 auxsu2 audit_d421 0
X445 audit_d421 auxsu2 avss avss nfet_03v3 ad=0.44p pd=2.88u as=0.44p ps=2.88u w=1u l=2u
VAUD422 avdd.t110 audit_d422 0
X446 audit_d422 avdd.t107 avdd.t109 avdd.t108 pfet_05v0 ad=8.25p pd=38.38u as=0 ps=0 w=18.75u l=8u
VAUD423 rbit1top.t2 audit_d423 0
X447 audit_d423 b0_b.t6 rbit0top.t3 dvdd.t22 pfet_03v3 ad=17.6p pd=80.88u as=17.6p ps=80.88u w=40u l=0.28u
VAUD424 avdd.t753 audit_d424 0
X448 audit_d424 avdd.t750 avdd.t752 avdd.t751 pfet_05v0 ad=24.1516p pd=0.11066m as=0 ps=0 w=54.89u l=4u
VAUD425 avdd.t290 audit_d425 0
X449 audit_d425 avdd.t287 avdd.t289 avdd.t288 pfet_05v0 ad=8.3556p pd=38.86u as=0 ps=0 w=18.99u l=8u
VAUD426 pm2.t4 audit_d426 0
X450 audit_d426 y1.t15 avdd.t952 avdd.t951 pfet_05v0 ad=9.1344p pd=42.4u as=9.1344p ps=42.4u w=20.76u l=4u
VAUD427 avdd.t374 audit_d427 0
X451 audit_d427 avdd.t371 avdd.t373 avdd.t372 pfet_05v0 ad=8.338p pd=38.78u as=0 ps=0 w=18.95u l=8u
VAUD428 avdd.t797 audit_d428 0
X452 audit_d428 avdd.t794 avdd.t796 avdd.t795 pfet_05v0 ad=9.7724p pd=45.3u as=0 ps=0 w=22.21u l=8u
VAUD429 rbit2top.t8 audit_d429 0
X453 audit_d429 b1_b.t3 rbit1top.t13 dvdd.t13 pfet_03v3 ad=17.6p pd=80.88u as=17.6p ps=80.88u w=40u l=0.28u
VAUD430 avdd.t662 audit_d430 0
X454 audit_d430 avdd.t659 avdd.t661 avdd.t660 pfet_05v0 ad=24.1516p pd=0.11066m as=0 ps=0 w=54.89u l=4u
VAUD431 avdd.t286 audit_d431 0
X455 audit_d431 avdd.t283 avdd.t285 avdd.t284 pfet_05v0 ad=8.3556p pd=38.86u as=0 ps=0 w=18.99u l=8u
VAUD432 avdd.t678 audit_d432 0
X456 audit_d432 avdd.t675 avdd.t677 avdd.t676 pfet_05v0 ad=9.7724p pd=45.3u as=0 ps=0 w=22.21u l=8u
VAUD433 avdd.t526 audit_d433 0
X457 audit_d433 avdd.t523 avdd.t525 avdd.t524 pfet_05v0 ad=24.1516p pd=0.11066m as=0 ps=0 w=54.89u l=4u
VAUD434 vgn2.t6 audit_d434 0
X458 audit_d434 vbp_cas.t21 pm2.t9 avdd.t971 pfet_05v0 ad=9.7724p pd=45.3u as=9.7724p ps=45.3u w=22.21u l=8u
VAUD435 pm1.t4 audit_d435 0
X459 audit_d435 y1.t17 avdd.t961 avdd.t960 pfet_05v0 ad=9.1344p pd=42.4u as=9.1344p ps=42.4u w=20.76u l=4u
VAUD436 avdd.t674 audit_d436 0
X460 audit_d436 avdd.t671 avdd.t673 avdd.t672 pfet_05v0 ad=9.7724p pd=45.3u as=0 ps=0 w=22.21u l=8u
VAUD437 psrg_vnc.t1 audit_d437 0
X461 audit_d437 vbp_i.t19 avdd.t17 avdd.t16 pfet_05v0 ad=7.8056p pd=36.36u as=7.8056p ps=36.36u w=17.74u l=4u
VAUD438 rbit0top.t8 audit_d438 0
X462 audit_d438 b0.t3 rbit1top.t7 dvss nfet_03v3 ad=17.6p pd=80.88u as=17.6p ps=80.88u w=40u l=0.28u
R0 v1.n5 v1.t2 67.301
R1 v1.n0 v1.t6 65.546
R2 v1.n4 v1.t5 65.501
R3 v1.n5 v1.t3 65.4526
R4 v1.n6 v1.t4 65.4526
R5 v1.n9 v1.n0 43.0205
R6 v1.n9 v1.n3 21.8705
R7 v1.n2 v1.t0 15.379
R8 v1.n3 v1.t1 13.8293
R9 v1.n10 v1.n9 10.2155
R10 v1 v1.n10 9.0905
R11 v1.n6 v1.n5 7.6505
R12 v1.n4 v1.n0 3.8705
R13 v1.n8 v1.n1 3.7365
R14 v1.n2 v1.n1 2.41301
R15 v1.n10 v1.n1 2.0175
R16 v1.n0 v1.n8 1.1705
R17 v1.n8 v1.n7 0.699338
R18 v1.n7 v1.n6 0.555141
R19 v1.n7 v1.n4 0.480177
R20 v1.n3 v1.n2 0.233095
R21 net4 net4.t0 29.4163
R22 vq2 vq2.t0 57.3643
R23 net3 net3.t0 149.625
R24 vref.t15 vref.n0 6.00378
R25 vref.n8 vref.n7 30.3305
R26 vref.t13 vref.n19 27.7295
R27 vref.n20 vref.t11 26.3374
R28 vref.n21 vref.n20 25.4255
R29 vref.n19 vref.n18 25.4132
R30 vref.n9 vref.n8 21.9584
R31 vref.n2 vref.n22 23.0535
R32 vref.n4 vref.n5 17.2918
R33 vref.n12 vref.n11 14.8505
R34 vref.n11 vref.t3 13.8364
R35 vref.t15 vref.n17 10.3635
R36 vref.n7 vref.t5 10.0775
R37 vref.n9 vref.t0 9.28143
R38 vref.n14 vref.t1 9.27752
R39 vref.n12 vref.t4 9.27361
R40 vref.n14 vref.n13 9.2705
R41 vref.n19 vref.t14 9.12959
R42 vref.n21 vref.n5 9.09275
R43 vref.n20 vref.t12 9.07925
R44 vref.t8 vref.n5 9.0075
R45 vref.n3 vref.n22 9.0005
R46 vref.t14 vref.n4 9.0005
R47 vref.n18 vref.n0 10.4353
R48 vref.n18 vref.n4 8.2985
R49 vref.n0 vref.n7 94.7
R50 vref.n22 vref.n21 8.21525
R51 vref.n16 vref.n9 7.6505
R52 vref.n8 vref.t2 4.78535
R53 vref.n1 vref.n2 0.282009
R54 vref.n13 vref.n12 4.5005
R55 vref.n15 vref.n14 4.5005
R56 vref.n11 vref.n10 2.0495
R57 vref vref.n2 1.25494
R58 vref.t15 vref.t14 1.5365
R59 vref.t14 vref.t8 1.5335
R60 vref.n1 vref.n3 1.5165
R61 vref.n16 vref.n15 1.4405
R62 vref.n15 vref.n6 1.1255
R63 vref.n17 vref.n16 1.1255
R64 vref.n13 vref.n10 1.1255
R65 vref.t12 vref.t13 0.951922
R66 vref.n10 vref.n6 0.4325
R67 vref.t14 vref.t9 0.23471
R68 vref.t15 vref.t10 0.23271
R69 vref.n1 vref.t6 0.16771
R70 vref.t12 vref.n3 0.1485
R71 vref.n3 vref.t7 0.14771
R72 vref.n17 vref.n6 0.1445
R73 vref.n1 vref.t11 0.122697
R74 vref.t13 vref.t8 0.104594
R75 b1.n1 b1.t0 553.995
R76 b1.n0 b1.t2 52.3518
R77 b1.n0 b1.t1 34.9128
R78 b1 b1.n1 34.0655
R79 b1.n1 b1.n0 8.7305
R80 b2.n0 b2.t2 299.99
R81 b2.n1 b2.t0 44.8554
R82 b2.n0 b2.t1 30.7964
R83 b2 b2.n1 27.8105
R84 b2.n1 b2.n0 23.4005
R85 vq3 vq3.n0 46.2005
R86 vq3.n0 vq3.t1 22.347
R87 vq3.n2 vq3.n1 18.3321
R88 vq3.n2 vq3.t0 16.1042
R89 vq3.n1 vq3.t2 13.5475
R90 vq3 vq3.n2 13.1253
R91 vq3.n1 vq3.n0 4.5005
R92 b6 b6.n1 46.0805
R93 b6.n1 b6.t0 44.9115
R94 b6.n0 b6.t2 44.5322
R95 b6.n0 b6.t1 42.8627
R96 b6.n1 b6.n0 11.8355
R97 b5.n0 b5.t1 63.7544
R98 b5.n0 b5.t2 49.1564
R99 b5.n1 b5.t0 45.1489
R100 b5 b5.n1 37.0805
R101 b5.n1 b5.n0 6.2105
R102 b0.n0 b0.t3 557.883
R103 b0.n0 b0.t2 547.923
R104 b0.n1 b0.t1 44.9587
R105 b0 b0.n2 44.2355
R106 b0.n2 b0.t0 37.0514
R107 b0.n1 b0.n0 19.4405
R108 b0.n2 b0.n1 8.9555
R109 b4.n0 b4.t2 109.124
R110 b4.n1 b4.t0 49.3969
R111 b4 b4.n1 41.0855
R112 b4.n0 b4.t1 35.1074
R113 b4.n1 b4.n0 25.2455
R114 b3.n0 b3.t2 178.858
R115 b3.n1 b3.t0 44.8894
R116 b3 b3.n1 38.0705
R117 b3.n0 b3.t1 37.0593
R118 b3.n1 b3.n0 17.2355
R119 avdd.n721 avdd.t989 770.606
R120 avdd.n500 avdd.t931 650.385
R121 avdd.n499 avdd.t1011 643.567
R122 avdd.n452 avdd.t87 577.881
R123 avdd.n607 avdd.t91 576.716
R124 avdd.n497 avdd.t1009 243.613
R125 avdd.n462 avdd.t1007 197.117
R126 avdd.n460 avdd.t901 192.661
R127 avdd.n464 avdd.t1013 192.607
R128 avdd.n603 avdd.t917 133.873
R129 avdd.n603 avdd.t919 131.543
R130 avdd.n429 avdd.t968 130.758
R131 avdd.n560 avdd.t957 130.758
R132 avdd.n564 avdd.t6 129.882
R133 avdd.n840 avdd.t933 129.881
R134 avdd.n428 avdd.t1023 129.875
R135 avdd.n866 avdd.t893 128.982
R136 avdd.n864 avdd.t1032 128.982
R137 avdd.n862 avdd.t907 128.982
R138 avdd.n860 avdd.t1045 128.982
R139 avdd.n841 avdd.t89 128.982
R140 avdd.n845 avdd.t46 128.982
R141 avdd.n429 avdd.t967 128.059
R142 avdd.n430 avdd.t973 128.059
R143 avdd.n431 avdd.t1043 128.059
R144 avdd.n558 avdd.t970 128.059
R145 avdd.n559 avdd.t974 128.059
R146 avdd.n560 avdd.t969 128.059
R147 avdd.n561 avdd.t1044 128.059
R148 avdd.n757 avdd.t50 127.987
R149 avdd.n758 avdd.t52 127.987
R150 avdd.n742 avdd.t22 127.984
R151 avdd.n745 avdd.t24 127.984
R152 avdd.n746 avdd.t60 127.984
R153 avdd.n426 avdd.t70 127.957
R154 avdd.n737 avdd.t56 127.957
R155 avdd.n423 avdd.t68 127.957
R156 avdd.n427 avdd.t54 127.957
R157 avdd.n799 avdd.t12 127.805
R158 avdd.n796 avdd.t38 127.805
R159 avdd.n795 avdd.t40 127.805
R160 avdd.n819 avdd.t891 127.763
R161 avdd.n822 avdd.t74 127.763
R162 avdd.n825 avdd.t66 127.763
R163 avdd.n594 avdd.t909 127.219
R164 avdd.n593 avdd.t911 127.178
R165 avdd.n564 avdd.t905 127.171
R166 avdd.n428 avdd.t1021 127.169
R167 avdd.n565 avdd.t903 127.165
R168 avdd.n842 avdd.t36 124.481
R169 avdd.n846 avdd.t72 124.481
R170 avdd.n835 avdd.t76 124.481
R171 avdd.n563 avdd.t972 123.558
R172 avdd.n762 avdd.t32 123.487
R173 avdd.n763 avdd.t34 123.487
R174 avdd.n755 avdd.t937 123.487
R175 avdd.n741 avdd.t20 123.484
R176 avdd.n748 avdd.t62 123.484
R177 avdd.n747 avdd.t935 123.484
R178 avdd.n422 avdd.t48 123.457
R179 avdd.n734 avdd.t18 123.457
R180 avdd.n884 avdd.t83 123.305
R181 avdd.n883 avdd.t85 123.305
R182 avdd.n800 avdd.t10 123.305
R183 avdd.n828 avdd.t79 123.263
R184 avdd.n829 avdd.t58 123.263
R185 avdd.n792 avdd.t889 123.263
R186 avdd.n723 avdd.t8 122.706
R187 avdd.n567 avdd.t81 122.701
R188 avdd.n716 avdd.t1036 122.472
R189 avdd.n512 avdd.t978 114.171
R190 avdd.n514 avdd.t980 114.171
R191 avdd.n511 avdd.t977 114.118
R192 avdd.n513 avdd.t979 114.118
R193 avdd.n515 avdd.t953 114.118
R194 avdd.n505 avdd.t955 114.09
R195 avdd.n507 avdd.t964 114.09
R196 avdd.n239 avdd.t144 112.359
R197 avdd.n241 avdd.t140 112.359
R198 avdd.n243 avdd.t136 112.359
R199 avdd.n245 avdd.t132 112.359
R200 avdd.n247 avdd.t128 112.359
R201 avdd.n249 avdd.t96 112.359
R202 avdd.n251 avdd.t180 112.359
R203 avdd.n253 avdd.t100 112.359
R204 avdd.n255 avdd.t104 112.359
R205 avdd.n257 avdd.t108 112.359
R206 avdd.n259 avdd.t112 112.359
R207 avdd.n261 avdd.t116 112.359
R208 avdd.n263 avdd.t120 112.359
R209 avdd.n265 avdd.t124 112.359
R210 avdd.n267 avdd.t184 112.359
R211 avdd.n269 avdd.t188 112.359
R212 avdd.n271 avdd.t244 112.359
R213 avdd.n272 avdd.t200 112.359
R214 avdd.n274 avdd.t204 112.359
R215 avdd.n276 avdd.t208 112.359
R216 avdd.n278 avdd.t212 112.359
R217 avdd.n280 avdd.t216 112.359
R218 avdd.n282 avdd.t220 112.359
R219 avdd.n284 avdd.t224 112.359
R220 avdd.n286 avdd.t228 112.359
R221 avdd.n288 avdd.t232 112.359
R222 avdd.n290 avdd.t236 112.359
R223 avdd.n292 avdd.t240 112.359
R224 avdd.n294 avdd.t248 112.359
R225 avdd.n297 avdd.t324 111.353
R226 avdd.n299 avdd.t332 111.353
R227 avdd.n301 avdd.t328 111.353
R228 avdd.n303 avdd.t348 111.353
R229 avdd.n345 avdd.t380 111.353
R230 avdd.n347 avdd.t376 111.353
R231 avdd.n349 avdd.t372 111.353
R232 avdd.n351 avdd.t368 111.353
R233 avdd.n353 avdd.t364 111.353
R234 avdd.n355 avdd.t360 111.353
R235 avdd.n357 avdd.t356 111.353
R236 avdd.n359 avdd.t352 111.353
R237 avdd.n361 avdd.t344 111.353
R238 avdd.n363 avdd.t340 111.353
R239 avdd.n365 avdd.t336 111.353
R240 avdd.n367 avdd.t320 111.353
R241 avdd.n369 avdd.t316 111.353
R242 avdd.n371 avdd.t312 111.353
R243 avdd.n373 avdd.t308 111.353
R244 avdd.n375 avdd.t304 111.353
R245 avdd.n377 avdd.t300 111.353
R246 avdd.n379 avdd.t296 111.353
R247 avdd.n381 avdd.t292 111.353
R248 avdd.n295 avdd.t252 111.156
R249 avdd.n384 avdd.t268 111.156
R250 avdd.n386 avdd.t288 111.156
R251 avdd.n388 avdd.t192 111.156
R252 avdd.n390 avdd.t256 111.156
R253 avdd.n392 avdd.t284 111.156
R254 avdd.n394 avdd.t280 111.156
R255 avdd.n396 avdd.t276 111.156
R256 avdd.n398 avdd.t272 111.156
R257 avdd.n400 avdd.t264 111.156
R258 avdd.n402 avdd.t260 111.156
R259 avdd.n404 avdd.t148 111.156
R260 avdd.n406 avdd.t152 111.156
R261 avdd.n408 avdd.t156 111.156
R262 avdd.n410 avdd.t160 111.156
R263 avdd.n412 avdd.t164 111.156
R264 avdd.n414 avdd.t168 111.156
R265 avdd.n416 avdd.t172 111.156
R266 avdd.n418 avdd.t176 111.156
R267 avdd.n420 avdd.t196 111.156
R268 avdd.n556 avdd.t1006 109.93
R269 avdd.n504 avdd.t954 109.671
R270 avdd.n506 avdd.t956 109.671
R271 avdd.n508 avdd.t965 109.671
R272 avdd.n510 avdd.t971 109.671
R273 avdd.n509 avdd.t966 109.59
R274 avdd.n305 avdd.t700 97.2026
R275 avdd.n307 avdd.t696 97.2026
R276 avdd.n309 avdd.t692 97.2026
R277 avdd.n311 avdd.t688 97.2026
R278 avdd.n313 avdd.t684 97.2026
R279 avdd.n315 avdd.t680 97.2026
R280 avdd.n317 avdd.t676 97.2026
R281 avdd.n319 avdd.t672 97.2026
R282 avdd.n321 avdd.t759 97.2026
R283 avdd.n323 avdd.t755 97.2026
R284 avdd.n325 avdd.t799 97.2026
R285 avdd.n327 avdd.t795 97.2026
R286 avdd.n329 avdd.t839 97.2026
R287 avdd.n331 avdd.t835 97.2026
R288 avdd.n333 avdd.t831 97.2026
R289 avdd.n335 avdd.t827 97.2026
R290 avdd.n337 avdd.t823 97.2026
R291 avdd.n339 avdd.t819 97.2026
R292 avdd.n341 avdd.t815 97.2026
R293 avdd.n343 avdd.t811 97.2026
R294 avdd.n703 avdd.t995 91.1774
R295 avdd.n649 avdd.t1002 91.1684
R296 avdd.n636 avdd.t1003 91.1639
R297 avdd.n606 avdd.t897 90.4027
R298 avdd.n606 avdd.t899 89.1427
R299 avdd.n543 avdd.t42 86.6822
R300 avdd.n545 avdd.t939 86.6822
R301 avdd.n547 avdd.t14 86.6822
R302 avdd.n622 avdd.t992 86.6819
R303 avdd.n621 avdd.t993 86.6819
R304 avdd.n625 avdd.t991 86.6819
R305 avdd.n702 avdd.t994 86.6774
R306 avdd.n705 avdd.t996 86.6774
R307 avdd.n655 avdd.t999 86.6729
R308 avdd.n654 avdd.t998 86.6729
R309 avdd.n647 avdd.t1000 86.6684
R310 avdd.n648 avdd.t1001 86.6684
R311 avdd.n639 avdd.t1005 86.6639
R312 avdd.n637 avdd.t1004 86.6639
R313 avdd.n542 avdd.t28 86.6372
R314 avdd.n544 avdd.t44 86.6372
R315 avdd.n546 avdd.t941 86.6372
R316 avdd.n554 avdd.t16 82.5017
R317 avdd.n652 avdd.t997 82.1099
R318 avdd.n568 avdd.t1034 81.0334
R319 avdd.n570 avdd.t1041 78.7249
R320 avdd.n569 avdd.t987 78.6979
R321 avdd.n568 avdd.t943 78.6901
R322 avdd.n571 avdd.t913 78.6801
R323 avdd.n483 avdd.t951 78.1708
R324 avdd.n485 avdd.t960 78.1708
R325 avdd.n467 avdd.t927 78.1393
R326 avdd.n469 avdd.t975 78.1393
R327 avdd.n482 avdd.t949 78.1258
R328 avdd.n484 avdd.t958 78.1258
R329 avdd.n466 avdd.t921 78.0538
R330 avdd.n468 avdd.t925 78.0538
R331 avdd.n470 avdd.t945 78.0538
R332 avdd.n169 avdd.t532 75.1897
R333 avdd.n171 avdd.t536 75.1897
R334 avdd.n173 avdd.t540 75.1897
R335 avdd.n175 avdd.t556 75.1897
R336 avdd.n177 avdd.t560 75.1897
R337 avdd.n179 avdd.t564 75.1897
R338 avdd.n181 avdd.t580 75.1897
R339 avdd.n183 avdd.t584 75.1897
R340 avdd.n185 avdd.t588 75.1897
R341 avdd.n187 avdd.t624 75.1897
R342 avdd.n189 avdd.t620 75.1897
R343 avdd.n191 avdd.t616 75.1897
R344 avdd.n193 avdd.t612 75.1897
R345 avdd.n195 avdd.t608 75.1897
R346 avdd.n197 avdd.t604 75.1897
R347 avdd.n199 avdd.t600 75.1897
R348 avdd.n201 avdd.t576 75.1897
R349 avdd.n203 avdd.t552 75.1897
R350 avdd.n205 avdd.t528 75.1897
R351 avdd.n207 avdd.t424 75.1897
R352 avdd.n208 avdd.t384 75.1897
R353 avdd.n210 avdd.t388 75.1897
R354 avdd.n212 avdd.t392 75.1897
R355 avdd.n214 avdd.t396 75.1897
R356 avdd.n216 avdd.t400 75.1897
R357 avdd.n218 avdd.t404 75.1897
R358 avdd.n220 avdd.t408 75.1897
R359 avdd.n222 avdd.t420 75.1897
R360 avdd.n224 avdd.t416 75.1897
R361 avdd.n226 avdd.t412 75.1897
R362 avdd.n228 avdd.t428 75.1897
R363 avdd.n230 avdd.t432 75.1897
R364 avdd.n232 avdd.t436 75.1897
R365 avdd.n234 avdd.t440 75.1897
R366 avdd.n579 avdd.t915 74.1829
R367 avdd.n481 avdd.t947 73.6708
R368 avdd.n465 avdd.t923 73.6393
R369 avdd.n487 avdd.t962 73.6258
R370 avdd.n670 avdd.t1016 65.0235
R371 avdd.n671 avdd.t1018 65.0235
R372 avdd.n672 avdd.t0 65.0235
R373 avdd.n674 avdd.t4 65.0235
R374 avdd.n642 avdd.t93 64.9965
R375 avdd.n643 avdd.t30 64.9965
R376 avdd.n645 avdd.t1047 64.9965
R377 avdd.n646 avdd.t1014 64.9965
R378 avdd.n662 avdd.t983 64.9965
R379 avdd.n663 avdd.t985 64.9965
R380 avdd.n664 avdd.t883 64.9965
R381 avdd.n666 avdd.t887 64.9965
R382 avdd.n99 avdd.t879 61.7045
R383 avdd.n101 avdd.t875 61.7045
R384 avdd.n103 avdd.t871 61.7045
R385 avdd.n105 avdd.t867 61.7045
R386 avdd.n107 avdd.t863 61.7045
R387 avdd.n109 avdd.t859 61.7045
R388 avdd.n111 avdd.t855 61.7045
R389 avdd.n113 avdd.t851 61.7045
R390 avdd.n115 avdd.t803 61.7045
R391 avdd.n117 avdd.t791 61.7045
R392 avdd.n119 avdd.t787 61.7045
R393 avdd.n121 avdd.t783 61.7045
R394 avdd.n123 avdd.t763 61.7045
R395 avdd.n125 avdd.t767 61.7045
R396 avdd.n127 avdd.t771 61.7045
R397 avdd.n129 avdd.t775 61.7045
R398 avdd.n131 avdd.t779 61.7045
R399 avdd.n133 avdd.t807 61.7045
R400 avdd.n135 avdd.t847 61.7045
R401 avdd.n137 avdd.t843 61.7045
R402 avdd.n572 avdd.t78 61.092
R403 avdd.n673 avdd.t2 60.5235
R404 avdd.n675 avdd.t981 60.5235
R405 avdd.n641 avdd.t1030 60.4965
R406 avdd.n644 avdd.t1038 60.4965
R407 avdd.n665 avdd.t885 60.4965
R408 avdd.n667 avdd.t895 60.4965
R409 avdd.n537 avdd.t703 51.8176
R410 avdd.n29 avdd.t468 49.1947
R411 avdd.n31 avdd.t464 49.1947
R412 avdd.n33 avdd.t460 49.1947
R413 avdd.n35 avdd.t456 49.1947
R414 avdd.n37 avdd.t452 49.1947
R415 avdd.n39 avdd.t448 49.1947
R416 avdd.n41 avdd.t656 49.1947
R417 avdd.n43 avdd.t652 49.1947
R418 avdd.n45 avdd.t648 49.1947
R419 avdd.n47 avdd.t644 49.1947
R420 avdd.n49 avdd.t640 49.1947
R421 avdd.n51 avdd.t636 49.1947
R422 avdd.n53 avdd.t632 49.1947
R423 avdd.n55 avdd.t628 49.1947
R424 avdd.n57 avdd.t592 49.1947
R425 avdd.n59 avdd.t596 49.1947
R426 avdd.n61 avdd.t568 49.1947
R427 avdd.n63 avdd.t572 49.1947
R428 avdd.n65 avdd.t548 49.1947
R429 avdd.n67 avdd.t544 49.1947
R430 avdd.n69 avdd.t444 49.1947
R431 avdd.n71 avdd.t472 49.1947
R432 avdd.n525 avdd.t1029 45.3932
R433 avdd.n527 avdd.t882 45.3932
R434 avdd.n531 avdd.t1026 45.3932
R435 avdd.n533 avdd.t1025 45.3932
R436 avdd.n524 avdd.t64 45.3482
R437 avdd.n526 avdd.t1028 45.3482
R438 avdd.n532 avdd.t1040 45.3482
R439 avdd.n534 avdd.t1020 40.8482
R440 avdd.n530 avdd.t1027 40.8482
R441 avdd.n528 avdd.t65 40.8482
R442 avdd.n716 avdd.n715 35.8513
R443 avdd.n580 avdd.n579 32.8055
R444 avdd.n540 avdd.t929 30.8624
R445 avdd.n541 avdd.t26 30.8309
R446 avdd.n503 avdd.n502 30.5105
R447 avdd.n502 avdd.t932 27.5722
R448 avdd.n752 avdd.t936 25.6018
R449 avdd.n74 avdd.t524 25.5994
R450 avdd.n76 avdd.t520 25.5994
R451 avdd.n78 avdd.t516 25.5994
R452 avdd.n80 avdd.t512 25.5994
R453 avdd.n82 avdd.t508 25.5994
R454 avdd.n84 avdd.t504 25.5994
R455 avdd.n86 avdd.t500 25.5994
R456 avdd.n88 avdd.t496 25.5994
R457 avdd.n90 avdd.t492 25.5994
R458 avdd.n92 avdd.t488 25.5994
R459 avdd.n94 avdd.t484 25.5994
R460 avdd.n96 avdd.t480 25.5994
R461 avdd.n98 avdd.t476 25.5994
R462 avdd.t705 avdd.t704 25.5994
R463 avdd.n140 avdd.t660 25.5994
R464 avdd.n142 avdd.t664 25.5994
R465 avdd.n144 avdd.t668 25.5994
R466 avdd.n146 avdd.t751 25.5994
R467 avdd.n148 avdd.t747 25.5994
R468 avdd.n150 avdd.t743 25.5994
R469 avdd.n152 avdd.t739 25.5994
R470 avdd.n154 avdd.t735 25.5994
R471 avdd.n156 avdd.t731 25.5994
R472 avdd.n158 avdd.t727 25.5994
R473 avdd.n160 avdd.t723 25.5994
R474 avdd.n162 avdd.t719 25.5994
R475 avdd.n164 avdd.t715 25.5994
R476 avdd.n166 avdd.t711 25.5994
R477 avdd.n168 avdd.t707 25.5994
R478 avdd.n722 avdd.t9 25.1177
R479 avdd.n720 avdd.t990 22.7703
R480 avdd.n500 avdd.t1012 22.3718
R481 avdd.n424 avdd.t49 21.2629
R482 avdd.n843 avdd.t90 21.2414
R483 avdd.n743 avdd.t21 21.2292
R484 avdd.n759 avdd.t51 21.228
R485 avdd.n797 avdd.t11 21.2278
R486 avdd.n776 avdd.t75 21.2278
R487 avdd.n820 avdd.t890 21.2278
R488 avdd.n602 avdd.t1037 21.1901
R489 avdd.n735 avdd.t19 21.0905
R490 avdd.n577 avdd.t916 20.6195
R491 avdd.n488 avdd.t924 20.5509
R492 avdd.n476 avdd.t948 20.4699
R493 avdd.n766 avdd.t33 20.418
R494 avdd.n783 avdd.t80 20.4178
R495 avdd.n480 avdd.t963 20.3797
R496 avdd.n595 avdd.t912 20.0552
R497 avdd.n433 avdd.t27 19.6327
R498 avdd.n607 avdd.t92 19.221
R499 avdd.n498 avdd.t1010 18.206
R500 avdd.n452 avdd.t88 17.9225
R501 avdd.n617 avdd.t423 16.7137
R502 avdd.n751 avdd.t25 16.5942
R503 avdd.n863 avdd.t1033 16.3364
R504 avdd.n865 avdd.t894 16.2991
R505 avdd.n861 avdd.t908 16.2991
R506 avdd.n840 avdd.t934 16.2541
R507 avdd.n461 avdd.t902 16.147
R508 avdd.n756 avdd.t938 16.0773
R509 avdd.n740 avdd.t71 16.0429
R510 avdd.n824 avdd.t39 16.0078
R511 avdd.n434 avdd.n433 15.7955
R512 avdd.n548 avdd.t29 15.7386
R513 avdd.n848 avdd.t47 15.7064
R514 avdd.n641 avdd.n60 16.4217
R515 avdd.n630 avdd.n42 16.3879
R516 avdd.n566 avdd.n563 14.9855
R517 avdd.n857 avdd.t77 14.6341
R518 avdd.n557 avdd.n556 14.5355
R519 avdd.n726 avdd.t1024 14.4932
R520 avdd.n608 avdd.t898 14.3338
R521 avdd.n610 avdd.t900 13.9738
R522 avdd.n752 avdd.t63 13.9392
R523 avdd.n881 avdd.t86 13.9249
R524 avdd.n782 avdd.t59 13.9249
R525 avdd.n765 avdd.t35 13.9173
R526 avdd.n849 avdd.t73 13.9141
R527 avdd.n601 avdd.t82 13.9127
R528 avdd.n719 avdd.t918 13.8808
R529 avdd.n548 avdd.t43 13.8021
R530 avdd.n550 avdd.t940 13.8021
R531 avdd.n553 avdd.t15 13.8021
R532 avdd.n549 avdd.t45 13.7586
R533 avdd.n597 avdd.t7 13.7532
R534 avdd.n575 avdd.t1042 13.7364
R535 avdd.n479 avdd.t959 13.7197
R536 avdd.n572 avdd.t1035 13.7094
R537 avdd.n573 avdd.t944 13.6877
R538 avdd.n574 avdd.t988 13.6795
R539 avdd.n720 avdd.n719 12.8255
R540 avdd.n593 avdd.n592 12.7805
R541 avdd.n880 avdd.t84 12.0928
R542 avdd.n825 avdd.n824 12.0605
R543 avdd.n761 avdd.n753 11.9705
R544 avdd.n746 avdd.n740 11.9705
R545 avdd.n599 avdd.n598 11.9705
R546 avdd.n608 avdd.n607 11.7905
R547 avdd.n509 avdd.n508 11.7005
R548 avdd.n23 avdd.n521 11.6105
R549 avdd.n648 avdd.n647 11.6105
R550 avdd.n464 avdd.n463 11.4305
R551 avdd.n463 avdd.t1008 11.287
R552 avdd.n490 avdd.n489 11.2505
R553 avdd.n496 avdd.n495 11.1605
R554 avdd.n529 avdd.n141 12.1654
R555 avdd.n489 avdd.n488 11.0705
R556 avdd.n491 avdd.n490 11.0255
R557 avdd.n670 avdd.n64 11.9434
R558 avdd.n662 avdd.n66 11.9292
R559 avdd.n702 avdd.n12 10.8005
R560 avdd.n622 avdd.n621 10.8005
R561 avdd.n654 avdd.n653 10.7555
R562 avdd.n496 avdd.n464 10.7105
R563 avdd.n698 avdd.n697 10.7105
R564 avdd.n708 avdd.n707 10.6824
R565 avdd.n685 avdd.t1031 10.0857
R566 avdd.n676 avdd.t1017 10.0857
R567 avdd.n657 avdd.t984 10.0857
R568 avdd.n562 avdd.n559 9.9005
R569 avdd.n685 avdd.t94 9.79773
R570 avdd.n686 avdd.t31 9.79773
R571 avdd.n687 avdd.t1039 9.79773
R572 avdd.n688 avdd.t1048 9.79773
R573 avdd.n689 avdd.t1015 9.79773
R574 avdd.n676 avdd.t1019 9.79773
R575 avdd.n677 avdd.t1 9.79773
R576 avdd.n678 avdd.t3 9.79773
R577 avdd.n679 avdd.t5 9.79773
R578 avdd.n680 avdd.t982 9.79773
R579 avdd.n657 avdd.t986 9.79773
R580 avdd.n658 avdd.t884 9.79773
R581 avdd.n659 avdd.t886 9.79773
R582 avdd.n660 avdd.t888 9.79773
R583 avdd.n661 avdd.t896 9.79773
R584 avdd.n718 avdd.n602 9.4955
R585 avdd.n735 avdd.t57 9.47292
R586 avdd.n725 avdd.t1022 9.44874
R587 avdd.n631 avdd.n46 10.5079
R588 avdd.n634 avdd.n52 10.5079
R589 avdd.n635 avdd.n54 10.5079
R590 avdd.n694 avdd.n56 10.5079
R591 avdd.n714 avdd.n30 10.4959
R592 avdd.n713 avdd.n32 10.4959
R593 avdd.n712 avdd.n34 10.4959
R594 avdd.n711 avdd.n36 10.4959
R595 avdd.n710 avdd.n38 10.4959
R596 avdd.n602 avdd.t920 9.36641
R597 avdd.n858 avdd.t1046 9.31644
R598 avdd.n599 avdd.t904 9.31374
R599 avdd.n555 avdd.t17 9.30213
R600 avdd.n489 avdd.t928 9.30085
R601 avdd.n491 avdd.t976 9.30085
R602 avdd.n424 avdd.t69 9.30055
R603 avdd.n739 avdd.t55 9.30055
R604 avdd.n843 avdd.t37 9.27907
R605 avdd.n488 avdd.t922 9.27568
R606 avdd.n490 avdd.t926 9.27568
R607 avdd.n493 avdd.t946 9.27568
R608 avdd.n598 avdd.t906 9.27324
R609 avdd.n743 avdd.t23 9.2668
R610 avdd.n750 avdd.t61 9.2668
R611 avdd.n478 avdd.t952 9.26485
R612 avdd.n480 avdd.t961 9.26485
R613 avdd.n551 avdd.t942 9.25863
R614 avdd.n596 avdd.t910 9.24726
R615 avdd.n797 avdd.t13 9.24493
R616 avdd.n776 avdd.t67 9.24493
R617 avdd.n820 avdd.t892 9.24493
R618 avdd.n823 avdd.t41 9.24493
R619 avdd.n759 avdd.t53 9.2373
R620 avdd.n476 avdd.t950 9.21968
R621 avdd.n773 avdd.n16 9.20563
R622 avdd.n576 avdd.t914 9.17845
R623 avdd.n805 avdd.n802 9.16095
R624 avdd.n807 avdd.n806 9.15963
R625 avdd.n809 avdd.n808 9.15963
R626 avdd.n812 avdd.n811 9.1294
R627 avdd.n810 avdd.n804 9.12895
R628 avdd.n433 avdd.t930 9.11234
R629 avdd.n794 avdd.n793 9.0805
R630 avdd.n834 avdd.n833 9.0805
R631 avdd.n815 avdd.n801 9.0805
R632 avdd.n786 avdd.n781 9.07055
R633 avdd.n788 avdd.n780 9.03338
R634 avdd.n785 avdd.n18 9.02607
R635 avdd.n832 avdd.n831 9.0045
R636 avdd.n236 avdd.n17 9.00058
R637 avdd.n790 avdd.n789 9.00054
R638 avdd.n0 avdd.n1 3.97661
R639 avdd.n529 avdd.n528 8.7305
R640 avdd.n21 avdd.n726 8.645
R641 avdd.n639 avdd.n638 8.56623
R642 avdd.n647 avdd.n628 8.43261
R643 avdd.n492 avdd.n487 7.7855
R644 avdd.n722 avdd.n721 7.7405
R645 avdd.n578 avdd.n577 7.6955
R646 avdd.n510 avdd.n326 8.6404
R647 avdd.n499 avdd.n498 7.5155
R648 avdd.n598 avdd.n597 7.4705
R649 avdd.n800 avdd.n799 7.3805
R650 avdd.n842 avdd.n841 7.3805
R651 avdd.n742 avdd.n741 7.3805
R652 avdd.n423 avdd.n422 7.3805
R653 avdd.n597 avdd.n596 7.3805
R654 avdd.n554 avdd.n553 7.3805
R655 avdd.n508 avdd.n507 7.3805
R656 avdd.n506 avdd.n505 7.3805
R657 avdd.n846 avdd.n252 8.47876
R658 avdd.n835 avdd.n268 8.47876
R659 avdd.n741 avdd.n364 8.47556
R660 avdd.n747 avdd.n366 8.47556
R661 avdd.n422 avdd.n304 8.46431
R662 avdd.n516 avdd.n330 8.4604
R663 avdd.n754 avdd.n300 8.45156
R664 avdd.n767 avdd.n368 8.45156
R665 avdd.n868 avdd.n273 8.45101
R666 avdd.n445 avdd.n306 8.43415
R667 avdd.n836 avdd.n240 8.43001
R668 avdd.n727 avdd.n346 8.40806
R669 avdd.n857 avdd.n19 7.2275
R670 avdd.n507 avdd.n506 7.2005
R671 avdd.n505 avdd.n504 7.2005
R672 avdd.n511 avdd.n510 7.2005
R673 avdd.n850 avdd.n849 7.1555
R674 avdd.n600 avdd.n567 7.1555
R675 avdd.n486 avdd.n480 7.1555
R676 avdd.n28 avdd.n515 7.1555
R677 avdd.n859 avdd.n858 7.0205
R678 avdd.n844 avdd.n843 7.0205
R679 avdd.n750 avdd.n749 7.0205
R680 avdd.n739 avdd.n738 7.0205
R681 avdd.n425 avdd.n424 7.0205
R682 avdd.n566 avdd.n565 7.0205
R683 avdd.n562 avdd.n561 7.0205
R684 avdd.n494 avdd.n493 7.0205
R685 avdd.n744 avdd.n743 7.0205
R686 avdd.n576 avdd.n575 6.8855
R687 avdd.n798 avdd.n797 6.8405
R688 avdd.n823 avdd.n774 6.8405
R689 avdd.n760 avdd.n759 6.8405
R690 avdd.n540 avdd.n539 6.8405
R691 avdd.n777 avdd.n776 6.8405
R692 avdd.n821 avdd.n820 6.8405
R693 avdd.n736 avdd.n735 6.7955
R694 avdd.n595 avdd.n594 6.7955
R695 avdd.n501 avdd.n452 6.7505
R696 avdd.n551 avdd.n550 6.7505
R697 avdd.n465 avdd.n136 7.79564
R698 avdd.n481 avdd.n134 7.77614
R699 avdd.n882 avdd.n881 6.6605
R700 avdd.n765 avdd.n764 6.6605
R701 avdd.n479 avdd.n478 6.6605
R702 avdd.n726 avdd.n725 6.6155
R703 avdd.n725 avdd.n724 6.6155
R704 avdd.n487 avdd.n116 7.68614
R705 avdd.n858 avdd.n857 6.5705
R706 avdd.n719 avdd.n718 6.5705
R707 avdd.n650 avdd.n649 6.5705
R708 avdd.n453 avdd.n100 7.61564
R709 avdd.n471 avdd.n118 7.61564
R710 avdd.n473 avdd.n124 7.61564
R711 avdd.n480 avdd.n479 6.5255
R712 avdd.n703 avdd.n702 6.5255
R713 avdd.n764 avdd.n298 7.59656
R714 avdd.n531 avdd.n530 6.4805
R715 avdd.n637 avdd.n636 6.4805
R716 avdd.n604 avdd.n209 7.57218
R717 avdd.n850 avdd.n250 7.57501
R718 avdd.n717 avdd.n716 6.40391
R719 avdd.n600 avdd.n599 6.3905
R720 avdd.n492 avdd.n491 6.3455
R721 avdd.n704 avdd.n703 6.3455
R722 avdd.n859 avdd.n835 6.3005
R723 avdd.n749 avdd.n748 6.3005
R724 avdd.n736 avdd.n734 6.3005
R725 avdd.n724 avdd.n723 6.3005
R726 avdd.n466 avdd.n465 6.3005
R727 avdd.n482 avdd.n481 6.3005
R728 avdd.n528 avdd.n527 6.3005
R729 avdd.n534 avdd.n533 6.3005
R730 avdd.n649 avdd.n648 6.3005
R731 avdd.n653 avdd.n652 6.28197
R732 avdd.n524 avdd.n523 6.27725
R733 avdd.n579 avdd.n578 6.1205
R734 avdd.n556 avdd.n555 6.0755
R735 avdd.n552 avdd.n551 6.0305
R736 avdd.n487 avdd.n486 5.9405
R737 avdd.n710 avdd.n709 5.9405
R738 avdd.n715 avdd.n714 5.9405
R739 avdd.n634 avdd.n633 5.9405
R740 avdd.n631 avdd.n630 5.9405
R741 avdd.n645 avdd.n644 5.9405
R742 avdd.n644 avdd.n643 5.9405
R743 avdd.n642 avdd.n641 5.9405
R744 avdd.n675 avdd.n674 5.9405
R745 avdd.n674 avdd.n673 5.9405
R746 avdd.n673 avdd.n672 5.9405
R747 avdd.n667 avdd.n666 5.9405
R748 avdd.n666 avdd.n665 5.9405
R749 avdd.n665 avdd.n664 5.9405
R750 avdd.n495 avdd.n494 5.7605
R751 avdd.n500 avdd.n499 5.6705
R752 avdd.n723 avdd.n722 5.5805
R753 avdd.n721 avdd.n720 5.5805
R754 avdd.n73 avdd.t523 52.1219
R755 avdd.n75 avdd.t519 52.1219
R756 avdd.n77 avdd.t515 52.1219
R757 avdd.n79 avdd.t511 52.1219
R758 avdd.n81 avdd.t507 52.1219
R759 avdd.n83 avdd.t503 52.1219
R760 avdd.n85 avdd.t499 52.1219
R761 avdd.n87 avdd.t495 52.1219
R762 avdd.n89 avdd.t491 52.1219
R763 avdd.n91 avdd.t487 52.1219
R764 avdd.n93 avdd.t483 52.1219
R765 avdd.n95 avdd.t479 52.1219
R766 avdd.n97 avdd.t475 52.1219
R767 avdd.n139 avdd.t659 52.1219
R768 avdd.n141 avdd.t663 52.1219
R769 avdd.n143 avdd.t667 52.1219
R770 avdd.n145 avdd.t750 52.1219
R771 avdd.n147 avdd.t746 52.1219
R772 avdd.n149 avdd.t742 52.1219
R773 avdd.n151 avdd.t738 52.1219
R774 avdd.n153 avdd.t734 52.1219
R775 avdd.n155 avdd.t730 52.1219
R776 avdd.n157 avdd.t726 52.1219
R777 avdd.n159 avdd.t722 52.1219
R778 avdd.n161 avdd.t718 52.1219
R779 avdd.n163 avdd.t714 52.1219
R780 avdd.n165 avdd.t710 52.1219
R781 avdd.n167 avdd.t706 52.1219
R782 avdd.n844 avdd.n842 5.4005
R783 avdd.n756 avdd.n755 5.4005
R784 avdd.n463 avdd.n462 5.3555
R785 avdd.n824 avdd.n823 5.2205
R786 avdd.n783 avdd.n782 5.2205
R787 avdd.n766 avdd.n765 5.2205
R788 avdd.n740 avdd.n739 5.2205
R789 avdd.n501 avdd.n500 5.2205
R790 avdd.n536 avdd.n535 5.10463
R791 avdd.n580 avdd.n73 6.09043
R792 avdd.n581 avdd.n75 6.09043
R793 avdd.n582 avdd.n77 6.09043
R794 avdd.n583 avdd.n79 6.09043
R795 avdd.n584 avdd.n81 6.09043
R796 avdd.n585 avdd.n83 6.09043
R797 avdd.n586 avdd.n85 6.09043
R798 avdd.n587 avdd.n87 6.09043
R799 avdd.n588 avdd.n89 6.09043
R800 avdd.n589 avdd.n91 6.09043
R801 avdd.n590 avdd.n93 6.09043
R802 avdd.n591 avdd.n95 6.09043
R803 avdd.n592 avdd.n97 6.09043
R804 avdd.n539 avdd.n538 5.04078
R805 avdd.n535 avdd.n139 6.09043
R806 avdd.n523 avdd.n143 6.09043
R807 avdd.n22 avdd.n145 6.09043
R808 avdd.n444 avdd.n147 6.09043
R809 avdd.n443 avdd.n149 6.09043
R810 avdd.n442 avdd.n151 6.09043
R811 avdd.n441 avdd.n153 6.09043
R812 avdd.n440 avdd.n155 6.09043
R813 avdd.n439 avdd.n157 6.09043
R814 avdd.n438 avdd.n159 6.09043
R815 avdd.n437 avdd.n161 6.09043
R816 avdd.n436 avdd.n163 6.09043
R817 avdd.n435 avdd.n165 6.09043
R818 avdd.n432 avdd.n167 6.09043
R819 avdd.n652 avdd.n627 5.01107
R820 avdd.n461 avdd.n460 4.9955
R821 avdd.n530 avdd.n529 4.9955
R822 avdd.n615 avdd.n614 4.99282
R823 avdd.n867 avdd.n866 4.951
R824 avdd.n695 avdd.n694 4.947
R825 avdd.n632 avdd.n48 6.00191
R826 avdd.n709 avdd.n40 5.99592
R827 avdd.n708 avdd.n70 5.99592
R828 avdd.n715 avdd.n72 5.99592
R829 avdd.n630 avdd.n44 5.99442
R830 avdd.n633 avdd.n50 5.99442
R831 avdd.n691 avdd.n58 5.98167
R832 avdd.n11 avdd.n62 5.97942
R833 avdd.n24 avdd.n68 5.97942
R834 avdd.n497 avdd.n496 4.8605
R835 avdd.n493 avdd.n492 4.8605
R836 avdd.n717 avdd.n603 4.8605
R837 avdd.n615 avdd.n611 4.8438
R838 avdd.n453 avdd.n102 5.90564
R839 avdd.n454 avdd.n104 5.90564
R840 avdd.n455 avdd.n106 5.90564
R841 avdd.n456 avdd.n108 5.90564
R842 avdd.n457 avdd.n110 5.90564
R843 avdd.n458 avdd.n112 5.90564
R844 avdd.n459 avdd.n114 5.90564
R845 avdd.n471 avdd.n120 5.90564
R846 avdd.n472 avdd.n122 5.90564
R847 avdd.n473 avdd.n126 5.90564
R848 avdd.n474 avdd.n128 5.90564
R849 avdd.n475 avdd.n130 5.90564
R850 avdd.n8 avdd.n132 5.90564
R851 avdd.n495 avdd.n138 5.90564
R852 avdd.n614 avdd.n221 5.90718
R853 avdd.n626 avdd.n227 5.90568
R854 avdd.n886 avdd.n385 1.57786
R855 avdd.n5 avdd.t243 9.45728
R856 avdd.n6 avdd.t247 9.45728
R857 avdd.n695 avdd.n188 5.88863
R858 avdd.n627 avdd.n170 5.88168
R859 avdd.n653 avdd.n172 5.88168
R860 avdd.n656 avdd.n174 5.88168
R861 avdd.n628 avdd.n176 5.88168
R862 avdd.n650 avdd.n178 5.88168
R863 avdd.n651 avdd.n180 5.88168
R864 avdd.n629 avdd.n182 5.88168
R865 avdd.n638 avdd.n184 5.88168
R866 avdd.n640 avdd.n186 5.88168
R867 avdd.n696 avdd.n190 5.88168
R868 avdd.n697 avdd.n192 5.88168
R869 avdd.n698 avdd.n194 5.88168
R870 avdd.n699 avdd.n196 5.88168
R871 avdd.n700 avdd.n198 5.88168
R872 avdd.n701 avdd.n200 5.88168
R873 avdd.n15 avdd.n202 5.88168
R874 avdd.n14 avdd.n204 5.88168
R875 avdd.n13 avdd.n206 5.88168
R876 avdd.n619 avdd.n618 4.78705
R877 avdd.n604 avdd.n211 5.88168
R878 avdd.n605 avdd.n213 5.88168
R879 avdd.n26 avdd.n215 5.88168
R880 avdd.n612 avdd.n217 5.88168
R881 avdd.n613 avdd.n219 5.88168
R882 avdd.n620 avdd.n223 5.88168
R883 avdd.n624 avdd.n225 5.88168
R884 avdd.n12 avdd.n229 5.88168
R885 avdd.n704 avdd.n231 5.88168
R886 avdd.n706 avdd.n233 5.88168
R887 avdd.n707 avdd.n235 5.88168
R888 avdd.n451 avdd.n320 5.86915
R889 avdd.n867 avdd.n270 5.85539
R890 avdd.n733 avdd.n362 5.85431
R891 avdd.n445 avdd.n308 5.8504
R892 avdd.n446 avdd.n310 5.8504
R893 avdd.n447 avdd.n312 5.8504
R894 avdd.n448 avdd.n314 5.8504
R895 avdd.n449 avdd.n316 5.8504
R896 avdd.n450 avdd.n318 5.8504
R897 avdd.n503 avdd.n322 5.8504
R898 avdd.n9 avdd.n324 5.8504
R899 avdd.n28 avdd.n328 5.8504
R900 avdd.n516 avdd.n332 5.8504
R901 avdd.n517 avdd.n334 5.8504
R902 avdd.n518 avdd.n336 5.8504
R903 avdd.n519 avdd.n338 5.8504
R904 avdd.n520 avdd.n340 5.8504
R905 avdd.n521 avdd.n342 5.8504
R906 avdd.n23 avdd.n344 5.8504
R907 avdd.n772 avdd.n382 5.84906
R908 avdd.n834 avdd.n296 5.84167
R909 avdd.n805 avdd.n387 5.84167
R910 avdd.n831 avdd.n389 5.84167
R911 avdd.n801 avdd.n391 5.84167
R912 avdd.n811 avdd.n393 5.84167
R913 avdd.n810 avdd.n395 5.84167
R914 avdd.n809 avdd.n397 5.84167
R915 avdd.n806 avdd.n399 5.84167
R916 avdd.n890 avdd.n401 5.84167
R917 avdd.n16 avdd.n403 5.84167
R918 avdd.n784 avdd.n405 5.84167
R919 avdd.n18 avdd.n407 5.84167
R920 avdd.n17 avdd.n409 5.84167
R921 avdd.n781 avdd.n411 5.84167
R922 avdd.n780 avdd.n413 5.84167
R923 avdd.n790 avdd.n415 5.84167
R924 avdd.n791 avdd.n417 5.84167
R925 avdd.n1 avdd.n419 6.9951
R926 avdd.n793 avdd.n421 5.84167
R927 avdd.n754 avdd.n302 5.84156
R928 avdd.n727 avdd.n348 5.84156
R929 avdd.n728 avdd.n350 5.84156
R930 avdd.n729 avdd.n352 5.84156
R931 avdd.n730 avdd.n354 5.84156
R932 avdd.n21 avdd.n356 5.84156
R933 avdd.n731 avdd.n358 5.84156
R934 avdd.n732 avdd.n360 5.84156
R935 avdd.n767 avdd.n370 5.84156
R936 avdd.n768 avdd.n372 5.84156
R937 avdd.n769 avdd.n374 5.84156
R938 avdd.n770 avdd.n376 5.84156
R939 avdd.n771 avdd.n378 5.84156
R940 avdd.n20 avdd.n380 5.84156
R941 avdd.n836 avdd.n242 5.84101
R942 avdd.n837 avdd.n244 5.84101
R943 avdd.n838 avdd.n246 5.84101
R944 avdd.n839 avdd.n248 5.84101
R945 avdd.n851 avdd.n254 5.84101
R946 avdd.n852 avdd.n256 5.84101
R947 avdd.n853 avdd.n258 5.84101
R948 avdd.n854 avdd.n260 5.84101
R949 avdd.n855 avdd.n262 5.84101
R950 avdd.n856 avdd.n264 5.84101
R951 avdd.n19 avdd.n266 5.84101
R952 avdd.n868 avdd.n275 5.84101
R953 avdd.n869 avdd.n277 5.84101
R954 avdd.n870 avdd.n279 5.84101
R955 avdd.n871 avdd.n281 5.84101
R956 avdd.n872 avdd.n283 5.84101
R957 avdd.n873 avdd.n285 5.84101
R958 avdd.n874 avdd.n287 5.84101
R959 avdd.n875 avdd.n289 5.84101
R960 avdd.n876 avdd.n291 5.84101
R961 avdd.n877 avdd.n293 5.84101
R962 avdd.n751 avdd.n750 4.6355
R963 avdd.n384 avdd.n383 4.59487
R964 avdd.n4 avdd.n5 1.36007
R965 avdd.n668 avdd.n656 4.56198
R966 avdd.n683 avdd.n651 4.56161
R967 avdd.n693 avdd.n640 4.56123
R968 avdd.n4 avdd.n877 4.82916
R969 avdd.n537 avdd.n536 4.50652
R970 avdd.n617 avdd.n616 4.50652
R971 avdd.n3 avdd.n27 2.24018
R972 avdd.n888 avdd.n887 4.5005
R973 avdd.n885 avdd.n884 4.5005
R974 avdd.n792 avdd.n779 4.5005
R975 avdd.n830 avdd.n775 4.5005
R976 avdd.n881 avdd.n880 4.5005
R977 avdd.n847 avdd.n846 4.5005
R978 avdd.n7 avdd.n6 1.36007
R979 avdd.n762 avdd.n761 4.5005
R980 avdd.n25 avdd.n24 0.273405
R981 avdd.n682 avdd.n11 4.5005
R982 avdd.n692 avdd.n691 4.5005
R983 avdd.n27 avdd.n383 4.5005
R984 avdd.n887 avdd.n886 4.5005
R985 avdd.n828 avdd.n827 4.5005
R986 avdd.n623 avdd.n26 4.487
R987 avdd.n611 avdd.n610 4.37586
R988 avdd.n879 avdd.n878 4.2755
R989 avdd.n636 avdd.n629 3.93223
R990 avdd.n632 avdd.n631 3.72782
R991 avdd.n23 avdd.n22 3.2255
R992 avdd.n18 avdd.n783 3.14825
R993 avdd.n20 avdd.n766 3.11
R994 avdd.n542 avdd.n541 3.0605
R995 avdd.n477 avdd.n8 2.948
R996 avdd.n796 avdd.n795 2.8805
R997 avdd.n884 avdd.n883 2.8805
R998 avdd.n847 avdd.n845 2.8805
R999 avdd.n763 avdd.n762 2.8805
R1000 avdd.n758 avdd.n757 2.8805
R1001 avdd.n746 avdd.n745 2.8805
R1002 avdd.n427 avdd.n426 2.8805
R1003 avdd.n430 avdd.n429 2.8805
R1004 avdd.n514 avdd.n513 2.8805
R1005 avdd.n512 avdd.n511 2.8805
R1006 avdd.n561 avdd.n560 2.8805
R1007 avdd.n748 avdd.n747 2.8805
R1008 avdd.n829 avdd.n828 2.8805
R1009 avdd.n522 avdd.n9 2.8505
R1010 avdd.n722 avdd.n601 2.7905
R1011 avdd.n504 avdd.n503 2.7905
R1012 avdd.n755 avdd.n754 2.7455
R1013 avdd.n825 avdd.n822 2.7005
R1014 avdd.n819 avdd.n779 2.7005
R1015 avdd.n594 avdd.n593 2.7005
R1016 avdd.n559 avdd.n558 2.7005
R1017 avdd.n431 avdd.n430 2.7005
R1018 avdd.n9 avdd.n509 2.7005
R1019 avdd.n515 avdd.n514 2.7005
R1020 avdd.n513 avdd.n512 2.7005
R1021 avdd.n565 avdd.n564 2.7005
R1022 avdd.n793 avdd.n792 2.6555
R1023 avdd.n801 avdd.n800 2.6555
R1024 avdd.n791 avdd.n1 1.13051
R1025 avdd.n791 avdd.n790 2.6105
R1026 avdd.n790 avdd.n780 2.6105
R1027 avdd.n781 avdd.n780 2.6105
R1028 avdd.n17 avdd.n781 2.6105
R1029 avdd.n18 avdd.n17 2.6105
R1030 avdd.n19 avdd.n839 2.6105
R1031 avdd.n839 avdd.n838 2.6105
R1032 avdd.n838 avdd.n837 2.6105
R1033 avdd.n837 avdd.n836 2.6105
R1034 avdd.n856 avdd.n855 2.6105
R1035 avdd.n855 avdd.n854 2.6105
R1036 avdd.n854 avdd.n853 2.6105
R1037 avdd.n853 avdd.n852 2.6105
R1038 avdd.n852 avdd.n851 2.6105
R1039 avdd.n848 avdd.n847 2.6105
R1040 avdd.n877 avdd.n876 2.6105
R1041 avdd.n876 avdd.n875 2.6105
R1042 avdd.n875 avdd.n874 2.6105
R1043 avdd.n874 avdd.n873 2.6105
R1044 avdd.n873 avdd.n872 2.6105
R1045 avdd.n872 avdd.n871 2.6105
R1046 avdd.n871 avdd.n870 2.6105
R1047 avdd.n870 avdd.n869 2.6105
R1048 avdd.n869 avdd.n868 2.6105
R1049 avdd.n734 avdd.n733 2.6105
R1050 avdd.n731 avdd.n21 2.6105
R1051 avdd.n450 avdd.n449 2.6105
R1052 avdd.n449 avdd.n448 2.6105
R1053 avdd.n448 avdd.n447 2.6105
R1054 avdd.n447 avdd.n446 2.6105
R1055 avdd.n446 avdd.n445 2.6105
R1056 avdd.n521 avdd.n520 2.6105
R1057 avdd.n520 avdd.n519 2.6105
R1058 avdd.n519 avdd.n518 2.6105
R1059 avdd.n518 avdd.n517 2.6105
R1060 avdd.n517 avdd.n516 2.6105
R1061 avdd.n730 avdd.n729 2.6105
R1062 avdd.n729 avdd.n728 2.6105
R1063 avdd.n728 avdd.n727 2.6105
R1064 avdd.n20 avdd.n771 2.6105
R1065 avdd.n771 avdd.n770 2.6105
R1066 avdd.n770 avdd.n769 2.6105
R1067 avdd.n769 avdd.n768 2.6105
R1068 avdd.n768 avdd.n767 2.6105
R1069 avdd.n27 avdd.n890 2.6105
R1070 avdd.n809 avdd.n806 2.6105
R1071 avdd.n810 avdd.n809 2.6105
R1072 avdd.n811 avdd.n810 2.6105
R1073 avdd.n806 avdd.n27 2.5955
R1074 avdd.n811 avdd.n805 2.582
R1075 avdd.n732 avdd.n731 2.567
R1076 avdd.n451 avdd.n450 2.5655
R1077 avdd.n890 avdd.n16 2.5655
R1078 avdd.n575 avdd.n574 2.5205
R1079 avdd.n574 avdd.n573 2.5205
R1080 avdd.n573 avdd.n572 2.5205
R1081 avdd.n571 avdd.n570 2.3405
R1082 avdd.n569 avdd.n568 2.3405
R1083 avdd.n555 avdd.n554 2.2955
R1084 avdd.n271 avdd.n5 0.0210888
R1085 avdd.n6 avdd.n294 0.0210888
R1086 avdd.n385 avdd.n384 0.028787
R1087 avdd.n570 avdd.n569 2.1605
R1088 avdd.n549 avdd.n548 2.1605
R1089 avdd.n460 avdd.n459 2.1155
R1090 avdd.n782 avdd.n775 2.0705
R1091 avdd.n753 avdd.n751 1.9805
R1092 avdd.n558 avdd.n557 1.9805
R1093 avdd.n547 avdd.n546 1.9805
R1094 avdd.n545 avdd.n544 1.9805
R1095 avdd.n543 avdd.n542 1.9805
R1096 avdd.n469 avdd.n468 1.9805
R1097 avdd.n467 avdd.n466 1.9805
R1098 avdd.n485 avdd.n484 1.9805
R1099 avdd.n483 avdd.n482 1.9805
R1100 avdd.n527 avdd.n526 1.9805
R1101 avdd.n525 avdd.n524 1.9805
R1102 avdd.n533 avdd.n532 1.9805
R1103 avdd.n550 avdd.n549 1.9805
R1104 avdd.n655 avdd.n654 1.96817
R1105 avdd.n624 avdd.n623 1.9355
R1106 avdd.n552 avdd.n547 1.8905
R1107 avdd.n706 avdd.n705 1.8455
R1108 avdd.n621 avdd.n620 1.8455
R1109 avdd.n885 avdd.n774 1.8005
R1110 avdd.n798 avdd.n796 1.8005
R1111 avdd.n861 avdd.n860 1.8005
R1112 avdd.n863 avdd.n862 1.8005
R1113 avdd.n865 avdd.n864 1.8005
R1114 avdd.n845 avdd.n844 1.8005
R1115 avdd.n841 avdd.n840 1.8005
R1116 avdd.n761 avdd.n760 1.8005
R1117 avdd.n757 avdd.n756 1.8005
R1118 avdd.n745 avdd.n744 1.8005
R1119 avdd.n738 avdd.n737 1.8005
R1120 avdd.n426 avdd.n425 1.8005
R1121 avdd.n546 avdd.n545 1.8005
R1122 avdd.n544 avdd.n543 1.8005
R1123 avdd.n470 avdd.n469 1.8005
R1124 avdd.n468 avdd.n467 1.8005
R1125 avdd.n484 avdd.n483 1.8005
R1126 avdd.n526 avdd.n525 1.8005
R1127 avdd.n532 avdd.n531 1.8005
R1128 avdd.n626 avdd.n625 1.78817
R1129 avdd.n535 avdd.n534 1.77725
R1130 avdd.n882 avdd.n834 1.7555
R1131 avdd.n656 avdd.n655 1.7555
R1132 avdd.n640 avdd.n639 1.7555
R1133 avdd.n638 avdd.n637 1.7555
R1134 avdd.n625 avdd.n624 1.7555
R1135 avdd.n831 avdd.n830 1.7555
R1136 avdd.n705 avdd.n704 1.74317
R1137 avdd.n696 avdd.n695 1.72149
R1138 avdd.n822 avdd.n821 1.7105
R1139 avdd.n591 avdd.n590 1.7105
R1140 avdd.n590 avdd.n589 1.7105
R1141 avdd.n589 avdd.n588 1.7105
R1142 avdd.n588 avdd.n587 1.7105
R1143 avdd.n587 avdd.n586 1.7105
R1144 avdd.n586 avdd.n585 1.7105
R1145 avdd.n585 avdd.n584 1.7105
R1146 avdd.n584 avdd.n583 1.7105
R1147 avdd.n583 avdd.n582 1.7105
R1148 avdd.n582 avdd.n581 1.7105
R1149 avdd.n581 avdd.n580 1.7105
R1150 avdd.n539 avdd.n432 1.7105
R1151 avdd.n435 avdd.n432 1.7105
R1152 avdd.n436 avdd.n435 1.7105
R1153 avdd.n437 avdd.n436 1.7105
R1154 avdd.n438 avdd.n437 1.7105
R1155 avdd.n439 avdd.n438 1.7105
R1156 avdd.n440 avdd.n439 1.7105
R1157 avdd.n441 avdd.n440 1.7105
R1158 avdd.n442 avdd.n441 1.7105
R1159 avdd.n443 avdd.n442 1.7105
R1160 avdd.n444 avdd.n443 1.7105
R1161 avdd.n22 avdd.n444 1.7105
R1162 avdd.n459 avdd.n458 1.7105
R1163 avdd.n458 avdd.n457 1.7105
R1164 avdd.n457 avdd.n456 1.7105
R1165 avdd.n456 avdd.n455 1.7105
R1166 avdd.n455 avdd.n454 1.7105
R1167 avdd.n454 avdd.n453 1.7105
R1168 avdd.n477 avdd.n476 1.7105
R1169 avdd.n8 avdd.n472 1.7105
R1170 avdd.n472 avdd.n471 1.7105
R1171 avdd.n475 avdd.n474 1.7105
R1172 avdd.n474 avdd.n473 1.7105
R1173 avdd.n707 avdd.n706 1.7105
R1174 avdd.n700 avdd.n699 1.7105
R1175 avdd.n699 avdd.n698 1.7105
R1176 avdd.n697 avdd.n696 1.7105
R1177 avdd.n651 avdd.n650 1.7105
R1178 avdd.n613 avdd.n612 1.7105
R1179 avdd.n26 avdd.n605 1.7105
R1180 avdd.n605 avdd.n604 1.7105
R1181 avdd.n827 avdd.n777 1.7105
R1182 avdd.n620 avdd.n619 1.6895
R1183 avdd.n701 avdd.n700 1.682
R1184 avdd.n592 avdd.n591 1.6805
R1185 avdd.n13 avdd.n627 1.6655
R1186 avdd.n14 avdd.n628 1.6655
R1187 avdd.n15 avdd.n629 1.6655
R1188 avdd.n614 avdd.n613 1.6655
R1189 avdd.n462 avdd.n461 1.5755
R1190 avdd.n718 avdd.n717 1.5755
R1191 avdd.n502 avdd.n501 1.5305
R1192 avdd.n240 avdd.n239 0.0203415
R1193 avdd.n242 avdd.n241 0.0203415
R1194 avdd.n244 avdd.n243 0.0203415
R1195 avdd.n246 avdd.n245 0.0203415
R1196 avdd.n248 avdd.n247 0.0203415
R1197 avdd.n250 avdd.n249 0.0203415
R1198 avdd.n252 avdd.n251 0.0203415
R1199 avdd.n254 avdd.n253 0.0203415
R1200 avdd.n256 avdd.n255 0.0203415
R1201 avdd.n258 avdd.n257 0.0203415
R1202 avdd.n260 avdd.n259 0.0203415
R1203 avdd.n262 avdd.n261 0.0203415
R1204 avdd.n264 avdd.n263 0.0203415
R1205 avdd.n266 avdd.n265 0.0203415
R1206 avdd.n268 avdd.n267 0.0203415
R1207 avdd.n270 avdd.n269 0.0203415
R1208 avdd.n273 avdd.n272 0.0203415
R1209 avdd.n275 avdd.n274 0.0203415
R1210 avdd.n277 avdd.n276 0.0203415
R1211 avdd.n279 avdd.n278 0.0203415
R1212 avdd.n281 avdd.n280 0.0203415
R1213 avdd.n283 avdd.n282 0.0203415
R1214 avdd.n285 avdd.n284 0.0203415
R1215 avdd.n287 avdd.n286 0.0203415
R1216 avdd.n289 avdd.n288 0.0203415
R1217 avdd.n291 avdd.n290 0.0203415
R1218 avdd.n293 avdd.n292 0.0203415
R1219 avdd.n298 avdd.n297 0.020531
R1220 avdd.n300 avdd.n299 0.020531
R1221 avdd.n302 avdd.n301 0.020531
R1222 avdd.n304 avdd.n303 0.020531
R1223 avdd.n346 avdd.n345 0.020531
R1224 avdd.n348 avdd.n347 0.020531
R1225 avdd.n350 avdd.n349 0.020531
R1226 avdd.n352 avdd.n351 0.020531
R1227 avdd.n354 avdd.n353 0.020531
R1228 avdd.n356 avdd.n355 0.020531
R1229 avdd.n358 avdd.n357 0.020531
R1230 avdd.n360 avdd.n359 0.020531
R1231 avdd.n362 avdd.n361 0.020531
R1232 avdd.n364 avdd.n363 0.020531
R1233 avdd.n366 avdd.n365 0.020531
R1234 avdd.n368 avdd.n367 0.020531
R1235 avdd.n370 avdd.n369 0.020531
R1236 avdd.n372 avdd.n371 0.020531
R1237 avdd.n374 avdd.n373 0.020531
R1238 avdd.n376 avdd.n375 0.020531
R1239 avdd.n378 avdd.n377 0.020531
R1240 avdd.n380 avdd.n379 0.020531
R1241 avdd.n382 avdd.n381 0.020531
R1242 avdd.n296 avdd.n295 0.0205689
R1243 avdd.n387 avdd.n386 0.0205689
R1244 avdd.n389 avdd.n388 0.0205689
R1245 avdd.n391 avdd.n390 0.0205689
R1246 avdd.n393 avdd.n392 0.0205689
R1247 avdd.n395 avdd.n394 0.0205689
R1248 avdd.n397 avdd.n396 0.0205689
R1249 avdd.n399 avdd.n398 0.0205689
R1250 avdd.n401 avdd.n400 0.0205689
R1251 avdd.n403 avdd.n402 0.0205689
R1252 avdd.n405 avdd.n404 0.0205689
R1253 avdd.n407 avdd.n406 0.0205689
R1254 avdd.n409 avdd.n408 0.0205689
R1255 avdd.n411 avdd.n410 0.0205689
R1256 avdd.n413 avdd.n412 0.0205689
R1257 avdd.n415 avdd.n414 0.0205689
R1258 avdd.n417 avdd.n416 0.0205689
R1259 avdd.n419 avdd.n418 0.0205689
R1260 avdd.n421 avdd.n420 0.0205689
R1261 avdd.n306 avdd.n305 0.0236016
R1262 avdd.n308 avdd.n307 0.0236016
R1263 avdd.n310 avdd.n309 0.0236016
R1264 avdd.n312 avdd.n311 0.0236016
R1265 avdd.n314 avdd.n313 0.0236016
R1266 avdd.n316 avdd.n315 0.0236016
R1267 avdd.n318 avdd.n317 0.0236016
R1268 avdd.n320 avdd.n319 0.0236016
R1269 avdd.n322 avdd.n321 0.0236016
R1270 avdd.n324 avdd.n323 0.0236016
R1271 avdd.n326 avdd.n325 0.0236016
R1272 avdd.n328 avdd.n327 0.0236016
R1273 avdd.n330 avdd.n329 0.0236016
R1274 avdd.n332 avdd.n331 0.0236016
R1275 avdd.n334 avdd.n333 0.0236016
R1276 avdd.n336 avdd.n335 0.0236016
R1277 avdd.n338 avdd.n337 0.0236016
R1278 avdd.n340 avdd.n339 0.0236016
R1279 avdd.n342 avdd.n341 0.0236016
R1280 avdd.n344 avdd.n343 0.0236016
R1281 avdd.n668 avdd.n25 1.31496
R1282 avdd.n711 avdd.n710 1.4405
R1283 avdd.n712 avdd.n711 1.4405
R1284 avdd.n713 avdd.n712 1.4405
R1285 avdd.n714 avdd.n713 1.4405
R1286 avdd.n635 avdd.n634 1.4405
R1287 avdd.n646 avdd.n645 1.4405
R1288 avdd.n643 avdd.n642 1.4405
R1289 avdd.n672 avdd.n671 1.4405
R1290 avdd.n671 avdd.n670 1.4405
R1291 avdd.n664 avdd.n663 1.4405
R1292 avdd.n663 avdd.n662 1.4405
R1293 avdd.n170 avdd.n169 0.0282666
R1294 avdd.n172 avdd.n171 0.0282666
R1295 avdd.n174 avdd.n173 0.0282666
R1296 avdd.n176 avdd.n175 0.0282666
R1297 avdd.n178 avdd.n177 0.0282666
R1298 avdd.n180 avdd.n179 0.0282666
R1299 avdd.n182 avdd.n181 0.0282666
R1300 avdd.n184 avdd.n183 0.0282666
R1301 avdd.n186 avdd.n185 0.0282666
R1302 avdd.n188 avdd.n187 0.0282666
R1303 avdd.n190 avdd.n189 0.0282666
R1304 avdd.n192 avdd.n191 0.0282666
R1305 avdd.n194 avdd.n193 0.0282666
R1306 avdd.n196 avdd.n195 0.0282666
R1307 avdd.n198 avdd.n197 0.0282666
R1308 avdd.n200 avdd.n199 0.0282666
R1309 avdd.n202 avdd.n201 0.0282666
R1310 avdd.n204 avdd.n203 0.0282666
R1311 avdd.n206 avdd.n205 0.0282666
R1312 avdd.n618 avdd.n207 1.43481
R1313 avdd.n209 avdd.n208 0.0282666
R1314 avdd.n211 avdd.n210 0.0282666
R1315 avdd.n213 avdd.n212 0.0282666
R1316 avdd.n215 avdd.n214 0.0282666
R1317 avdd.n217 avdd.n216 0.0282666
R1318 avdd.n219 avdd.n218 0.0282666
R1319 avdd.n221 avdd.n220 0.0282666
R1320 avdd.n223 avdd.n222 0.0282666
R1321 avdd.n225 avdd.n224 0.0282666
R1322 avdd.n227 avdd.n226 0.0282666
R1323 avdd.n229 avdd.n228 0.0282666
R1324 avdd.n231 avdd.n230 0.0282666
R1325 avdd.n233 avdd.n232 0.0282666
R1326 avdd.n235 avdd.n234 0.0282666
R1327 avdd.n100 avdd.n99 0.0345514
R1328 avdd.n102 avdd.n101 0.0345514
R1329 avdd.n104 avdd.n103 0.0345514
R1330 avdd.n106 avdd.n105 0.0345514
R1331 avdd.n108 avdd.n107 0.0345514
R1332 avdd.n110 avdd.n109 0.0345514
R1333 avdd.n112 avdd.n111 0.0345514
R1334 avdd.n114 avdd.n113 0.0345514
R1335 avdd.n116 avdd.n115 0.0345514
R1336 avdd.n118 avdd.n117 0.0345514
R1337 avdd.n120 avdd.n119 0.0345514
R1338 avdd.n122 avdd.n121 0.0345514
R1339 avdd.n124 avdd.n123 0.0345514
R1340 avdd.n126 avdd.n125 0.0345514
R1341 avdd.n128 avdd.n127 0.0345514
R1342 avdd.n130 avdd.n129 0.0345514
R1343 avdd.n132 avdd.n131 0.0345514
R1344 avdd.n134 avdd.n133 0.0345514
R1345 avdd.n136 avdd.n135 0.0345514
R1346 avdd.n138 avdd.n137 0.0345514
R1347 avdd.n30 avdd.n29 0.0395454
R1348 avdd.n32 avdd.n31 0.0395454
R1349 avdd.n34 avdd.n33 0.0395454
R1350 avdd.n36 avdd.n35 0.0395454
R1351 avdd.n38 avdd.n37 0.0395454
R1352 avdd.n40 avdd.n39 0.0395454
R1353 avdd.n42 avdd.n41 0.0395454
R1354 avdd.n44 avdd.n43 0.0395454
R1355 avdd.n46 avdd.n45 0.0395454
R1356 avdd.n48 avdd.n47 0.0395454
R1357 avdd.n50 avdd.n49 0.0395454
R1358 avdd.n52 avdd.n51 0.0395454
R1359 avdd.n54 avdd.n53 0.0395454
R1360 avdd.n56 avdd.n55 0.0395454
R1361 avdd.n58 avdd.n57 0.0395454
R1362 avdd.n60 avdd.n59 0.0395454
R1363 avdd.n62 avdd.n61 0.0395454
R1364 avdd.n64 avdd.n63 0.0395454
R1365 avdd.n66 avdd.n65 0.0395454
R1366 avdd.n68 avdd.n67 0.0395454
R1367 avdd.n70 avdd.n69 0.0395454
R1368 avdd.n72 avdd.n71 0.0395454
R1369 avdd.n538 avdd.t705 1.38724
R1370 avdd.n24 avdd.n667 1.3805
R1371 avdd.n827 avdd.n826 1.3655
R1372 avdd.n11 avdd.n675 1.3505
R1373 avdd.n522 avdd.n22 1.34105
R1374 avdd.n832 avdd.n775 1.2855
R1375 avdd.n541 avdd.n540 1.2605
R1376 avdd.n633 avdd.n632 1.22379
R1377 avdd.n15 avdd.n701 1.22082
R1378 avdd.n596 avdd.n595 1.2155
R1379 avdd.n694 avdd.n635 1.2155
R1380 avdd.n692 avdd.n646 1.2155
R1381 avdd.n709 avdd.n708 1.1705
R1382 avdd.n623 avdd.n622 1.1705
R1383 avdd avdd.n889 1.1295
R1384 avdd.n826 avdd.n825 1.1255
R1385 avdd.n822 avdd.n778 1.1255
R1386 avdd.n819 avdd.n818 1.1255
R1387 avdd.n817 avdd.n779 1.1255
R1388 avdd.n681 avdd.n669 1.1255
R1389 avdd.n690 avdd.n684 1.1255
R1390 avdd.n860 avdd.n859 1.0805
R1391 avdd.n864 avdd.n863 1.0805
R1392 avdd.n737 avdd.n736 1.0805
R1393 avdd.n601 avdd.n600 1.0805
R1394 avdd.n733 avdd.n732 1.06944
R1395 avdd.n609 avdd.n606 0.9905
R1396 avdd.n880 avdd.n879 0.9455
R1397 avdd.n795 avdd.n774 0.9005
R1398 avdd.n799 avdd.n798 0.9005
R1399 avdd.n883 avdd.n882 0.9005
R1400 avdd.n862 avdd.n861 0.9005
R1401 avdd.n866 avdd.n865 0.9005
R1402 avdd.n849 avdd.n848 0.9005
R1403 avdd.n764 avdd.n763 0.9005
R1404 avdd.n760 avdd.n758 0.9005
R1405 avdd.n753 avdd.n752 0.9005
R1406 avdd.n749 avdd.n746 0.9005
R1407 avdd.n744 avdd.n742 0.9005
R1408 avdd.n738 avdd.n427 0.9005
R1409 avdd.n425 avdd.n423 0.9005
R1410 avdd.n724 avdd.n428 0.9005
R1411 avdd.n557 avdd.n431 0.9005
R1412 avdd.n830 avdd.n829 0.9005
R1413 avdd.n851 avdd.n850 0.8555
R1414 avdd.n821 avdd.n819 0.8105
R1415 avdd.n609 avdd.n608 0.8105
R1416 avdd.n825 avdd.n777 0.8105
R1417 avdd.n523 avdd.n522 0.725787
R1418 avdd.n578 avdd.n571 0.7205
R1419 avdd.n694 avdd.n693 0.7205
R1420 avdd.n889 avdd.n885 0.5855
R1421 avdd.n538 avdd.n434 0.551312
R1422 avdd.n494 avdd.n470 0.5405
R1423 avdd.n618 avdd.n616 0.501038
R1424 avdd.n553 avdd.n552 0.4955
R1425 avdd.n878 avdd.n867 0.47529
R1426 avdd.n878 avdd.n7 2.68284
R1427 avdd.n498 avdd.n497 0.4505
R1428 avdd.n610 avdd.n609 0.4505
R1429 avdd.n691 avdd.n690 0.411125
R1430 avdd.n536 avdd.n434 0.409662
R1431 avdd.n74 avdd.n73 0.0768096
R1432 avdd.n76 avdd.n75 0.0768096
R1433 avdd.n78 avdd.n77 0.0768096
R1434 avdd.n80 avdd.n79 0.0768096
R1435 avdd.n82 avdd.n81 0.0768096
R1436 avdd.n84 avdd.n83 0.0768096
R1437 avdd.n86 avdd.n85 0.0768096
R1438 avdd.n88 avdd.n87 0.0768096
R1439 avdd.n90 avdd.n89 0.0768096
R1440 avdd.n92 avdd.n91 0.0768096
R1441 avdd.n94 avdd.n93 0.0768096
R1442 avdd.n96 avdd.n95 0.0768096
R1443 avdd.n98 avdd.n97 0.0768096
R1444 avdd.t705 avdd.n537 0.402089
R1445 avdd.n140 avdd.n139 0.0768096
R1446 avdd.n142 avdd.n141 0.0768096
R1447 avdd.n144 avdd.n143 0.0768096
R1448 avdd.n146 avdd.n145 0.0768096
R1449 avdd.n148 avdd.n147 0.0768096
R1450 avdd.n150 avdd.n149 0.0768096
R1451 avdd.n152 avdd.n151 0.0768096
R1452 avdd.n154 avdd.n153 0.0768096
R1453 avdd.n156 avdd.n155 0.0768096
R1454 avdd.n158 avdd.n157 0.0768096
R1455 avdd.n160 avdd.n159 0.0768096
R1456 avdd.n162 avdd.n161 0.0768096
R1457 avdd.n164 avdd.n163 0.0768096
R1458 avdd.n166 avdd.n165 0.0768096
R1459 avdd.n168 avdd.n167 0.0768096
R1460 avdd.n619 avdd.n611 0.399831
R1461 avdd.n684 avdd.n683 0.398975
R1462 avdd.n669 avdd.n668 0.383225
R1463 avdd.n486 avdd.n485 0.3605
R1464 avdd.n682 avdd.n669 0.337775
R1465 avdd.n886 avdd.n383 0.326525
R1466 avdd.n692 avdd.n684 0.322025
R1467 avdd.n478 avdd.n477 0.3155
R1468 avdd.n889 avdd.n888 0.291612
R1469 avdd.n689 avdd.n688 0.2885
R1470 avdd.n688 avdd.n687 0.2885
R1471 avdd.n687 avdd.n686 0.2885
R1472 avdd.n686 avdd.n685 0.2885
R1473 avdd.n680 avdd.n679 0.2885
R1474 avdd.n679 avdd.n678 0.2885
R1475 avdd.n678 avdd.n677 0.2885
R1476 avdd.n677 avdd.n676 0.2885
R1477 avdd.n661 avdd.n660 0.2885
R1478 avdd.n660 avdd.n659 0.2885
R1479 avdd.n659 avdd.n658 0.2885
R1480 avdd.n658 avdd.n657 0.2885
R1481 avdd.n794 avdd.n0 0.284152
R1482 avdd.n169 avdd.t533 0.259912
R1483 avdd.n169 avdd.t534 0.259912
R1484 avdd.n171 avdd.t537 0.259912
R1485 avdd.n171 avdd.t538 0.259912
R1486 avdd.n173 avdd.t541 0.259912
R1487 avdd.n173 avdd.t542 0.259912
R1488 avdd.n175 avdd.t557 0.259912
R1489 avdd.n175 avdd.t558 0.259912
R1490 avdd.n177 avdd.t561 0.259912
R1491 avdd.n177 avdd.t562 0.259912
R1492 avdd.n179 avdd.t565 0.259912
R1493 avdd.n179 avdd.t566 0.259912
R1494 avdd.n181 avdd.t581 0.259912
R1495 avdd.n181 avdd.t582 0.259912
R1496 avdd.n183 avdd.t585 0.259912
R1497 avdd.n183 avdd.t586 0.259912
R1498 avdd.n185 avdd.t589 0.259912
R1499 avdd.n185 avdd.t590 0.259912
R1500 avdd.n187 avdd.t625 0.259912
R1501 avdd.n187 avdd.t626 0.259912
R1502 avdd.n189 avdd.t621 0.259912
R1503 avdd.n189 avdd.t622 0.259912
R1504 avdd.n191 avdd.t617 0.259912
R1505 avdd.n191 avdd.t618 0.259912
R1506 avdd.n193 avdd.t613 0.259912
R1507 avdd.n193 avdd.t614 0.259912
R1508 avdd.n195 avdd.t609 0.259912
R1509 avdd.n195 avdd.t610 0.259912
R1510 avdd.n197 avdd.t605 0.259912
R1511 avdd.n197 avdd.t606 0.259912
R1512 avdd.n199 avdd.t601 0.259912
R1513 avdd.n199 avdd.t602 0.259912
R1514 avdd.n201 avdd.t577 0.259912
R1515 avdd.n201 avdd.t578 0.259912
R1516 avdd.n203 avdd.t553 0.259912
R1517 avdd.n203 avdd.t554 0.259912
R1518 avdd.n205 avdd.t529 0.259912
R1519 avdd.n205 avdd.t530 0.259912
R1520 avdd.n207 avdd.t425 0.259912
R1521 avdd.n207 avdd.t426 0.259912
R1522 avdd.n208 avdd.t385 0.259912
R1523 avdd.n208 avdd.t386 0.259912
R1524 avdd.n210 avdd.t389 0.259912
R1525 avdd.n210 avdd.t390 0.259912
R1526 avdd.n212 avdd.t393 0.259912
R1527 avdd.n212 avdd.t394 0.259912
R1528 avdd.n214 avdd.t397 0.259912
R1529 avdd.n214 avdd.t398 0.259912
R1530 avdd.n216 avdd.t401 0.259912
R1531 avdd.n216 avdd.t402 0.259912
R1532 avdd.n218 avdd.t405 0.259912
R1533 avdd.n218 avdd.t406 0.259912
R1534 avdd.n220 avdd.t409 0.259912
R1535 avdd.n220 avdd.t410 0.259912
R1536 avdd.n222 avdd.t421 0.259912
R1537 avdd.n222 avdd.t422 0.259912
R1538 avdd.n224 avdd.t417 0.259912
R1539 avdd.n224 avdd.t418 0.259912
R1540 avdd.n226 avdd.t413 0.259912
R1541 avdd.n226 avdd.t414 0.259912
R1542 avdd.n228 avdd.t429 0.259912
R1543 avdd.n228 avdd.t430 0.259912
R1544 avdd.n230 avdd.t433 0.259912
R1545 avdd.n230 avdd.t434 0.259912
R1546 avdd.n232 avdd.t437 0.259912
R1547 avdd.n232 avdd.t438 0.259912
R1548 avdd.n234 avdd.t441 0.259912
R1549 avdd.n234 avdd.t442 0.259912
R1550 avdd.n29 avdd.t469 0.257728
R1551 avdd.n29 avdd.t470 0.257728
R1552 avdd.n31 avdd.t465 0.257728
R1553 avdd.n31 avdd.t466 0.257728
R1554 avdd.n33 avdd.t461 0.257728
R1555 avdd.n33 avdd.t462 0.257728
R1556 avdd.n35 avdd.t457 0.257728
R1557 avdd.n35 avdd.t458 0.257728
R1558 avdd.n37 avdd.t453 0.257728
R1559 avdd.n37 avdd.t454 0.257728
R1560 avdd.n39 avdd.t449 0.257728
R1561 avdd.n39 avdd.t450 0.257728
R1562 avdd.n41 avdd.t657 0.257728
R1563 avdd.n41 avdd.t658 0.257728
R1564 avdd.n43 avdd.t653 0.257728
R1565 avdd.n43 avdd.t654 0.257728
R1566 avdd.n45 avdd.t649 0.257728
R1567 avdd.n45 avdd.t650 0.257728
R1568 avdd.n47 avdd.t645 0.257728
R1569 avdd.n47 avdd.t646 0.257728
R1570 avdd.n49 avdd.t641 0.257728
R1571 avdd.n49 avdd.t642 0.257728
R1572 avdd.n51 avdd.t637 0.257728
R1573 avdd.n51 avdd.t638 0.257728
R1574 avdd.n53 avdd.t633 0.257728
R1575 avdd.n53 avdd.t634 0.257728
R1576 avdd.n55 avdd.t629 0.257728
R1577 avdd.n55 avdd.t630 0.257728
R1578 avdd.n57 avdd.t593 0.257728
R1579 avdd.n57 avdd.t594 0.257728
R1580 avdd.n59 avdd.t597 0.257728
R1581 avdd.n59 avdd.t598 0.257728
R1582 avdd.n61 avdd.t569 0.257728
R1583 avdd.n61 avdd.t570 0.257728
R1584 avdd.n63 avdd.t573 0.257728
R1585 avdd.n63 avdd.t574 0.257728
R1586 avdd.n65 avdd.t549 0.257728
R1587 avdd.n65 avdd.t550 0.257728
R1588 avdd.n67 avdd.t545 0.257728
R1589 avdd.n67 avdd.t546 0.257728
R1590 avdd.n69 avdd.t445 0.257728
R1591 avdd.n69 avdd.t446 0.257728
R1592 avdd.n71 avdd.t473 0.257728
R1593 avdd.n71 avdd.t474 0.257728
R1594 avdd.n826 avdd.n778 0.2565
R1595 avdd.n818 avdd.n817 0.2565
R1596 avdd.n693 avdd.n692 0.2525
R1597 avdd.n683 avdd.n682 0.2525
R1598 avdd.n818 avdd.n778 0.2405
R1599 avdd.n879 avdd.n834 0.234387
R1600 avdd.n239 avdd.t145 0.227567
R1601 avdd.n239 avdd.t146 0.227567
R1602 avdd.n241 avdd.t141 0.227567
R1603 avdd.n241 avdd.t142 0.227567
R1604 avdd.n243 avdd.t137 0.227567
R1605 avdd.n243 avdd.t138 0.227567
R1606 avdd.n245 avdd.t133 0.227567
R1607 avdd.n245 avdd.t134 0.227567
R1608 avdd.n247 avdd.t129 0.227567
R1609 avdd.n247 avdd.t130 0.227567
R1610 avdd.n249 avdd.t97 0.227567
R1611 avdd.n249 avdd.t98 0.227567
R1612 avdd.n251 avdd.t181 0.227567
R1613 avdd.n251 avdd.t182 0.227567
R1614 avdd.n253 avdd.t101 0.227567
R1615 avdd.n253 avdd.t102 0.227567
R1616 avdd.n255 avdd.t105 0.227567
R1617 avdd.n255 avdd.t106 0.227567
R1618 avdd.n257 avdd.t109 0.227567
R1619 avdd.n257 avdd.t110 0.227567
R1620 avdd.n259 avdd.t113 0.227567
R1621 avdd.n259 avdd.t114 0.227567
R1622 avdd.n261 avdd.t117 0.227567
R1623 avdd.n261 avdd.t118 0.227567
R1624 avdd.n263 avdd.t121 0.227567
R1625 avdd.n263 avdd.t122 0.227567
R1626 avdd.n265 avdd.t125 0.227567
R1627 avdd.n265 avdd.t126 0.227567
R1628 avdd.n267 avdd.t185 0.227567
R1629 avdd.n267 avdd.t186 0.227567
R1630 avdd.n269 avdd.t189 0.227567
R1631 avdd.n269 avdd.t190 0.227567
R1632 avdd.n271 avdd.t245 0.227567
R1633 avdd.n271 avdd.t246 0.227567
R1634 avdd.n272 avdd.t201 0.227567
R1635 avdd.n272 avdd.t202 0.227567
R1636 avdd.n274 avdd.t205 0.227567
R1637 avdd.n274 avdd.t206 0.227567
R1638 avdd.n276 avdd.t209 0.227567
R1639 avdd.n276 avdd.t210 0.227567
R1640 avdd.n278 avdd.t213 0.227567
R1641 avdd.n278 avdd.t214 0.227567
R1642 avdd.n280 avdd.t217 0.227567
R1643 avdd.n280 avdd.t218 0.227567
R1644 avdd.n282 avdd.t221 0.227567
R1645 avdd.n282 avdd.t222 0.227567
R1646 avdd.n284 avdd.t225 0.227567
R1647 avdd.n284 avdd.t226 0.227567
R1648 avdd.n286 avdd.t229 0.227567
R1649 avdd.n286 avdd.t230 0.227567
R1650 avdd.n288 avdd.t233 0.227567
R1651 avdd.n288 avdd.t234 0.227567
R1652 avdd.n290 avdd.t237 0.227567
R1653 avdd.n290 avdd.t238 0.227567
R1654 avdd.n292 avdd.t241 0.227567
R1655 avdd.n292 avdd.t242 0.227567
R1656 avdd.n294 avdd.t249 0.227567
R1657 avdd.n294 avdd.t250 0.227567
R1658 avdd.n297 avdd.t325 0.226542
R1659 avdd.n297 avdd.t326 0.226542
R1660 avdd.n299 avdd.t333 0.226542
R1661 avdd.n299 avdd.t334 0.226542
R1662 avdd.n301 avdd.t329 0.226542
R1663 avdd.n301 avdd.t330 0.226542
R1664 avdd.n303 avdd.t349 0.226542
R1665 avdd.n303 avdd.t350 0.226542
R1666 avdd.n345 avdd.t381 0.226542
R1667 avdd.n345 avdd.t382 0.226542
R1668 avdd.n347 avdd.t377 0.226542
R1669 avdd.n347 avdd.t378 0.226542
R1670 avdd.n349 avdd.t373 0.226542
R1671 avdd.n349 avdd.t374 0.226542
R1672 avdd.n351 avdd.t369 0.226542
R1673 avdd.n351 avdd.t370 0.226542
R1674 avdd.n353 avdd.t365 0.226542
R1675 avdd.n353 avdd.t366 0.226542
R1676 avdd.n355 avdd.t361 0.226542
R1677 avdd.n355 avdd.t362 0.226542
R1678 avdd.n357 avdd.t357 0.226542
R1679 avdd.n357 avdd.t358 0.226542
R1680 avdd.n359 avdd.t353 0.226542
R1681 avdd.n359 avdd.t354 0.226542
R1682 avdd.n361 avdd.t345 0.226542
R1683 avdd.n361 avdd.t346 0.226542
R1684 avdd.n363 avdd.t341 0.226542
R1685 avdd.n363 avdd.t342 0.226542
R1686 avdd.n365 avdd.t337 0.226542
R1687 avdd.n365 avdd.t338 0.226542
R1688 avdd.n367 avdd.t321 0.226542
R1689 avdd.n367 avdd.t322 0.226542
R1690 avdd.n369 avdd.t317 0.226542
R1691 avdd.n369 avdd.t318 0.226542
R1692 avdd.n371 avdd.t313 0.226542
R1693 avdd.n371 avdd.t314 0.226542
R1694 avdd.n373 avdd.t309 0.226542
R1695 avdd.n373 avdd.t310 0.226542
R1696 avdd.n375 avdd.t305 0.226542
R1697 avdd.n375 avdd.t306 0.226542
R1698 avdd.n377 avdd.t301 0.226542
R1699 avdd.n377 avdd.t302 0.226542
R1700 avdd.n379 avdd.t297 0.226542
R1701 avdd.n379 avdd.t298 0.226542
R1702 avdd.n381 avdd.t293 0.226542
R1703 avdd.n381 avdd.t294 0.226542
R1704 avdd.n295 avdd.t253 0.22634
R1705 avdd.n295 avdd.t254 0.22634
R1706 avdd.n384 avdd.t269 0.22634
R1707 avdd.n384 avdd.t270 0.22634
R1708 avdd.n386 avdd.t289 0.22634
R1709 avdd.n386 avdd.t290 0.22634
R1710 avdd.n388 avdd.t193 0.22634
R1711 avdd.n388 avdd.t194 0.22634
R1712 avdd.n390 avdd.t257 0.22634
R1713 avdd.n390 avdd.t258 0.22634
R1714 avdd.n392 avdd.t285 0.22634
R1715 avdd.n392 avdd.t286 0.22634
R1716 avdd.n394 avdd.t281 0.22634
R1717 avdd.n394 avdd.t282 0.22634
R1718 avdd.n396 avdd.t277 0.22634
R1719 avdd.n396 avdd.t278 0.22634
R1720 avdd.n398 avdd.t273 0.22634
R1721 avdd.n398 avdd.t274 0.22634
R1722 avdd.n400 avdd.t265 0.22634
R1723 avdd.n400 avdd.t266 0.22634
R1724 avdd.n402 avdd.t261 0.22634
R1725 avdd.n402 avdd.t262 0.22634
R1726 avdd.n404 avdd.t149 0.22634
R1727 avdd.n404 avdd.t150 0.22634
R1728 avdd.n406 avdd.t153 0.22634
R1729 avdd.n406 avdd.t154 0.22634
R1730 avdd.n408 avdd.t157 0.22634
R1731 avdd.n408 avdd.t158 0.22634
R1732 avdd.n410 avdd.t161 0.22634
R1733 avdd.n410 avdd.t162 0.22634
R1734 avdd.n412 avdd.t165 0.22634
R1735 avdd.n412 avdd.t166 0.22634
R1736 avdd.n414 avdd.t169 0.22634
R1737 avdd.n414 avdd.t170 0.22634
R1738 avdd.n416 avdd.t173 0.22634
R1739 avdd.n416 avdd.t174 0.22634
R1740 avdd.n418 avdd.t177 0.22634
R1741 avdd.n418 avdd.t178 0.22634
R1742 avdd.n420 avdd.t197 0.22634
R1743 avdd.n420 avdd.t198 0.22634
R1744 avdd.n690 avdd.n689 0.2228
R1745 avdd.n681 avdd.n680 0.2228
R1746 avdd.n25 avdd.n661 0.310592
R1747 avdd.n99 avdd.t880 0.20635
R1748 avdd.n99 avdd.t881 0.20635
R1749 avdd.n101 avdd.t876 0.20635
R1750 avdd.n101 avdd.t877 0.20635
R1751 avdd.n103 avdd.t872 0.20635
R1752 avdd.n103 avdd.t873 0.20635
R1753 avdd.n105 avdd.t868 0.20635
R1754 avdd.n105 avdd.t869 0.20635
R1755 avdd.n107 avdd.t864 0.20635
R1756 avdd.n107 avdd.t865 0.20635
R1757 avdd.n109 avdd.t860 0.20635
R1758 avdd.n109 avdd.t861 0.20635
R1759 avdd.n111 avdd.t856 0.20635
R1760 avdd.n111 avdd.t857 0.20635
R1761 avdd.n113 avdd.t852 0.20635
R1762 avdd.n113 avdd.t853 0.20635
R1763 avdd.n115 avdd.t804 0.20635
R1764 avdd.n115 avdd.t805 0.20635
R1765 avdd.n117 avdd.t792 0.20635
R1766 avdd.n117 avdd.t793 0.20635
R1767 avdd.n119 avdd.t788 0.20635
R1768 avdd.n119 avdd.t789 0.20635
R1769 avdd.n121 avdd.t784 0.20635
R1770 avdd.n121 avdd.t785 0.20635
R1771 avdd.n123 avdd.t764 0.20635
R1772 avdd.n123 avdd.t765 0.20635
R1773 avdd.n125 avdd.t768 0.20635
R1774 avdd.n125 avdd.t769 0.20635
R1775 avdd.n127 avdd.t772 0.20635
R1776 avdd.n127 avdd.t773 0.20635
R1777 avdd.n129 avdd.t776 0.20635
R1778 avdd.n129 avdd.t777 0.20635
R1779 avdd.n131 avdd.t780 0.20635
R1780 avdd.n131 avdd.t781 0.20635
R1781 avdd.n133 avdd.t808 0.20635
R1782 avdd.n133 avdd.t809 0.20635
R1783 avdd.n135 avdd.t848 0.20635
R1784 avdd.n135 avdd.t849 0.20635
R1785 avdd.n137 avdd.t844 0.20635
R1786 avdd.n137 avdd.t845 0.20635
R1787 avdd.n817 avdd.n816 0.2005
R1788 avdd.n305 avdd.t701 0.193083
R1789 avdd.n305 avdd.t702 0.193083
R1790 avdd.n307 avdd.t697 0.193083
R1791 avdd.n307 avdd.t698 0.193083
R1792 avdd.n309 avdd.t693 0.193083
R1793 avdd.n309 avdd.t694 0.193083
R1794 avdd.n311 avdd.t689 0.193083
R1795 avdd.n311 avdd.t690 0.193083
R1796 avdd.n313 avdd.t685 0.193083
R1797 avdd.n313 avdd.t686 0.193083
R1798 avdd.n315 avdd.t681 0.193083
R1799 avdd.n315 avdd.t682 0.193083
R1800 avdd.n317 avdd.t677 0.193083
R1801 avdd.n317 avdd.t678 0.193083
R1802 avdd.n319 avdd.t673 0.193083
R1803 avdd.n319 avdd.t674 0.193083
R1804 avdd.n321 avdd.t760 0.193083
R1805 avdd.n321 avdd.t761 0.193083
R1806 avdd.n323 avdd.t756 0.193083
R1807 avdd.n323 avdd.t757 0.193083
R1808 avdd.n325 avdd.t800 0.193083
R1809 avdd.n325 avdd.t801 0.193083
R1810 avdd.n327 avdd.t796 0.193083
R1811 avdd.n327 avdd.t797 0.193083
R1812 avdd.n329 avdd.t840 0.193083
R1813 avdd.n329 avdd.t841 0.193083
R1814 avdd.n331 avdd.t836 0.193083
R1815 avdd.n331 avdd.t837 0.193083
R1816 avdd.n333 avdd.t832 0.193083
R1817 avdd.n333 avdd.t833 0.193083
R1818 avdd.n335 avdd.t828 0.193083
R1819 avdd.n335 avdd.t829 0.193083
R1820 avdd.n337 avdd.t824 0.193083
R1821 avdd.n337 avdd.t825 0.193083
R1822 avdd.n339 avdd.t820 0.193083
R1823 avdd.n339 avdd.t821 0.193083
R1824 avdd.n341 avdd.t816 0.193083
R1825 avdd.n341 avdd.t817 0.193083
R1826 avdd.n343 avdd.t812 0.193083
R1827 avdd.n343 avdd.t813 0.193083
R1828 avdd.n567 avdd.n566 0.1805
R1829 avdd.n563 avdd.n562 0.1805
R1830 avdd.n808 avdd.n803 0.170875
R1831 avdd.n237 avdd.n238 0.0487132
R1832 avdd.n833 avdd.n832 0.156929
R1833 avdd.n888 avdd.n3 0.17017
R1834 avdd.n236 avdd.n785 0.135989
R1835 avdd.n577 avdd.n576 0.1355
R1836 avdd.n816 avdd.n815 0.128929
R1837 avdd.n789 avdd.n788 0.127989
R1838 avdd.n2 avdd.n0 0.0562901
R1839 avdd.n808 avdd.n807 0.101981
R1840 avdd.n814 avdd.n813 0.1005
R1841 avdd.n786 avdd.n237 0.0943978
R1842 avdd.n812 avdd.n802 0.0904484
R1843 avdd.n890 avdd.n10 9.14876
R1844 avdd.n787 avdd.n786 0.0885
R1845 avdd.n238 avdd.n785 0.0620137
R1846 avdd.n421 avdd.t195 9.56733
R1847 avdd.n419 avdd.t175 9.56733
R1848 avdd.n417 avdd.t171 9.56733
R1849 avdd.n415 avdd.t167 9.56733
R1850 avdd.n413 avdd.t163 9.56733
R1851 avdd.n411 avdd.t159 9.56733
R1852 avdd.n409 avdd.t155 9.56733
R1853 avdd.n407 avdd.t151 9.56733
R1854 avdd.n405 avdd.t147 9.56733
R1855 avdd.n403 avdd.t259 9.56733
R1856 avdd.n401 avdd.t263 9.56733
R1857 avdd.n399 avdd.t271 9.56733
R1858 avdd.n397 avdd.t275 9.56733
R1859 avdd.n395 avdd.t279 9.56733
R1860 avdd.n393 avdd.t283 9.56733
R1861 avdd.n391 avdd.t255 9.56733
R1862 avdd.n389 avdd.t191 9.56733
R1863 avdd.n387 avdd.t287 9.56733
R1864 avdd.t267 avdd.n385 9.55923
R1865 avdd.n382 avdd.t291 9.54895
R1866 avdd.n380 avdd.t295 9.54895
R1867 avdd.n378 avdd.t299 9.54895
R1868 avdd.n376 avdd.t303 9.54895
R1869 avdd.n374 avdd.t307 9.54895
R1870 avdd.n372 avdd.t311 9.54895
R1871 avdd.n370 avdd.t315 9.54895
R1872 avdd.n368 avdd.t319 9.54895
R1873 avdd.n366 avdd.t335 9.54895
R1874 avdd.n364 avdd.t339 9.54895
R1875 avdd.n362 avdd.t343 9.54895
R1876 avdd.n360 avdd.t351 9.54895
R1877 avdd.n358 avdd.t355 9.54895
R1878 avdd.n356 avdd.t359 9.54895
R1879 avdd.n354 avdd.t363 9.54895
R1880 avdd.n352 avdd.t367 9.54895
R1881 avdd.n350 avdd.t371 9.54895
R1882 avdd.n348 avdd.t375 9.54895
R1883 avdd.n346 avdd.t379 9.54895
R1884 avdd.n344 avdd.t810 11.0472
R1885 avdd.n342 avdd.t814 11.0472
R1886 avdd.n340 avdd.t818 11.0472
R1887 avdd.n338 avdd.t822 11.0472
R1888 avdd.n336 avdd.t826 11.0472
R1889 avdd.n334 avdd.t830 11.0472
R1890 avdd.n332 avdd.t834 11.0472
R1891 avdd.n330 avdd.t838 11.0472
R1892 avdd.n328 avdd.t794 11.0472
R1893 avdd.n326 avdd.t798 11.0472
R1894 avdd.n324 avdd.t754 11.0472
R1895 avdd.n322 avdd.t758 11.0472
R1896 avdd.n320 avdd.t671 11.0472
R1897 avdd.n318 avdd.t675 11.0472
R1898 avdd.n316 avdd.t679 11.0472
R1899 avdd.n314 avdd.t683 11.0472
R1900 avdd.n312 avdd.t687 11.0472
R1901 avdd.n310 avdd.t691 11.0472
R1902 avdd.n308 avdd.t695 11.0472
R1903 avdd.n306 avdd.t699 11.0472
R1904 avdd.n304 avdd.t347 9.54895
R1905 avdd.n302 avdd.t327 9.54895
R1906 avdd.n300 avdd.t331 9.54895
R1907 avdd.n298 avdd.t323 9.54895
R1908 avdd.n296 avdd.t251 9.56733
R1909 avdd.n293 avdd.t239 9.45703
R1910 avdd.n291 avdd.t235 9.45703
R1911 avdd.n289 avdd.t231 9.45703
R1912 avdd.n287 avdd.t227 9.45703
R1913 avdd.n285 avdd.t223 9.45703
R1914 avdd.n283 avdd.t219 9.45703
R1915 avdd.n281 avdd.t215 9.45703
R1916 avdd.n279 avdd.t211 9.45703
R1917 avdd.n277 avdd.t207 9.45703
R1918 avdd.n275 avdd.t203 9.45703
R1919 avdd.n273 avdd.t199 9.45703
R1920 avdd.n270 avdd.t187 9.45703
R1921 avdd.n268 avdd.t183 9.45703
R1922 avdd.n266 avdd.t123 9.45703
R1923 avdd.n264 avdd.t119 9.45703
R1924 avdd.n262 avdd.t115 9.45703
R1925 avdd.n260 avdd.t111 9.45703
R1926 avdd.n258 avdd.t107 9.45703
R1927 avdd.n256 avdd.t103 9.45703
R1928 avdd.n254 avdd.t99 9.45703
R1929 avdd.n252 avdd.t179 9.45703
R1930 avdd.n250 avdd.t95 9.45703
R1931 avdd.n248 avdd.t127 9.45703
R1932 avdd.n246 avdd.t131 9.45703
R1933 avdd.n244 avdd.t135 9.45703
R1934 avdd.n242 avdd.t139 9.45703
R1935 avdd.n240 avdd.t143 9.45703
R1936 avdd.n814 avdd.n802 0.0861055
R1937 avdd.n833 avdd.n773 0.0843923
R1938 avdd.n237 avdd.n236 0.0826923
R1939 avdd.n10 avdd.n773 0.0998572
R1940 avdd.n74 avdd.t526 0.0781017
R1941 avdd.n76 avdd.t522 0.0781017
R1942 avdd.n78 avdd.t518 0.0781017
R1943 avdd.n80 avdd.t514 0.0781017
R1944 avdd.n82 avdd.t510 0.0781017
R1945 avdd.n84 avdd.t506 0.0781017
R1946 avdd.n86 avdd.t502 0.0781017
R1947 avdd.n88 avdd.t498 0.0781017
R1948 avdd.n90 avdd.t494 0.0781017
R1949 avdd.n92 avdd.t490 0.0781017
R1950 avdd.n94 avdd.t486 0.0781017
R1951 avdd.n96 avdd.t482 0.0781017
R1952 avdd.n98 avdd.t478 0.0781017
R1953 avdd.n140 avdd.t662 0.0781017
R1954 avdd.n142 avdd.t666 0.0781017
R1955 avdd.n144 avdd.t670 0.0781017
R1956 avdd.n146 avdd.t753 0.0781017
R1957 avdd.n148 avdd.t749 0.0781017
R1958 avdd.n150 avdd.t745 0.0781017
R1959 avdd.n152 avdd.t741 0.0781017
R1960 avdd.n154 avdd.t737 0.0781017
R1961 avdd.n156 avdd.t733 0.0781017
R1962 avdd.n158 avdd.t729 0.0781017
R1963 avdd.n160 avdd.t725 0.0781017
R1964 avdd.n162 avdd.t721 0.0781017
R1965 avdd.n164 avdd.t717 0.0781017
R1966 avdd.n166 avdd.t713 0.0781017
R1967 avdd.n168 avdd.t709 0.0781017
R1968 avdd.n815 avdd.n814 0.0767
R1969 avdd.n616 avdd.n615 0.0748204
R1970 avdd.n812 avdd.n804 0.0725
R1971 avdd.n813 avdd.n803 0.0725
R1972 avdd.n816 avdd.n794 0.0645
R1973 avdd.n238 avdd.n784 9.31584
R1974 avdd.n235 avdd.t439 16.8096
R1975 avdd.n233 avdd.t435 16.8096
R1976 avdd.n231 avdd.t431 16.8096
R1977 avdd.n229 avdd.t427 16.8096
R1978 avdd.n227 avdd.t411 16.8096
R1979 avdd.n225 avdd.t415 16.8096
R1980 avdd.n223 avdd.t419 16.8096
R1981 avdd.n221 avdd.t407 16.8096
R1982 avdd.n219 avdd.t403 16.8096
R1983 avdd.n217 avdd.t399 16.8096
R1984 avdd.n215 avdd.t395 16.8096
R1985 avdd.n213 avdd.t391 16.8096
R1986 avdd.n211 avdd.t387 16.8096
R1987 avdd.n209 avdd.t383 16.8096
R1988 avdd.n207 avdd.n617 0.125484
R1989 avdd.n206 avdd.t527 16.8096
R1990 avdd.n204 avdd.t551 16.8096
R1991 avdd.n202 avdd.t575 16.8096
R1992 avdd.n200 avdd.t599 16.8096
R1993 avdd.n198 avdd.t603 16.8096
R1994 avdd.n196 avdd.t607 16.8096
R1995 avdd.n194 avdd.t611 16.8096
R1996 avdd.n192 avdd.t615 16.8096
R1997 avdd.n190 avdd.t619 16.8096
R1998 avdd.n188 avdd.t623 16.8096
R1999 avdd.n186 avdd.t587 16.8096
R2000 avdd.n184 avdd.t583 16.8096
R2001 avdd.n182 avdd.t579 16.8096
R2002 avdd.n180 avdd.t563 16.8096
R2003 avdd.n178 avdd.t559 16.8096
R2004 avdd.n176 avdd.t555 16.8096
R2005 avdd.n174 avdd.t539 16.8096
R2006 avdd.n172 avdd.t535 16.8096
R2007 avdd.n170 avdd.t531 16.8096
R2008 avdd.n138 avdd.t842 20.7938
R2009 avdd.n136 avdd.t846 20.7938
R2010 avdd.n134 avdd.t806 20.7938
R2011 avdd.n132 avdd.t778 20.7938
R2012 avdd.n130 avdd.t774 20.7938
R2013 avdd.n128 avdd.t770 20.7938
R2014 avdd.n126 avdd.t766 20.7938
R2015 avdd.n124 avdd.t762 20.7938
R2016 avdd.n122 avdd.t782 20.7938
R2017 avdd.n120 avdd.t786 20.7938
R2018 avdd.n118 avdd.t790 20.7938
R2019 avdd.n116 avdd.t802 20.7938
R2020 avdd.n114 avdd.t850 20.7938
R2021 avdd.n112 avdd.t854 20.7938
R2022 avdd.n110 avdd.t858 20.7938
R2023 avdd.n108 avdd.t862 20.7938
R2024 avdd.n106 avdd.t866 20.7938
R2025 avdd.n104 avdd.t870 20.7938
R2026 avdd.n102 avdd.t874 20.7938
R2027 avdd.n100 avdd.t878 20.7938
R2028 avdd.n72 avdd.t471 34.1741
R2029 avdd.n70 avdd.t443 34.1741
R2030 avdd.n68 avdd.t543 34.1741
R2031 avdd.n66 avdd.t547 34.1741
R2032 avdd.n64 avdd.t571 34.1741
R2033 avdd.n62 avdd.t567 34.1741
R2034 avdd.n60 avdd.t595 34.1741
R2035 avdd.n58 avdd.t591 34.1741
R2036 avdd.n56 avdd.t627 34.1741
R2037 avdd.n54 avdd.t631 34.1741
R2038 avdd.n52 avdd.t635 34.1741
R2039 avdd.n50 avdd.t639 34.1741
R2040 avdd.n48 avdd.t643 34.1741
R2041 avdd.n46 avdd.t647 34.1741
R2042 avdd.n44 avdd.t651 34.1741
R2043 avdd.n42 avdd.t655 34.1741
R2044 avdd.n40 avdd.t447 34.1741
R2045 avdd.n38 avdd.t451 34.1741
R2046 avdd.n36 avdd.t455 34.1741
R2047 avdd.n34 avdd.t459 34.1741
R2048 avdd.n32 avdd.t463 34.1741
R2049 avdd.n30 avdd.t467 34.1741
R2050 avdd.n9 avdd.n28 1.01368
R2051 avdd.n887 avdd.n27 0.193025
R2052 avdd.n168 avdd.t708 0.0807146
R2053 avdd.n166 avdd.t712 0.0807146
R2054 avdd.n164 avdd.t716 0.0807146
R2055 avdd.n162 avdd.t720 0.0807146
R2056 avdd.n160 avdd.t724 0.0807146
R2057 avdd.n158 avdd.t728 0.0807146
R2058 avdd.n156 avdd.t732 0.0807146
R2059 avdd.n154 avdd.t736 0.0807146
R2060 avdd.n152 avdd.t740 0.0807146
R2061 avdd.n150 avdd.t744 0.0807146
R2062 avdd.n148 avdd.t748 0.0807146
R2063 avdd.n146 avdd.t752 0.0807146
R2064 avdd.n144 avdd.t669 0.0807146
R2065 avdd.n142 avdd.t665 0.0807146
R2066 avdd.n140 avdd.t661 0.0807146
R2067 avdd.n98 avdd.t477 0.0807146
R2068 avdd.n96 avdd.t481 0.0807146
R2069 avdd.n94 avdd.t485 0.0807146
R2070 avdd.n92 avdd.t489 0.0807146
R2071 avdd.n90 avdd.t493 0.0807146
R2072 avdd.n88 avdd.t497 0.0807146
R2073 avdd.n86 avdd.t501 0.0807146
R2074 avdd.n84 avdd.t505 0.0807146
R2075 avdd.n82 avdd.t509 0.0807146
R2076 avdd.n80 avdd.t513 0.0807146
R2077 avdd.n78 avdd.t517 0.0807146
R2078 avdd.n76 avdd.t521 0.0807146
R2079 avdd.n74 avdd.t525 0.0807146
R2080 avdd.n807 avdd 0.0520066
R2081 avdd.n813 avdd.n812 0.0485
R2082 avdd.n789 avdd.n2 0.0191987
R2083 avdd.n788 avdd.n787 0.0443571
R2084 avdd.n804 avdd.n803 0.0441364
R2085 avdd avdd.n3 4.62755
R2086 avdd.n21 avdd.n730 2.6105
R2087 avdd.n19 avdd.n856 2.6105
R2088 avdd.n18 avdd.n784 2.6105
R2089 avdd.n772 avdd.n20 2.603
R2090 avdd.n16 avdd.n772 1.99344
R2091 avdd.n612 avdd.n26 1.7105
R2092 avdd.n8 avdd.n475 1.7105
R2093 avdd.n14 avdd.n15 1.23732
R2094 avdd.n13 avdd.n14 1.23732
R2095 avdd.n12 avdd.n13 1.23732
R2096 avdd.n12 avdd.n626 1.23732
R2097 avdd.n28 avdd.n23 1.02867
R2098 avdd.n9 avdd.n451 1.02493
R2099 avdd.n11 avdd.n681 0.437375
R2100 avdd.n4 avdd.n7 2.69452
R2101 avdd.n787 avdd.n2 0.206082
R2102 avdd.n10 avdd 0.100992
R2103 dvdd.n11 dvdd.t26 109.692
R2104 dvdd.n32 dvdd.t28 109.445
R2105 dvdd.n25 dvdd.t8 109.422
R2106 dvdd.n7 dvdd.t10 109.272
R2107 dvdd.n29 dvdd.t6 109.264
R2108 dvdd.n13 dvdd.t0 104.746
R2109 dvdd.n10 dvdd.t24 100.174
R2110 dvdd.n8 dvdd.t17 82.4916
R2111 dvdd.n3 dvdd.t5 60.7437
R2112 dvdd.n24 dvdd.t4 45.3749
R2113 dvdd.n37 dvdd.t20 39.4649
R2114 dvdd.n38 dvdd.t23 39.4347
R2115 dvdd.n12 dvdd.t2 33.4172
R2116 dvdd.n18 dvdd.t14 31.6601
R2117 dvdd.n15 dvdd.t19 31.4969
R2118 dvdd.n20 dvdd.t21 30.6194
R2119 dvdd.n18 dvdd.t13 30.6149
R2120 dvdd.n17 dvdd.t18 30.6059
R2121 dvdd.n21 dvdd.t15 30.578
R2122 dvdd.n19 dvdd.t12 30.5714
R2123 dvdd.n16 dvdd.t3 30.5689
R2124 dvdd.n15 dvdd.t22 30.5667
R2125 dvdd.n5 dvdd.t16 30.4271
R2126 dvdd.n9 dvdd.n8 24.3348
R2127 dvdd.n2 dvdd.n11 18.9905
R2128 dvdd.n6 dvdd.n5 15.8855
R2129 dvdd.n14 dvdd.t1 15.5386
R2130 dvdd.n33 dvdd.t29 15.1483
R2131 dvdd.n2 dvdd.t27 15.0931
R2132 dvdd.n26 dvdd.t9 15.0481
R2133 dvdd.n39 dvdd.n0 14.8505
R2134 dvdd.n10 dvdd.n9 14.186
R2135 dvdd dvdd.n3 12.4205
R2136 dvdd.n8 dvdd.n7 11.5239
R2137 dvdd.n6 dvdd.t11 10.5249
R2138 dvdd.n9 dvdd.t25 10.5033
R2139 dvdd.n28 dvdd.t7 10.4782
R2140 dvdd.n2 dvdd.n33 10.4405
R2141 dvdd.n0 dvdd.n5 9.37175
R2142 dvdd.n34 dvdd.n10 9.288
R2143 dvdd.n13 dvdd.n12 6.5255
R2144 dvdd.n28 dvdd.n27 6.0305
R2145 dvdd.n7 dvdd.n6 5.3555
R2146 dvdd.n29 dvdd.n28 5.0405
R2147 dvdd.n14 dvdd.n13 4.5005
R2148 dvdd.n39 dvdd.n3 4.5005
R2149 dvdd.n34 dvdd.n2 2.4305
R2150 dvdd.n23 dvdd.n22 1.80783
R2151 dvdd.n30 dvdd.n12 1.40779
R2152 dvdd.n20 dvdd.n19 1.2605
R2153 dvdd.n40 dvdd.n39 1.2375
R2154 dvdd.n29 dvdd.n14 1.1705
R2155 dvdd.n2 dvdd.n1 1.1705
R2156 dvdd.n32 dvdd.n31 1.12958
R2157 dvdd.n37 dvdd.n4 1.1255
R2158 dvdd.n0 dvdd.n36 1.1255
R2159 dvdd.n35 dvdd.n34 1.1255
R2160 dvdd.n30 dvdd.n29 1.1255
R2161 dvdd.n26 dvdd.n11 1.0805
R2162 dvdd.n21 dvdd.n20 1.0805
R2163 dvdd.n16 dvdd.n15 1.0805
R2164 dvdd.n25 dvdd.n24 0.9905
R2165 dvdd.n24 dvdd.n23 0.965742
R2166 dvdd.n19 dvdd.n18 0.9005
R2167 dvdd.n17 dvdd.n16 0.9005
R2168 dvdd.n38 dvdd.n37 0.8105
R2169 dvdd.n36 dvdd.n35 0.6965
R2170 dvdd.n22 dvdd.n17 0.5855
R2171 dvdd dvdd.n40 0.4925
R2172 dvdd.n40 dvdd.n4 0.4885
R2173 dvdd.n0 dvdd.n38 0.4505
R2174 dvdd.n23 dvdd.n1 0.30824
R2175 dvdd.n27 dvdd.n25 0.2705
R2176 dvdd.n33 dvdd.n32 0.2255
R2177 dvdd.n22 dvdd.n21 0.2255
R2178 dvdd.n31 dvdd.n1 0.199468
R2179 dvdd.n31 dvdd.n30 0.175539
R2180 dvdd.n27 dvdd.n26 0.1355
R2181 dvdd.n36 dvdd.n4 0.1285
R2182 dvdd.n35 dvdd.n1 0.1205
R2183 psrg_mf1_protected psrg_mf1_protected.t1 34.4979
R2184 psrg_mf1_protected psrg_mf1_protected.t0 4.75063
R2185 y1.n0 y1.t7 36.1922
R2186 y1.n6 y1.t13 36.1574
R2187 y1.n1 y1.t9 34.3923
R2188 y1.n3 y1.t11 34.3923
R2189 y1.n7 y1.t15 34.3574
R2190 y1.n9 y1.t17 34.3574
R2191 y1.n0 y1.t8 34.3472
R2192 y1.n2 y1.t10 34.3472
R2193 y1.n6 y1.t14 34.2865
R2194 y1.n8 y1.t16 34.2865
R2195 y1.n10 y1.t18 34.2865
R2196 y1.n4 y1.t4 31.8593
R2197 y1.n4 y1.t12 29.8473
R2198 y1.n12 y1.n11 25.6505
R2199 y1.n15 y1.t5 21.1316
R2200 y1.n14 y1.t3 13.894
R2201 y1.n13 y1.t2 13.7842
R2202 y1.n12 y1.t1 13.759
R2203 y1.n16 y1.n14 10.6205
R2204 y1.n15 y1.t6 9.21558
R2205 y1.n13 y1.n12 8.6405
R2206 y1 y1.n16 7.394
R2207 y1.n11 y1.n5 5.9405
R2208 y1.n16 y1.n15 5.8505
R2209 y1 y1.t0 4.69308
R2210 y1.n5 y1.n4 4.5005
R2211 y1.n14 y1.n13 2.7905
R2212 y1.n9 y1.n8 1.9805
R2213 y1.n7 y1.n6 1.9805
R2214 y1.n3 y1.n2 1.9805
R2215 y1.n1 y1.n0 1.9805
R2216 y1.n10 y1.n9 1.8005
R2217 y1.n8 y1.n7 1.8005
R2218 y1.n5 y1.n3 1.8005
R2219 y1.n2 y1.n1 1.8005
R2220 y1.n11 y1.n10 0.1805
R2221 pm1.n5 pm1.n4 41.324
R2222 pm1.n6 pm1.n5 22.0055
R2223 pm1 pm1.n8 20.849
R2224 pm1.n1 pm1.t7 19.4457
R2225 pm1.n2 pm1.t6 17.6349
R2226 pm1.n1 pm1.t9 15.8457
R2227 pm1.n8 pm1.n7 14.8955
R2228 pm1.n2 pm1.n1 14.5355
R2229 pm1.n1 pm1.t8 13.9359
R2230 pm1.n4 pm1.t4 13.7649
R2231 pm1.n7 pm1.t3 13.759
R2232 pm1.n3 pm1.t5 13.7197
R2233 pm1.n0 pm1.t10 12.3566
R2234 pm1.n8 pm1.n0 10.1705
R2235 pm1.n6 pm1.t2 9.28421
R2236 pm1.n0 pm1.t11 9.21558
R2237 pm1.n7 pm1.n6 7.5605
R2238 pm1.n5 pm1.t1 4.75058
R2239 pm1 pm1.t0 4.69308
R2240 pm1.n4 pm1.n3 2.1605
R2241 pm1.n3 pm1.n2 1.8905
R2242 pm2.n7 pm2.n6 33.5705
R2243 pm2.n0 pm2.t2 26.7442
R2244 pm2.n4 pm2.t8 19.5609
R2245 pm2 pm2.n9 16.6692
R2246 pm2.n2 pm2.t5 15.8797
R2247 pm2.n3 pm2.n2 14.7155
R2248 pm2.n3 pm2.t3 13.8997
R2249 pm2.n6 pm2.n3 13.8155
R2250 pm2.n5 pm2.t6 13.8009
R2251 pm2.n4 pm2.t7 13.7757
R2252 pm2.n2 pm2.t4 13.7649
R2253 pm2.n7 pm2.t9 13.7156
R2254 pm2.n1 pm2.n0 12.1055
R2255 pm2.n8 pm2.n1 10.8905
R2256 pm2.n9 pm2.n8 10.6205
R2257 pm2.n1 pm2.t0 9.28421
R2258 pm2.n0 pm2.t1 9.25904
R2259 pm2.n9 pm2.t10 9.25158
R2260 pm2.n6 pm2.n5 6.4805
R2261 pm2 pm2.t11 4.69308
R2262 pm2.n8 pm2.n7 2.5205
R2263 pm2.n5 pm2.n4 2.1605
R2264 iref_gate.n0 iref_gate.t3 155.671
R2265 iref_gate.n1 iref_gate.t1 38.5561
R2266 iref_gate.n0 iref_gate.t2 13.6303
R2267 iref_gate.n1 iref_gate.n0 5.9855
R2268 iref_gate iref_gate.t0 4.55384
R2269 iref_gate iref_gate.n1 4.50383
R2270 vbn.n0 vbn.t3 130.732
R2271 vbn.n1 vbn.t2 26.3118
R2272 vbn.n1 vbn.t0 17.7886
R2273 vbn.n0 vbn.t4 17.7886
R2274 vbn vbn.n2 10.4394
R2275 vbn.n2 vbn.n0 6.3005
R2276 vbn vbn.t1 5.1112
R2277 vbn.n2 vbn.n1 4.5005
R2278 psrg_m3_protected.n1 psrg_m3_protected.t0 33.6292
R2279 psrg_m3_protected.n0 psrg_m3_protected.t3 20.4823
R2280 psrg_m3_protected.n1 psrg_m3_protected.n0 20.2505
R2281 psrg_m3_protected.n0 psrg_m3_protected.t2 9.52742
R2282 psrg_m3_protected psrg_m3_protected.t1 4.81592
R2283 psrg_m3_protected psrg_m3_protected.n1 4.559
R2284 psrg_vnc.n4 psrg_vnc.t9 122.335
R2285 psrg_vnc.n9 psrg_vnc.n8 27.3155
R2286 psrg_vnc.n9 psrg_vnc.t10 24.2364
R2287 psrg_vnc psrg_vnc.t11 19.6464
R2288 psrg_vnc.n7 psrg_vnc.t8 17.666
R2289 psrg_vnc.n0 psrg_vnc.t2 15.9186
R2290 psrg_vnc psrg_vnc.n9 15.3376
R2291 psrg_vnc.n8 psrg_vnc.t7 14.1938
R2292 psrg_vnc.n0 psrg_vnc.t3 13.8021
R2293 psrg_vnc.n2 psrg_vnc.t5 13.8021
R2294 psrg_vnc.n1 psrg_vnc.t4 13.7586
R2295 psrg_vnc.n3 psrg_vnc.t6 13.7586
R2296 psrg_vnc.n7 psrg_vnc.n6 13.0955
R2297 psrg_vnc.n6 psrg_vnc.n5 9.4955
R2298 psrg_vnc.n4 psrg_vnc.t0 9.30213
R2299 psrg_vnc.n6 psrg_vnc.t1 9.30213
R2300 psrg_vnc.n8 psrg_vnc.n7 6.9305
R2301 psrg_vnc.n5 psrg_vnc.n4 4.6355
R2302 psrg_vnc.n2 psrg_vnc.n1 2.1605
R2303 psrg_vnc.n5 psrg_vnc.n3 2.0705
R2304 psrg_vnc.n3 psrg_vnc.n2 1.9805
R2305 psrg_vnc.n1 psrg_vnc.n0 1.9805
R2306 vbp_cas.n29 vbp_cas.n28 68.5805
R2307 vbp_cas.n13 vbp_cas.t20 31.3027
R2308 vbp_cas.n4 vbp_cas.t27 27.3674
R2309 vbp_cas.n0 vbp_cas.t21 27.3528
R2310 vbp_cas.n10 vbp_cas.t2 25.8124
R2311 vbp_cas.n23 vbp_cas.t14 25.5874
R2312 vbp_cas.n25 vbp_cas.t10 25.5874
R2313 vbp_cas.n27 vbp_cas.t12 25.5874
R2314 vbp_cas.n21 vbp_cas.t0 25.5874
R2315 vbp_cas.n5 vbp_cas.t29 24.6674
R2316 vbp_cas.n7 vbp_cas.t31 24.6674
R2317 vbp_cas.n3 vbp_cas.t25 24.6528
R2318 vbp_cas.n4 vbp_cas.t28 24.6224
R2319 vbp_cas.n6 vbp_cas.t30 24.6224
R2320 vbp_cas.n8 vbp_cas.t32 24.6224
R2321 vbp_cas.n0 vbp_cas.t22 24.5751
R2322 vbp_cas.n2 vbp_cas.t24 24.5751
R2323 vbp_cas.n17 vbp_cas.t16 24.0124
R2324 vbp_cas.n13 vbp_cas.t4 23.1124
R2325 vbp_cas.n14 vbp_cas.t8 23.1124
R2326 vbp_cas.n10 vbp_cas.t6 23.1124
R2327 vbp_cas.n18 vbp_cas.t18 23.1124
R2328 vbp_cas.n1 vbp_cas.t23 20.1528
R2329 vbp_cas.n9 vbp_cas.t3 16.8665
R2330 vbp_cas.n19 vbp_cas.t17 15.6333
R2331 vbp_cas vbp_cas.t26 15.5628
R2332 vbp_cas.n16 vbp_cas.t5 13.9041
R2333 vbp_cas.n12 vbp_cas.t9 13.8065
R2334 vbp_cas.n28 vbp_cas.t13 13.8031
R2335 vbp_cas.n24 vbp_cas.t15 13.8031
R2336 vbp_cas.n20 vbp_cas.t19 13.8031
R2337 vbp_cas.n9 vbp_cas.t7 13.7691
R2338 vbp_cas.n22 vbp_cas.t1 13.7433
R2339 vbp_cas.n26 vbp_cas.t11 13.7433
R2340 vbp_cas.n15 vbp_cas.n14 11.2955
R2341 vbp_cas.n11 vbp_cas.n10 11.2955
R2342 vbp_cas.n29 vbp_cas.n8 10.8005
R2343 vbp_cas.n1 vbp_cas.n0 7.3805
R2344 vbp_cas.n29 vbp_cas.n3 7.2005
R2345 vbp_cas.n2 vbp_cas.n1 7.2005
R2346 vbp_cas vbp_cas.n29 4.51287
R2347 vbp_cas.n3 vbp_cas.n2 2.8805
R2348 vbp_cas.n7 vbp_cas.n6 2.8805
R2349 vbp_cas.n5 vbp_cas.n4 2.8805
R2350 vbp_cas.n17 vbp_cas.n16 2.7905
R2351 vbp_cas.n8 vbp_cas.n7 2.7005
R2352 vbp_cas.n6 vbp_cas.n5 2.7005
R2353 vbp_cas.n14 vbp_cas.n13 2.7005
R2354 vbp_cas.n19 vbp_cas.n18 2.4305
R2355 vbp_cas.n12 vbp_cas.n11 1.9805
R2356 vbp_cas.n23 vbp_cas.n22 1.8905
R2357 vbp_cas.n25 vbp_cas.n24 1.8905
R2358 vbp_cas.n27 vbp_cas.n26 1.8905
R2359 vbp_cas.n21 vbp_cas.n20 1.8905
R2360 vbp_cas.n16 vbp_cas.n15 1.8905
R2361 vbp_cas.n18 vbp_cas.n17 1.8005
R2362 vbp_cas.n24 vbp_cas.n23 1.1705
R2363 vbp_cas.n28 vbp_cas.n27 1.1705
R2364 vbp_cas.n20 vbp_cas.n19 1.1705
R2365 vbp_cas.n15 vbp_cas.n12 1.0805
R2366 vbp_cas.n26 vbp_cas.n25 0.9905
R2367 vbp_cas.n22 vbp_cas.n21 0.9905
R2368 vbp_cas.n11 vbp_cas.n9 0.9005
R2369 xf1.n5 xf1.t0 42.9365
R2370 xf1.n5 xf1.n4 41.1755
R2371 xf1.n6 xf1.n5 36.0108
R2372 xf1.n8 xf1.n7 25.1105
R2373 xf1.n1 xf1.t3 21.2642
R2374 xf1.n0 xf1.t1 16.7624
R2375 xf1.n0 xf1.t2 13.9742
R2376 xf1.n2 xf1.t5 13.8392
R2377 xf1.n1 xf1.t4 13.8024
R2378 xf1.n9 xf1.t7 13.6715
R2379 xf1.n7 xf1.t8 13.6463
R2380 xf1 xf1.n9 13.0989
R2381 xf1.n7 xf1.n6 11.0115
R2382 xf1.n3 xf1.n2 10.1705
R2383 xf1.n4 xf1.t11 9.30241
R2384 xf1.n8 xf1.t10 9.14631
R2385 xf1.n3 xf1.n0 8.9105
R2386 xf1.n9 xf1.n8 6.6605
R2387 xf1 xf1.t6 4.5781
R2388 xf1.n6 xf1.t9 4.5781
R2389 xf1.n2 xf1.n1 3.0605
R2390 xf1.n4 xf1.n3 2.7905
R2391 xf2.n5 xf2.t0 44.9165
R2392 xf2.n6 xf2.n5 38.8805
R2393 xf2.n5 xf2.n4 33.8405
R2394 xf2.n4 xf2.t3 30.2624
R2395 xf2.n9 xf2.n8 29.6105
R2396 xf2.n1 xf2.t7 24.0542
R2397 xf2 xf2.n9 22.1187
R2398 xf2.n0 xf2.t4 16.7624
R2399 xf2.n0 xf2.t5 13.9742
R2400 xf2.n3 xf2.t11 13.9742
R2401 xf2.n8 xf2.t2 13.6463
R2402 xf2.n2 xf2.t10 9.30241
R2403 xf2.n7 xf2.t6 9.17148
R2404 xf2.n6 xf2.t1 9.14631
R2405 xf2.n1 xf2.n0 8.9105
R2406 xf2.n3 xf2.n2 7.4705
R2407 xf2.n8 xf2.n7 6.4805
R2408 xf2.n7 xf2.n6 5.9405
R2409 xf2.n4 xf2.n3 4.7705
R2410 xf2.n9 xf2.t9 4.64631
R2411 xf2 xf2.t8 4.5781
R2412 xf2.n2 xf2.n1 2.7905
R2413 vgn2.n1 vgn2.t10 49.7719
R2414 vgn2.n2 vgn2.n1 46.3055
R2415 vgn2.n8 vgn2.t8 33.1543
R2416 vgn2.n8 vgn2.n7 22.1072
R2417 vgn2.n7 vgn2.t1 20.3042
R2418 vgn2 vgn2.t9 19.6464
R2419 vgn2.n0 vgn2.t3 19.0975
R2420 vgn2.n2 vgn2.t0 18.6825
R2421 vgn2.n0 vgn2.t2 18.2924
R2422 vgn2.n5 vgn2.t5 18.2516
R2423 vgn2.n6 vgn2.t4 18.2489
R2424 vgn2.n3 vgn2.t6 18.2156
R2425 vgn2.n1 vgn2.t7 16.4921
R2426 vgn2 vgn2.n8 15.3438
R2427 vgn2.n3 vgn2.n2 4.5605
R2428 vgn2.n4 vgn2.n0 1.78717
R2429 vgn2.n4 vgn2.n3 1.7205
R2430 vgn2.n7 vgn2.n6 1.02717
R2431 vgn2.n6 vgn2.n5 0.813833
R2432 vgn2.n5 vgn2.n4 0.813833
R2433 vsp.n5 vsp.n4 37.1705
R2434 vsp.n10 vsp.n9 16.8305
R2435 vsp.n0 vsp.t13 16.2006
R2436 vsp.n4 vsp.t4 13.8156
R2437 vsp.n1 vsp.t6 13.7139
R2438 vsp.n2 vsp.t15 13.7139
R2439 vsp.n0 vsp.t5 13.686
R2440 vsp.n3 vsp.t3 13.686
R2441 vsp.n6 vsp.t12 13.6715
R2442 vsp.n13 vsp.t8 13.6715
R2443 vsp.n11 vsp.t9 13.6715
R2444 vsp.n8 vsp.t2 13.6715
R2445 vsp.n12 vsp.t14 13.6463
R2446 vsp.n10 vsp.t10 13.6463
R2447 vsp.n9 vsp.t1 13.6463
R2448 vsp.n7 vsp.t11 13.6463
R2449 vsp.n5 vsp.t0 13.6463
R2450 vsp vsp.n13 11.2737
R2451 vsp vsp.t7 4.5781
R2452 vsp.n3 vsp.n2 2.5205
R2453 vsp.n1 vsp.n0 2.5205
R2454 vsp.n4 vsp.n3 2.4305
R2455 vsp.n2 vsp.n1 2.3405
R2456 vsp.n7 vsp.n6 2.1605
R2457 vsp.n9 vsp.n8 2.1605
R2458 vsp.n12 vsp.n11 2.1605
R2459 vsp.n8 vsp.n7 1.9805
R2460 vsp.n11 vsp.n10 1.9805
R2461 vsp.n13 vsp.n12 1.9805
R2462 vsp.n6 vsp.n5 1.9805
R2463 v2.n2 v2.t4 65.501
R2464 v2.n1 v2.t3 65.4526
R2465 v2.n3 v2.t5 65.4526
R2466 v2.n4 v2.t6 60.9526
R2467 v2.n5 v2.t7 60.9526
R2468 v2.n6 v2.n5 54.8555
R2469 v2.n6 v2.t0 15.4715
R2470 v2.n10 v2.t2 13.8293
R2471 v2.n5 v2.n4 13.0505
R2472 v2.n4 v2.n3 12.2855
R2473 v2.n7 v2.n0 10.5305
R2474 v2.n11 v2.n10 9.0455
R2475 v2.n11 v2.n0 6.7055
R2476 v2.n8 v2.n1 6.5855
R2477 v2.n2 v2.n1 5.8505
R2478 v2 v2.n11 5.774
R2479 v2 v2.t1 4.81592
R2480 v2.n7 v2.n6 1.8455
R2481 v2.n3 v2.n2 1.8005
R2482 v2.n10 v2.n9 1.76429
R2483 v2.n9 v2.n0 1.1415
R2484 v2.n8 v2.n7 1.1255
R2485 v2.n9 v2.n8 0.9285
R2486 vaux.n0 vaux.t2 55.5092
R2487 vaux vaux.n0 15.2091
R2488 vaux.n0 vaux.t0 9.47375
R2489 vaux vaux.t1 4.93012
R2490 vx3 vx3.n4 34.3187
R2491 vx3.n5 vx3.t4 31.1652
R2492 vx3 vx3.n7 19.6205
R2493 vx3.n6 vx3.n5 18.4205
R2494 vx3.n7 vx3.t7 13.8364
R2495 vx3.n0 vx3.t2 13.3392
R2496 vx3.n0 vx3.t3 13.0962
R2497 vx3.n1 vx3.t0 11.7192
R2498 vx3.n1 vx3.t9 11.4762
R2499 vx3.n3 vx3.t10 10.6392
R2500 vx3.n3 vx3.t1 10.3962
R2501 vx3.n2 vx3.n0 9.61925
R2502 vx3.n6 vx3.t6 9.33641
R2503 vx3.n7 vx3.n6 9.3155
R2504 vx3 vx3.t8 4.76969
R2505 vx3.n5 vx3.t5 4.75991
R2506 vx3.n4 vx3.n2 4.57925
R2507 vx3.n2 vx3.n1 4.5005
R2508 vx3.n4 vx3.n3 4.5005
R2509 psrg_m3_feed.n1 psrg_m3_feed.n0 129.106
R2510 psrg_m3_feed.n7 psrg_m3_feed.t15 49.1087
R2511 psrg_m3_feed.n1 psrg_m3_feed.t9 47.7002
R2512 psrg_m3_feed.n2 psrg_m3_feed.t10 47.7002
R2513 psrg_m3_feed.n3 psrg_m3_feed.t11 47.7002
R2514 psrg_m3_feed.n5 psrg_m3_feed.t13 47.7002
R2515 psrg_m3_feed.n6 psrg_m3_feed.t14 47.7002
R2516 psrg_m3_feed.n13 psrg_m3_feed.t21 47.6777
R2517 psrg_m3_feed.n14 psrg_m3_feed.t22 47.6777
R2518 psrg_m3_feed.n15 psrg_m3_feed.t23 47.6777
R2519 psrg_m3_feed.n16 psrg_m3_feed.t24 47.6777
R2520 psrg_m3_feed.n17 psrg_m3_feed.t25 47.6777
R2521 psrg_m3_feed.n21 psrg_m3_feed.t26 47.6777
R2522 psrg_m3_feed.n7 psrg_m3_feed.t16 47.6688
R2523 psrg_m3_feed.n8 psrg_m3_feed.t17 47.6688
R2524 psrg_m3_feed.n10 psrg_m3_feed.t19 47.6688
R2525 psrg_m3_feed.n11 psrg_m3_feed.t20 47.6688
R2526 psrg_m3_feed.n4 psrg_m3_feed.t12 43.2002
R2527 psrg_m3_feed.n9 psrg_m3_feed.t18 43.1688
R2528 psrg_m3_feed.n18 psrg_m3_feed.t28 36.691
R2529 psrg_m3_feed.n18 psrg_m3_feed.t27 35.431
R2530 psrg_m3_feed.n0 psrg_m3_feed.t8 29.1043
R2531 psrg_m3_feed.n19 psrg_m3_feed.t4 26.7064
R2532 psrg_m3_feed psrg_m3_feed.n24 18.437
R2533 psrg_m3_feed.n23 psrg_m3_feed.t5 16.3114
R2534 psrg_m3_feed.n12 psrg_m3_feed.t1 15.8724
R2535 psrg_m3_feed.n20 psrg_m3_feed.n19 15.3905
R2536 psrg_m3_feed.n23 psrg_m3_feed.n22 15.3005
R2537 psrg_m3_feed.n13 psrg_m3_feed.n12 14.7605
R2538 psrg_m3_feed.n12 psrg_m3_feed.t0 13.8673
R2539 psrg_m3_feed.n0 psrg_m3_feed.t7 11.305
R2540 psrg_m3_feed.n24 psrg_m3_feed.n23 10.3505
R2541 psrg_m3_feed.n19 psrg_m3_feed.t3 9.33641
R2542 psrg_m3_feed.n24 psrg_m3_feed.t6 9.33641
R2543 psrg_m3_feed.n21 psrg_m3_feed.n20 8.8205
R2544 psrg_m3_feed.n10 psrg_m3_feed.n9 5.9405
R2545 psrg_m3_feed.n9 psrg_m3_feed.n8 5.9405
R2546 psrg_m3_feed.n5 psrg_m3_feed.n4 5.9405
R2547 psrg_m3_feed.n4 psrg_m3_feed.n3 5.9405
R2548 psrg_m3_feed.n22 psrg_m3_feed.n6 5.0405
R2549 psrg_m3_feed.n22 psrg_m3_feed.n21 4.8605
R2550 psrg_m3_feed psrg_m3_feed.t2 4.75991
R2551 psrg_m3_feed.n21 psrg_m3_feed.n17 1.4405
R2552 psrg_m3_feed.n17 psrg_m3_feed.n16 1.4405
R2553 psrg_m3_feed.n16 psrg_m3_feed.n15 1.4405
R2554 psrg_m3_feed.n15 psrg_m3_feed.n14 1.4405
R2555 psrg_m3_feed.n14 psrg_m3_feed.n13 1.4405
R2556 psrg_m3_feed.n11 psrg_m3_feed.n10 1.4405
R2557 psrg_m3_feed.n8 psrg_m3_feed.n7 1.4405
R2558 psrg_m3_feed.n6 psrg_m3_feed.n5 1.4405
R2559 psrg_m3_feed.n3 psrg_m3_feed.n2 1.4405
R2560 psrg_m3_feed.n2 psrg_m3_feed.n1 1.4405
R2561 psrg_m3_feed.n20 psrg_m3_feed.n18 1.1705
R2562 psrg_m3_feed.n22 psrg_m3_feed.n11 0.1805
R2563 vx2.n0 vx2.t6 39.3003
R2564 vx2.n8 vx2.n7 34.1431
R2565 vx2.n0 vx2.t7 19.4964
R2566 vx2.n2 vx2.n1 17.3255
R2567 vx2.n8 vx2.n2 13.8605
R2568 vx2.n6 vx2.t5 13.2762
R2569 vx2.n6 vx2.t4 12.7992
R2570 vx2.n3 vx2.t1 12.1962
R2571 vx2.n3 vx2.t0 11.7192
R2572 vx2.n1 vx2.n0 10.8905
R2573 vx2.n4 vx2.t3 10.5762
R2574 vx2.n4 vx2.t2 10.0992
R2575 vx2.n5 vx2.n3 9.61925
R2576 vx2.n1 vx2.t8 9.27752
R2577 vx2.n2 vx2.t9 9.27361
R2578 vx2.n7 vx2.n5 5.11925
R2579 vx2 vx2.t10 4.75991
R2580 vx2 vx2.n8 4.51028
R2581 vx2.n7 vx2.n6 4.5005
R2582 vx2.n5 vx2.n4 4.5005
R2583 vgn1.n3 vgn1.t9 119.844
R2584 vgn1.n7 vgn1.n6 46.8905
R2585 vgn1.n5 vgn1.t2 29.9964
R2586 vgn1.n6 vgn1.t0 28.6542
R2587 vgn1.n0 vgn1.t6 23.9614
R2588 vgn1 vgn1.n7 14.8603
R2589 vgn1.n4 vgn1.t1 13.9643
R2590 vgn1.n3 vgn1.t3 13.8744
R2591 vgn1.n0 vgn1.t4 13.7814
R2592 vgn1.n1 vgn1.t7 13.7775
R2593 vgn1.n2 vgn1.t8 13.7736
R2594 vgn1.n5 vgn1.n4 10.5755
R2595 vgn1.n2 vgn1.n1 4.8605
R2596 vgn1.n1 vgn1.n0 4.8155
R2597 vgn1 vgn1.t5 4.75991
R2598 vgn1.n7 vgn1.n2 2.4755
R2599 vgn1.n4 vgn1.n3 1.8905
R2600 vgn1.n6 vgn1.n5 0.5405
R2601 vx1.n8 vx1.n7 46.0231
R2602 vx1.n0 vx1.t6 37.6353
R2603 vx1.n1 vx1.n0 13.8605
R2604 vx1.n2 vx1.t9 13.8364
R2605 vx1.n4 vx1.t3 13.4562
R2606 vx1.n4 vx1.t2 13.3392
R2607 vx1 vx1.n8 12.137
R2608 vx1.n6 vx1.t5 11.8362
R2609 vx1.n6 vx1.t4 11.7192
R2610 vx1.n2 vx1.n1 10.6655
R2611 vx1.n3 vx1.t1 10.2162
R2612 vx1.n3 vx1.t0 10.0992
R2613 vx1.n0 vx1.t7 9.33641
R2614 vx1.n1 vx1.t8 9.33641
R2615 vx1.n5 vx1.n3 9.07925
R2616 vx1.n8 vx1.n2 5.5805
R2617 vx1.n7 vx1.n5 5.11925
R2618 vx1 vx1.t10 4.75991
R2619 vx1.n7 vx1.n6 4.5005
R2620 vx1.n5 vx1.n4 4.5005
R2621 su_state.n0 su_state.t1 133.207
R2622 su_state.n0 su_state.t0 72.447
R2623 su_state su_state.t2 5.6975
R2624 su_state su_state.n0 2.69913
R2625 vbp_tail.n11 vbp_tail.n10 76.0955
R2626 vbp_tail.n0 vbp_tail.t7 34.687
R2627 vbp_tail.n6 vbp_tail.t6 34.6554
R2628 vbp_tail.n2 vbp_tail.t10 32.3785
R2629 vbp_tail.n1 vbp_tail.t9 32.3515
R2630 vbp_tail.n0 vbp_tail.t8 32.3436
R2631 vbp_tail.n3 vbp_tail.t11 32.3337
R2632 vbp_tail.n4 vbp_tail.t13 31.2736
R2633 vbp_tail.n10 vbp_tail.t4 23.8189
R2634 vbp_tail vbp_tail.t12 23.284
R2635 vbp_tail.n4 vbp_tail.t0 23.1246
R2636 vbp_tail.n5 vbp_tail.t2 23.1102
R2637 vbp_tail.n6 vbp_tail.t1 15.0643
R2638 vbp_tail.n9 vbp_tail.t5 13.9935
R2639 vbp_tail.n8 vbp_tail.t3 13.8613
R2640 vbp_tail vbp_tail.n11 9.05298
R2641 vbp_tail.n9 vbp_tail.n8 2.4305
R2642 vbp_tail.n5 vbp_tail.n4 2.3405
R2643 vbp_tail.n11 vbp_tail.n3 2.3405
R2644 vbp_tail.n3 vbp_tail.n2 2.3405
R2645 vbp_tail.n1 vbp_tail.n0 2.3405
R2646 vbp_tail.n2 vbp_tail.n1 2.1605
R2647 vbp_tail.n7 vbp_tail.n5 1.7105
R2648 vbp_tail.n10 vbp_tail.n9 1.3505
R2649 vbp_tail.n8 vbp_tail.n7 0.8105
R2650 vbp_tail.n7 vbp_tail.n6 0.5405
R2651 vbp_bias.n12 vbp_bias.t10 25.8965
R2652 vbp_bias.n4 vbp_bias.t22 25.8785
R2653 vbp_bias.n0 vbp_bias.t9 25.7583
R2654 vbp_bias.n7 vbp_bias.t24 25.5095
R2655 vbp_bias.n5 vbp_bias.t26 25.469
R2656 vbp_bias.n13 vbp_bias.t14 25.4377
R2657 vbp_bias.n17 vbp_bias.t16 24.0965
R2658 vbp_bias.n4 vbp_bias.t20 23.1627
R2659 vbp_bias.n18 vbp_bias.t18 23.1573
R2660 vbp_bias.n12 vbp_bias.t12 23.1403
R2661 vbp_bias.n3 vbp_bias.t3 16.8291
R2662 vbp_bias.n21 vbp_bias.t0 15.8765
R2663 vbp_bias.n21 vbp_bias.n20 14.7155
R2664 vbp_bias.n13 vbp_bias.t15 14.6957
R2665 vbp_bias.n5 vbp_bias.t27 14.652
R2666 vbp_bias.n24 vbp_bias.n23 14.2205
R2667 vbp_bias.n2 vbp_bias.t6 13.9381
R2668 vbp_bias.n0 vbp_bias.t8 13.9381
R2669 vbp_bias.n20 vbp_bias.t17 13.887
R2670 vbp_bias.n1 vbp_bias.t7 13.8783
R2671 vbp_bias.n25 vbp_bias.t5 13.8783
R2672 vbp_bias.n16 vbp_bias.t11 13.867
R2673 vbp_bias.n3 vbp_bias.t2 13.8065
R2674 vbp_bias.n8 vbp_bias.t23 13.7957
R2675 vbp_bias.n9 vbp_bias.t21 13.7957
R2676 vbp_bias.n6 vbp_bias.t25 13.7481
R2677 vbp_bias.n11 vbp_bias.t19 13.7481
R2678 vbp_bias.n14 vbp_bias.t13 13.7311
R2679 vbp_bias vbp_bias.n25 12.047
R2680 vbp_bias.n2 vbp_bias.n1 11.8805
R2681 vbp_bias.n1 vbp_bias.n0 11.7005
R2682 vbp_bias.n23 vbp_bias.t1 9.26915
R2683 vbp_bias.n24 vbp_bias.n2 7.2005
R2684 vbp_bias vbp_bias.t4 4.72664
R2685 vbp_bias.n23 vbp_bias.n22 4.6355
R2686 vbp_bias.n25 vbp_bias.n24 4.5005
R2687 vbp_bias.n9 vbp_bias.n8 3.0605
R2688 vbp_bias.n17 vbp_bias.n16 2.7905
R2689 vbp_bias.n22 vbp_bias.n3 2.7905
R2690 vbp_bias.n19 vbp_bias.n18 2.2505
R2691 vbp_bias.n10 vbp_bias.n4 2.2505
R2692 vbp_bias.n15 vbp_bias.n12 2.2505
R2693 vbp_bias.n11 vbp_bias.n10 1.9805
R2694 vbp_bias.n8 vbp_bias.n7 1.9805
R2695 vbp_bias.n6 vbp_bias.n5 1.9805
R2696 vbp_bias.n14 vbp_bias.n13 1.9805
R2697 vbp_bias.n16 vbp_bias.n15 1.8905
R2698 vbp_bias.n20 vbp_bias.n19 1.8905
R2699 vbp_bias.n18 vbp_bias.n17 1.8005
R2700 vbp_bias.n15 vbp_bias.n14 0.9005
R2701 vbp_bias.n19 vbp_bias.n11 0.9005
R2702 vbp_bias.n22 vbp_bias.n21 0.9005
R2703 vbp_bias.n10 vbp_bias.n9 0.9005
R2704 vbp_bias.n7 vbp_bias.n6 0.9005
R2705 vbn_sink.n28 vbn_sink.n27 47.3855
R2706 vbn_sink.n24 vbn_sink.n23 46.8905
R2707 vbn_sink.n0 vbn_sink.t21 24.8377
R2708 vbn_sink.n4 vbn_sink.t27 24.8242
R2709 vbn_sink.n0 vbn_sink.t22 22.0027
R2710 vbn_sink.n2 vbn_sink.t24 22.0027
R2711 vbn_sink.n4 vbn_sink.t28 21.9892
R2712 vbn_sink.n6 vbn_sink.t30 21.9892
R2713 vbn_sink.n1 vbn_sink.t23 21.9577
R2714 vbn_sink.n3 vbn_sink.t25 21.9577
R2715 vbn_sink.n5 vbn_sink.t29 21.9442
R2716 vbn_sink.n7 vbn_sink.t31 21.9442
R2717 vbn_sink.n26 vbn_sink.t17 20.1359
R2718 vbn_sink.n24 vbn_sink.t15 20.0583
R2719 vbn_sink.n28 vbn_sink.t32 17.4892
R2720 vbn_sink.n8 vbn_sink.t20 16.863
R2721 vbn_sink.n13 vbn_sink.t1 16.6468
R2722 vbn_sink.n25 vbn_sink.t16 15.5285
R2723 vbn_sink.n27 vbn_sink.t18 15.5033
R2724 vbn_sink.n11 vbn_sink.t5 13.938
R2725 vbn_sink.n23 vbn_sink.t6 13.9355
R2726 vbn_sink.n22 vbn_sink.t13 13.8379
R2727 vbn_sink.n20 vbn_sink.t9 13.8379
R2728 vbn_sink.n13 vbn_sink.t2 13.8042
R2729 vbn_sink.n15 vbn_sink.t11 13.8042
R2730 vbn_sink.n9 vbn_sink.t8 13.803
R2731 vbn_sink.n21 vbn_sink.t14 13.8005
R2732 vbn_sink.n19 vbn_sink.t10 13.8005
R2733 vbn_sink.n14 vbn_sink.t3 13.7668
R2734 vbn_sink.n16 vbn_sink.t12 13.7668
R2735 vbn_sink.n8 vbn_sink.t7 13.7373
R2736 vbn_sink.n10 vbn_sink.t4 13.7373
R2737 vbn_sink vbn_sink.t26 12.8857
R2738 vbn_sink.n18 vbn_sink.n17 9.6755
R2739 vbn_sink.n12 vbn_sink.n11 9.6755
R2740 vbn_sink.n18 vbn_sink.t0 9.33792
R2741 vbn_sink.n12 vbn_sink.t19 9.30417
R2742 vbn_sink vbn_sink.n30 9.2975
R2743 vbn_sink.n19 vbn_sink.n18 7.3805
R2744 vbn_sink.n30 vbn_sink.n29 4.8605
R2745 vbn_sink.n17 vbn_sink.n12 4.6355
R2746 vbn_sink.n29 vbn_sink.n28 4.5005
R2747 vbn_sink.n16 vbn_sink.n15 3.0605
R2748 vbn_sink.n14 vbn_sink.n13 3.0605
R2749 vbn_sink.n10 vbn_sink.n9 3.0605
R2750 vbn_sink.n20 vbn_sink.n19 3.0605
R2751 vbn_sink.n22 vbn_sink.n21 3.0605
R2752 vbn_sink.n15 vbn_sink.n14 2.8805
R2753 vbn_sink.n9 vbn_sink.n8 2.8805
R2754 vbn_sink.n21 vbn_sink.n20 2.8805
R2755 vbn_sink.n29 vbn_sink.n7 2.8805
R2756 vbn_sink.n6 vbn_sink.n5 2.8805
R2757 vbn_sink.n2 vbn_sink.n1 2.8805
R2758 vbn_sink.n17 vbn_sink.n16 2.7905
R2759 vbn_sink.n11 vbn_sink.n10 2.7905
R2760 vbn_sink.n23 vbn_sink.n22 2.7905
R2761 vbn_sink.n7 vbn_sink.n6 2.7005
R2762 vbn_sink.n5 vbn_sink.n4 2.7005
R2763 vbn_sink.n30 vbn_sink.n3 2.7005
R2764 vbn_sink.n3 vbn_sink.n2 2.7005
R2765 vbn_sink.n1 vbn_sink.n0 2.7005
R2766 vbn_sink.n26 vbn_sink.n25 1.8005
R2767 vbn_sink.n27 vbn_sink.n26 1.0805
R2768 vbn_sink.n25 vbn_sink.n24 0.9005
R2769 b3_b b3_b.t2 413.057
R2770 b3_b.n0 b3_b.t0 29.9251
R2771 b3_b.n0 b3_b.t1 18.2995
R2772 b3_b b3_b.n0 11.9367
R2773 b1_b.n1 b1_b.t2 552.784
R2774 b1_b.n2 b1_b.t3 552.491
R2775 b1_b b1_b.t4 543.413
R2776 b1_b.n0 b1_b.t1 19.0513
R2777 b1_b.n0 b1_b.t0 17.9371
R2778 b1_b b1_b.n2 9.91021
R2779 b1_b.n1 b1_b.n0 7.6505
R2780 b1_b.n2 b1_b.n1 0.7205
R2781 b6_b b6_b.t2 70.8681
R2782 b6_b.n0 b6_b.t0 33.2506
R2783 b6_b.n0 b6_b.t1 26.6113
R2784 b6_b b6_b.n0 9.06575
R2785 b4_b b4_b.t2 217.519
R2786 b4_b.n0 b4_b.t1 38.4035
R2787 b4_b.n0 b4_b.t0 20.5606
R2788 b4_b b4_b.n0 19.2897
R2789 b0_b.n1 b0_b.t2 552.495
R2790 b0_b.n3 b0_b.t4 552.482
R2791 b0_b.n2 b0_b.t3 552.424
R2792 b0_b.n4 b0_b.t5 547.922
R2793 b0_b.n5 b0_b.t6 547.922
R2794 b0_b b0_b.t7 543.413
R2795 b0_b.n0 b0_b.t0 21.7749
R2796 b0_b.n0 b0_b.t1 18.3369
R2797 b0_b b0_b.n5 14.4612
R2798 b0_b.n5 b0_b.n4 10.0805
R2799 b0_b.n1 b0_b.n0 5.8055
R2800 b0_b.n4 b0_b.n3 5.4005
R2801 b0_b.n3 b0_b.n2 1.0805
R2802 b0_b.n2 b0_b.n1 1.0805
R2803 rbit0top.n1 rbit0top.t0 47.8149
R2804 rbit0top.n1 rbit0top.t1 27.35
R2805 rbit0top.n2 rbit0top.n1 24.7955
R2806 rbit0top.n0 rbit0top.t8 14.9729
R2807 rbit0top.n3 rbit0top.t2 13.6904
R2808 rbit0top.n0 rbit0top.t9 13.6898
R2809 rbit0top.n5 rbit0top.t4 13.6634
R2810 rbit0top.n7 rbit0top.t3 13.6544
R2811 rbit0top.n4 rbit0top.t6 13.6145
R2812 rbit0top rbit0top.n7 10.3573
R2813 rbit0top.n2 rbit0top.t7 9.11555
R2814 rbit0top.n3 rbit0top.n2 5.7605
R2815 rbit0top rbit0top.t5 4.60718
R2816 rbit0top.n6 rbit0top.n0 3.3178
R2817 rbit0top.n5 rbit0top.n4 1.2605
R2818 rbit0top.n4 rbit0top.n3 1.0805
R2819 rbit0top.n6 rbit0top.n5 0.6755
R2820 rbit0top.n7 rbit0top.n6 0.1355
R2821 rbit1top.n2 rbit1top.n1 31.7705
R2822 rbit1top.n1 rbit1top.t9 22.274
R2823 rbit1top.n0 rbit1top.t8 14.8598
R2824 rbit1top.n7 rbit1top.t5 13.8254
R2825 rbit1top.n9 rbit1top.t3 13.7984
R2826 rbit1top.n10 rbit1top.t2 13.7894
R2827 rbit1top.n2 rbit1top.t10 13.7888
R2828 rbit1top.n0 rbit1top.t7 13.7579
R2829 rbit1top.n8 rbit1top.t4 13.7495
R2830 rbit1top.n3 rbit1top.t11 13.6949
R2831 rbit1top.n5 rbit1top.t12 13.6724
R2832 rbit1top.n6 rbit1top.t6 13.6155
R2833 rbit1top.n4 rbit1top.t13 13.6152
R2834 rbit1top.n11 rbit1top.n0 10.3055
R2835 rbit1top.n1 rbit1top.t0 10.142
R2836 rbit1top rbit1top.n11 9.00729
R2837 rbit1top rbit1top.t1 4.60718
R2838 rbit1top.n3 rbit1top.n2 1.5305
R2839 rbit1top.n5 rbit1top.n4 1.2605
R2840 rbit1top.n4 rbit1top.n3 1.2605
R2841 rbit1top.n11 rbit1top.n10 1.2155
R2842 rbit1top.n7 rbit1top.n6 1.1705
R2843 rbit1top.n6 rbit1top.n5 1.0805
R2844 rbit1top.n9 rbit1top.n8 1.0805
R2845 rbit1top.n10 rbit1top.n9 0.9005
R2846 rbit1top.n8 rbit1top.n7 0.9005
R2847 rbit2top.n1 rbit2top.n0 34.9521
R2848 rbit2top.n0 rbit2top.t5 25.739
R2849 rbit2top.n4 rbit2top.t3 15.0003
R2850 rbit2top.n5 rbit2top.t2 13.9426
R2851 rbit2top.n4 rbit2top.t4 13.9336
R2852 rbit2top.n6 rbit2top.t0 13.8011
R2853 rbit2top.n3 rbit2top.t8 13.7502
R2854 rbit2top.n2 rbit2top.t9 13.6949
R2855 rbit2top.n7 rbit2top.n6 11.9255
R2856 rbit2top.n6 rbit2top.n5 10.6655
R2857 rbit2top.n0 rbit2top.t1 10.106
R2858 rbit2top rbit2top.n7 9.20075
R2859 rbit2top.n1 rbit2top.t6 9.11557
R2860 rbit2top.n2 rbit2top.n1 5.5805
R2861 rbit2top rbit2top.t7 4.60718
R2862 rbit2top.n3 rbit2top.n2 1.1705
R2863 rbit2top.n7 rbit2top.n3 1.0805
R2864 rbit2top.n5 rbit2top.n4 0.9005
R2865 b2_b.n1 b2_b.t2 291.709
R2866 b2_b.n2 b2_b.t3 291.709
R2867 b2_b b2_b.t4 282.7
R2868 b2_b.n0 b2_b.t0 29.7878
R2869 b2_b.n1 b2_b.n0 29.7455
R2870 b2_b b2_b.n2 9.96125
R2871 b2_b.n0 b2_b.t1 9.37191
R2872 b2_b.n2 b2_b.n1 1.0805
R2873 rbit6top.n2 rbit6top.t0 20.1082
R2874 rbit6top rbit6top.n3 16.4243
R2875 rbit6top.n2 rbit6top.t3 16.2905
R2876 rbit6top.n3 rbit6top.n0 11.2267
R2877 rbit6top.n3 rbit6top.t4 10.197
R2878 rbit6top.n1 rbit6top.n2 9.5405
R2879 rbit6top.n1 rbit6top.t5 9.02203
R2880 rbit6top.n1 rbit6top.n0 4.4644
R2881 rbit6top rbit6top.t2 5.06817
R2882 rbit6top.n0 rbit6top.t1 17.5032
R2883 rbit5top.n2 rbit5top.n1 30.1505
R2884 rbit5top rbit5top.t0 29.2375
R2885 rbit5top.n1 rbit5top.t5 28.961
R2886 rbit5top rbit5top.n2 16.7383
R2887 rbit5top.n2 rbit5top.n0 12.9155
R2888 rbit5top.n0 rbit5top.t2 11.3205
R2889 rbit5top.n0 rbit5top.t3 9.9581
R2890 rbit5top.n1 rbit5top.t4 5.59703
R2891 rbit5top rbit5top.t1 4.78433
R2892 b5_b b5_b.t2 119.752
R2893 b5_b b5_b.n0 34.8211
R2894 b5_b.n0 b5_b.t0 31.9875
R2895 b5_b.n0 b5_b.t1 9.33465
R2896 rbit3top.n3 rbit3top.n0 34.6609
R2897 rbit3top.n0 rbit3top.t2 21.3044
R2898 rbit3top.n1 rbit3top.t7 18.735
R2899 rbit3top.n0 rbit3top.t6 15.732
R2900 rbit3top.n5 rbit3top.n4 15.2105
R2901 rbit3top.n1 rbit3top.t3 13.9653
R2902 rbit3top.n4 rbit3top.t5 13.8076
R2903 rbit3top.n2 rbit3top.t4 13.7986
R2904 rbit3top rbit3top.n5 12.5895
R2905 rbit3top.n5 rbit3top.t0 9.43613
R2906 rbit3top rbit3top.t1 4.64242
R2907 rbit3top.n2 rbit3top.n1 1.0805
R2908 rbit3top.n3 rbit3top.n2 0.9905
R2909 rbit3top.n4 rbit3top.n3 0.1355
R2910 rbit4top.n2 rbit4top.t4 31.67
R2911 rbit4top.n3 rbit4top.n2 20.2505
R2912 rbit4top.n0 rbit4top.t5 17.61
R2913 rbit4top.n1 rbit4top.n0 17.0555
R2914 rbit4top.n0 rbit4top.t1 14.5188
R2915 rbit4top.n1 rbit4top.t0 13.9981
R2916 rbit4top.n3 rbit4top.n1 12.2405
R2917 rbit4top.n2 rbit4top.t3 10.097
R2918 rbit4top rbit4top.t2 4.64242
R2919 rbit4top rbit4top.n3 4.53446
R2920 vbn_fold.n13 vbn_fold.n12 129.555
R2921 vbn_fold.n1 vbn_fold.n0 44.9105
R2922 vbn_fold.n1 vbn_fold.t14 25.9901
R2923 vbn_fold.n0 vbn_fold.t12 17.6066
R2924 vbn_fold vbn_fold.t15 16.9451
R2925 vbn_fold.n2 vbn_fold.t10 16.6249
R2926 vbn_fold.n0 vbn_fold.t13 16.0915
R2927 vbn_fold.n6 vbn_fold.t4 13.9378
R2928 vbn_fold.n12 vbn_fold.t0 13.8799
R2929 vbn_fold.n2 vbn_fold.t11 13.8028
R2930 vbn_fold.n4 vbn_fold.t5 13.8028
R2931 vbn_fold.n9 vbn_fold.t3 13.8028
R2932 vbn_fold.n11 vbn_fold.t1 13.8028
R2933 vbn_fold.n3 vbn_fold.t6 13.7449
R2934 vbn_fold.n5 vbn_fold.t7 13.7449
R2935 vbn_fold.n8 vbn_fold.t8 13.7449
R2936 vbn_fold.n10 vbn_fold.t2 13.7449
R2937 vbn_fold.n7 vbn_fold.n6 9.6755
R2938 vbn_fold.n7 vbn_fold.t9 9.30284
R2939 vbn_fold vbn_fold.n13 9.0455
R2940 vbn_fold.n8 vbn_fold.n7 7.3805
R2941 vbn_fold.n11 vbn_fold.n10 3.0605
R2942 vbn_fold.n9 vbn_fold.n8 3.0605
R2943 vbn_fold.n5 vbn_fold.n4 3.0605
R2944 vbn_fold.n3 vbn_fold.n2 3.0605
R2945 vbn_fold.n10 vbn_fold.n9 2.8805
R2946 vbn_fold.n4 vbn_fold.n3 2.8805
R2947 vbn_fold.n12 vbn_fold.n11 2.7905
R2948 vbn_fold.n6 vbn_fold.n5 2.7905
R2949 vbn_fold.n13 vbn_fold.n1 2.3405
R2950 vbn_i.n1 vbn_i.n0 128.25
R2951 vbn_i.n6 vbn_i.n5 61.5605
R2952 vbn_i.n0 vbn_i.t5 25.027
R2953 vbn_i.n4 vbn_i.t10 18.7019
R2954 vbn_i.n0 vbn_i.t8 18.4407
R2955 vbn_i.n2 vbn_i.t1 18.0635
R2956 vbn_i.n3 vbn_i.t9 16.3752
R2957 vbn_i.n9 vbn_i.n8 16.2005
R2958 vbn_i vbn_i.n9 14.8944
R2959 vbn_i.n9 vbn_i.t0 13.8164
R2960 vbn_i.n8 vbn_i.t4 13.8164
R2961 vbn_i.n7 vbn_i.t7 13.7791
R2962 vbn_i.n7 vbn_i.n6 13.1405
R2963 vbn_i.n2 vbn_i.n1 11.0705
R2964 vbn_i.n5 vbn_i.t11 10.307
R2965 vbn_i.n3 vbn_i.n2 9.6755
R2966 vbn_i.n6 vbn_i.t6 9.31644
R2967 vbn_i.n4 vbn_i.n3 8.8205
R2968 vbn_i.n5 vbn_i.n4 7.0205
R2969 vbn_i.n1 vbn_i.t2 5.16057
R2970 vbn_i vbn_i.t3 4.72757
R2971 vbn_i.n8 vbn_i.n7 2.8805
R2972 vbp_i.n0 vbp_i.t11 313.841
R2973 vbp_i.n0 vbp_i.t12 312.521
R2974 vbp_i.n7 vbp_i.t19 31.7827
R2975 vbp_i.n2 vbp_i.t14 31.6027
R2976 vbp_i.n4 vbp_i.t16 31.6027
R2977 vbp_i.n6 vbp_i.t18 31.6027
R2978 vbp_i.n1 vbp_i.t13 31.5532
R2979 vbp_i.n3 vbp_i.t15 31.5532
R2980 vbp_i.n5 vbp_i.t17 31.5532
R2981 vbp_i.n12 vbp_i.t23 26.033
R2982 vbp_i.n16 vbp_i.t29 26.0263
R2983 vbp_i.n23 vbp_i.t40 26.0198
R2984 vbp_i.n27 vbp_i.t46 26.0198
R2985 vbp_i.n32 vbp_i.t56 25.9418
R2986 vbp_i.n20 vbp_i.t35 25.8215
R2987 vbp_i.n54 vbp_i.n11 23.6705
R2988 vbp_i.n12 vbp_i.t24 23.153
R2989 vbp_i.n13 vbp_i.t25 23.153
R2990 vbp_i.n14 vbp_i.t26 23.153
R2991 vbp_i.n15 vbp_i.t27 23.153
R2992 vbp_i.n16 vbp_i.t30 23.1463
R2993 vbp_i.n17 vbp_i.t31 23.1463
R2994 vbp_i.n18 vbp_i.t32 23.1463
R2995 vbp_i.n19 vbp_i.t33 23.1463
R2996 vbp_i.n52 vbp_i.t34 23.1463
R2997 vbp_i.n23 vbp_i.t41 23.1398
R2998 vbp_i.n24 vbp_i.t42 23.1398
R2999 vbp_i.n25 vbp_i.t43 23.1398
R3000 vbp_i.n26 vbp_i.t44 23.1398
R3001 vbp_i.n48 vbp_i.t45 23.1398
R3002 vbp_i.n28 vbp_i.t48 23.1398
R3003 vbp_i.n30 vbp_i.t50 23.1398
R3004 vbp_i.n27 vbp_i.t47 23.1398
R3005 vbp_i.n29 vbp_i.t49 23.1398
R3006 vbp_i.n31 vbp_i.t51 23.1398
R3007 vbp_i.n20 vbp_i.t36 23.1215
R3008 vbp_i.n21 vbp_i.t37 23.1215
R3009 vbp_i.n22 vbp_i.t38 23.1215
R3010 vbp_i.n50 vbp_i.t39 23.1215
R3011 vbp_i.n37 vbp_i.t5 23.0618
R3012 vbp_i.n35 vbp_i.t3 23.0618
R3013 vbp_i.n34 vbp_i.t55 23.0618
R3014 vbp_i.n32 vbp_i.t1 23.0618
R3015 vbp_i.n45 vbp_i.t52 23.0618
R3016 vbp_i.n42 vbp_i.t9 23.0618
R3017 vbp_i.n41 vbp_i.t7 23.0618
R3018 vbp_i.n40 vbp_i.t53 23.0618
R3019 vbp_i.n39 vbp_i.t54 23.0618
R3020 vbp_i.n10 vbp_i.n9 21.3755
R3021 vbp_i.n11 vbp_i.n10 21.3305
R3022 vbp_i.n49 vbp_i.n48 18.0005
R3023 vbp_i.n1 vbp_i.n0 17.0105
R3024 vbp_i.n43 vbp_i.t8 16.6064
R3025 vbp_i.n38 vbp_i.t6 15.9314
R3026 vbp_i.n36 vbp_i.t4 15.8941
R3027 vbp_i.n33 vbp_i.t2 15.8941
R3028 vbp_i.n11 vbp_i.t22 14.9342
R3029 vbp_i vbp_i.t28 14.0765
R3030 vbp_i.n10 vbp_i.t0 14.0571
R3031 vbp_i.n9 vbp_i.t21 14.0084
R3032 vbp_i.n43 vbp_i.t10 13.9141
R3033 vbp_i.n8 vbp_i.t20 13.8092
R3034 vbp_i.n46 vbp_i.n45 13.7705
R3035 vbp_i vbp_i.n54 9.077
R3036 vbp_i.n53 vbp_i.n52 5.5805
R3037 vbp_i.n51 vbp_i.n50 5.4005
R3038 vbp_i.n7 vbp_i.n6 5.2205
R3039 vbp_i.n39 vbp_i.n38 4.8605
R3040 vbp_i.n46 vbp_i.n31 4.4105
R3041 vbp_i.n40 vbp_i.n39 2.8805
R3042 vbp_i.n42 vbp_i.n41 2.8805
R3043 vbp_i.n35 vbp_i.n34 2.8805
R3044 vbp_i.n25 vbp_i.n24 2.8805
R3045 vbp_i.n21 vbp_i.n20 2.8805
R3046 vbp_i.n18 vbp_i.n17 2.8805
R3047 vbp_i.n14 vbp_i.n13 2.8805
R3048 vbp_i.n31 vbp_i.n30 2.8805
R3049 vbp_i.n29 vbp_i.n28 2.8805
R3050 vbp_i.n41 vbp_i.n40 2.7005
R3051 vbp_i.n47 vbp_i.n26 2.7005
R3052 vbp_i.n26 vbp_i.n25 2.7005
R3053 vbp_i.n24 vbp_i.n23 2.7005
R3054 vbp_i.n22 vbp_i.n21 2.7005
R3055 vbp_i.n51 vbp_i.n19 2.7005
R3056 vbp_i.n19 vbp_i.n18 2.7005
R3057 vbp_i.n17 vbp_i.n16 2.7005
R3058 vbp_i.n53 vbp_i.n15 2.7005
R3059 vbp_i.n15 vbp_i.n14 2.7005
R3060 vbp_i.n13 vbp_i.n12 2.7005
R3061 vbp_i.n30 vbp_i.n29 2.7005
R3062 vbp_i.n28 vbp_i.n27 2.7005
R3063 vbp_i.n8 vbp_i.n7 2.2055
R3064 vbp_i.n6 vbp_i.n5 1.9805
R3065 vbp_i.n4 vbp_i.n3 1.9805
R3066 vbp_i.n2 vbp_i.n1 1.9805
R3067 vbp_i.n44 vbp_i.n43 1.8905
R3068 vbp_i.n45 vbp_i.n44 1.8005
R3069 vbp_i.n34 vbp_i.n33 1.8005
R3070 vbp_i.n37 vbp_i.n36 1.8005
R3071 vbp_i.n49 vbp_i.n22 1.8005
R3072 vbp_i.n5 vbp_i.n4 1.8005
R3073 vbp_i.n3 vbp_i.n2 1.8005
R3074 vbp_i.n9 vbp_i.n8 1.6655
R3075 vbp_i.n38 vbp_i.n37 1.0805
R3076 vbp_i.n50 vbp_i.n49 1.0805
R3077 vbp_i.n47 vbp_i.n46 0.9905
R3078 vbp_i.n44 vbp_i.n42 0.9005
R3079 vbp_i.n33 vbp_i.n32 0.9005
R3080 vbp_i.n36 vbp_i.n35 0.9005
R3081 vbp_i.n48 vbp_i.n47 0.1805
R3082 vbp_i.n52 vbp_i.n51 0.1805
R3083 vbp_i.n54 vbp_i.n53 0.1805
Cconserve0 aux_gate avdd 1.24002e-14
Cconserve1 aux_gate iref_gate 1.57958e-14
Cconserve2 aux_gate pm2 1.57445e-15
Cconserve3 aux_gate psrg_m3_feed 2.9788e-16
Cconserve4 aux_gate su_state 4.5769e-16
Cconserve5 aux_gate vbn 1.3619e-16
Cconserve6 aux_gate vbn_fold 4.71041e-15
Cconserve7 aux_gate vbn_i 5.512e-16
Cconserve8 aux_gate vbp_bias 1.42034e-15
Cconserve9 aux_gate vgn1 1.1942e-16
Cconserve10 aux_gate vgn2 2.7644e-16
Cconserve11 aux_gate vref 4.9479e-16
Cconserve12 aux_gate vsu 2.354e-16
Cconserve13 aux_gate xf1 1.6199e-16
Cconserve14 aux_gate xf2 4.88286e-15
Cconserve15 auxsu2 auxsu1 2.0281e-16
Cconserve16 avdd auxsu1 1.24345e-15
Cconserve17 auxsu1 bgsu1 7.94465e-15
Cconserve18 auxsu1 bgsu2 2.998e-16
Cconserve19 auxsu1 psrg_m3_feed 3.6042e-16
Cconserve20 psrg_vnc auxsu1 2.1772e-16
Cconserve21 rb_mid auxsu1 1.5762e-16
Cconserve22 auxsu1 vbn 1.29764e-14
Cconserve23 vcasp auxsu1 4.5235e-16
Cconserve24 auxsu1 vgn1 1.004e-16
Cconserve25 auxsu1 vgn2 1.2252e-16
Cconserve26 auxsu1 vnx_bias 2.31588e-15
Cconserve27 vsu auxsu1 1.0019e-16
Cconserve28 vsu2 auxsu1 3.4171e-16
Cconserve29 vsua auxsu1 1.181e-16
Cconserve30 vsu2 auxsu2 3.506e-16
Cconserve31 avdd avss 2.2416499450069e-14
Cconserve32 avdd.n0 avss 5.9777028368939e-18
Cconserve33 avdd.n1 avss 2.4108436408196e-18
Cconserve34 avdd.n2 avss 1.3659083208989e-18
Cconserve35 avdd.n4 avss 4.082222608887e-18
Cconserve36 avdd.n5 avss 1.3897488804669e-18
Cconserve37 avdd.n6 avss 1.3897488804669e-18
Cconserve38 avdd.n7 avss 2.1189824789119e-18
Cconserve39 avdd.n8 avss 2.0891039082774e-18
Cconserve40 avdd.n9 avss 4.4146007418796e-18
Cconserve41 avdd.n10 avss 2.6295538194497e-18
Cconserve42 avdd.n12 avss 1.6581528485885e-18
Cconserve43 avdd.n13 avss 1.6438005921249e-18
Cconserve44 avdd.n14 avss 1.6438005921249e-18
Cconserve45 avdd.n15 avss 1.6438005921249e-18
Cconserve46 avdd.n16 avss 3.0696816975452e-18
Cconserve47 avdd.n17 avss 2.8798677147332e-18
Cconserve48 avdd.n18 avss 2.9145143972813e-18
Cconserve49 avdd.n19 avss 5.3697565877286e-18
Cconserve50 avdd.n20 avss 5.4118309823029e-18
Cconserve51 avdd.n21 avss 5.4119987048326e-18
Cconserve52 avdd.n22 avss 3.9759104854666e-18
Cconserve53 avdd.n23 avss 3.9750958331799e-18
Cconserve54 avdd.n25 avss 3.259807165055e-19
Cconserve55 avdd.n26 avss 1.6904993364446e-18
Cconserve56 avdd.n28 avss 4.2579958199333e-18
Cconserve57 avdd.n29 avss 1.453986609313e-18
Cconserve58 avdd.n30 avss 8.6281261311011e-19
Cconserve59 avdd.n31 avss 1.453986609313e-18
Cconserve60 avdd.n32 avss 8.6281261311011e-19
Cconserve61 avdd.n33 avss 1.453986609313e-18
Cconserve62 avdd.n34 avss 8.6281261311011e-19
Cconserve63 avdd.n35 avss 1.453986609313e-18
Cconserve64 avdd.n36 avss 8.6281261311011e-19
Cconserve65 avdd.n37 avss 1.453986609313e-18
Cconserve66 avdd.n38 avss 8.6281261311011e-19
Cconserve67 avdd.n39 avss 1.453986609313e-18
Cconserve68 avdd.n40 avss 6.6645745164282e-19
Cconserve69 avdd.n41 avss 1.453986609313e-18
Cconserve70 avdd.n42 avss 9.6368573449844e-19
Cconserve71 avdd.n43 avss 1.453986609313e-18
Cconserve72 avdd.n44 avss 6.6636161019732e-19
Cconserve73 avdd.n45 avss 1.453986609313e-18
Cconserve74 avdd.n46 avss 8.6211776263024e-19
Cconserve75 avdd.n47 avss 1.453986609313e-18
Cconserve76 avdd.n48 avss 6.6693665887031e-19
Cconserve77 avdd.n49 avss 1.453986609313e-18
Cconserve78 avdd.n50 avss 6.6636161019732e-19
Cconserve79 avdd.n51 avss 1.453986609313e-18
Cconserve80 avdd.n52 avss 8.6211776263024e-19
Cconserve81 avdd.n53 avss 1.453986609313e-18
Cconserve82 avdd.n54 avss 8.6211776263024e-19
Cconserve83 avdd.n55 avss 1.453986609313e-18
Cconserve84 avdd.n56 avss 8.6211776263024e-19
Cconserve85 avdd.n57 avss 1.453986609313e-18
Cconserve86 avdd.n58 avss 6.652354732127e-19
Cconserve87 avdd.n59 avss 1.453986609313e-18
Cconserve88 avdd.n60 avss 9.6473999039893e-19
Cconserve89 avdd.n61 avss 1.453986609313e-18
Cconserve90 avdd.n62 avss 6.6521151285132e-19
Cconserve91 avdd.n63 avss 1.453986609313e-18
Cconserve92 avdd.n64 avss 8.9630919831222e-19
Cconserve93 avdd.n65 avss 1.453986609313e-18
Cconserve94 avdd.n66 avss 8.9573414963922e-19
Cconserve95 avdd.n67 avss 1.453986609313e-18
Cconserve96 avdd.n68 avss 6.6521151285132e-19
Cconserve97 avdd.n69 avss 1.453986609313e-18
Cconserve98 avdd.n70 avss 6.6645745164282e-19
Cconserve99 avdd.n71 avss 1.453986609313e-18
Cconserve100 avdd.n72 avss 6.6645745164282e-19
Cconserve101 avdd.n73 avss 3.6557521367752e-18
Cconserve102 avdd.t525 avss 1.1012900898745e-18
Cconserve103 avdd.t526 avss 1.1012900898745e-18
Cconserve104 avdd.n74 avss 5.7856126197514e-18
Cconserve105 avdd.n75 avss 3.6557521367752e-18
Cconserve106 avdd.t521 avss 1.1012900898745e-18
Cconserve107 avdd.t522 avss 1.1012900898745e-18
Cconserve108 avdd.n76 avss 5.7856126197514e-18
Cconserve109 avdd.n77 avss 3.6557521367752e-18
Cconserve110 avdd.t517 avss 1.1012900898745e-18
Cconserve111 avdd.t518 avss 1.1012900898745e-18
Cconserve112 avdd.n78 avss 5.7856126197514e-18
Cconserve113 avdd.n79 avss 3.6557521367752e-18
Cconserve114 avdd.t513 avss 1.1012900898745e-18
Cconserve115 avdd.t514 avss 1.1012900898745e-18
Cconserve116 avdd.n80 avss 5.7856126197514e-18
Cconserve117 avdd.n81 avss 3.6557521367752e-18
Cconserve118 avdd.t509 avss 1.1012900898745e-18
Cconserve119 avdd.t510 avss 1.1012900898745e-18
Cconserve120 avdd.n82 avss 5.7856126197514e-18
Cconserve121 avdd.n83 avss 3.6557521367752e-18
Cconserve122 avdd.t505 avss 1.1012900898745e-18
Cconserve123 avdd.t506 avss 1.1012900898745e-18
Cconserve124 avdd.n84 avss 5.7856126197514e-18
Cconserve125 avdd.n85 avss 3.6557521367752e-18
Cconserve126 avdd.t501 avss 1.1012900898745e-18
Cconserve127 avdd.t502 avss 1.1012900898745e-18
Cconserve128 avdd.n86 avss 5.7856126197514e-18
Cconserve129 avdd.n87 avss 3.6557521367752e-18
Cconserve130 avdd.t497 avss 1.1012900898745e-18
Cconserve131 avdd.t498 avss 1.1012900898745e-18
Cconserve132 avdd.n88 avss 5.7856126197514e-18
Cconserve133 avdd.n89 avss 3.6557521367752e-18
Cconserve134 avdd.t493 avss 1.1012900898745e-18
Cconserve135 avdd.t494 avss 1.1012900898745e-18
Cconserve136 avdd.n90 avss 5.7856126197514e-18
Cconserve137 avdd.n91 avss 3.6557521367752e-18
Cconserve138 avdd.t489 avss 1.1012900898745e-18
Cconserve139 avdd.t490 avss 1.1012900898745e-18
Cconserve140 avdd.n92 avss 5.7856126197514e-18
Cconserve141 avdd.n93 avss 3.6557521367752e-18
Cconserve142 avdd.t485 avss 1.1012900898745e-18
Cconserve143 avdd.t486 avss 1.1012900898745e-18
Cconserve144 avdd.n94 avss 5.7856126197514e-18
Cconserve145 avdd.n95 avss 3.6557521367752e-18
Cconserve146 avdd.t481 avss 1.1012900898745e-18
Cconserve147 avdd.t482 avss 1.1012900898745e-18
Cconserve148 avdd.n96 avss 5.7856126197514e-18
Cconserve149 avdd.n97 avss 3.6557521367752e-18
Cconserve150 avdd.t477 avss 1.1012900898745e-18
Cconserve151 avdd.t478 avss 1.1012900898745e-18
Cconserve152 avdd.n98 avss 5.7856126197514e-18
Cconserve153 avdd.n99 avss 2.4002292007305e-18
Cconserve154 avdd.n100 avss 1.8914788476573e-18
Cconserve155 avdd.n101 avss 2.4002292007305e-18
Cconserve156 avdd.n102 avss 1.4327337687735e-18
Cconserve157 avdd.n103 avss 2.4002292007305e-18
Cconserve158 avdd.n104 avss 1.4327337687735e-18
Cconserve159 avdd.n105 avss 2.4002292007305e-18
Cconserve160 avdd.n106 avss 1.4327337687735e-18
Cconserve161 avdd.n107 avss 2.4002292007305e-18
Cconserve162 avdd.n108 avss 1.4327337687735e-18
Cconserve163 avdd.n109 avss 2.4002292007305e-18
Cconserve164 avdd.n110 avss 1.4327337687735e-18
Cconserve165 avdd.n111 avss 2.4002292007305e-18
Cconserve166 avdd.n112 avss 1.4327337687735e-18
Cconserve167 avdd.n113 avss 2.4002292007305e-18
Cconserve168 avdd.n114 avss 1.4327337687735e-18
Cconserve169 avdd.n115 avss 2.4002292007305e-18
Cconserve170 avdd.n116 avss 1.9062623906256e-18
Cconserve171 avdd.n117 avss 2.4002292007305e-18
Cconserve172 avdd.n118 avss 1.8914788476573e-18
Cconserve173 avdd.n119 avss 2.4002292007305e-18
Cconserve174 avdd.n120 avss 1.4327337687735e-18
Cconserve175 avdd.n121 avss 2.4002292007305e-18
Cconserve176 avdd.n122 avss 1.4327337687735e-18
Cconserve177 avdd.n123 avss 2.4002292007305e-18
Cconserve178 avdd.n124 avss 1.8914788476573e-18
Cconserve179 avdd.n125 avss 2.4002292007305e-18
Cconserve180 avdd.n126 avss 1.4327337687735e-18
Cconserve181 avdd.n127 avss 2.4002292007305e-18
Cconserve182 avdd.n128 avss 1.4327337687735e-18
Cconserve183 avdd.n129 avss 2.4002292007305e-18
Cconserve184 avdd.n130 avss 1.4327337687735e-18
Cconserve185 avdd.n131 avss 2.4002292007305e-18
Cconserve186 avdd.n132 avss 1.4327337687735e-18
Cconserve187 avdd.n133 avss 2.4002292007305e-18
Cconserve188 avdd.n134 avss 1.9246399878001e-18
Cconserve189 avdd.n135 avss 2.4002292007305e-18
Cconserve190 avdd.n136 avss 1.9284736456201e-18
Cconserve191 avdd.n137 avss 2.4002292007305e-18
Cconserve192 avdd.n138 avss 1.4327337687735e-18
Cconserve193 avdd.t705 avss 7.977817963025e-18
Cconserve194 avdd.n139 avss 3.6557521367752e-18
Cconserve195 avdd.t661 avss 1.1012900898745e-18
Cconserve196 avdd.t662 avss 1.1012900898745e-18
Cconserve197 avdd.n140 avss 5.7856126197514e-18
Cconserve198 avdd.n141 avss 6.2942671313791e-18
Cconserve199 avdd.t665 avss 1.1012900898745e-18
Cconserve200 avdd.t666 avss 1.1012900898745e-18
Cconserve201 avdd.n142 avss 5.7856126197514e-18
Cconserve202 avdd.n143 avss 3.6557521367752e-18
Cconserve203 avdd.t669 avss 1.1012900898745e-18
Cconserve204 avdd.t670 avss 1.1012900898745e-18
Cconserve205 avdd.n144 avss 5.7856126197514e-18
Cconserve206 avdd.n145 avss 3.6557521367752e-18
Cconserve207 avdd.t752 avss 1.1012900898745e-18
Cconserve208 avdd.t753 avss 1.1012900898745e-18
Cconserve209 avdd.n146 avss 5.7856126197514e-18
Cconserve210 avdd.n147 avss 3.6557521367752e-18
Cconserve211 avdd.t748 avss 1.1012900898745e-18
Cconserve212 avdd.t749 avss 1.1012900898745e-18
Cconserve213 avdd.n148 avss 5.7856126197514e-18
Cconserve214 avdd.n149 avss 3.6557521367752e-18
Cconserve215 avdd.t744 avss 1.1012900898745e-18
Cconserve216 avdd.t745 avss 1.1012900898745e-18
Cconserve217 avdd.n150 avss 5.7856126197514e-18
Cconserve218 avdd.n151 avss 3.6557521367752e-18
Cconserve219 avdd.t740 avss 1.1012900898745e-18
Cconserve220 avdd.t741 avss 1.1012900898745e-18
Cconserve221 avdd.n152 avss 5.7856126197514e-18
Cconserve222 avdd.n153 avss 3.6557521367752e-18
Cconserve223 avdd.t736 avss 1.1012900898745e-18
Cconserve224 avdd.t737 avss 1.1012900898745e-18
Cconserve225 avdd.n154 avss 5.7856126197514e-18
Cconserve226 avdd.n155 avss 3.6557521367752e-18
Cconserve227 avdd.t732 avss 1.1012900898745e-18
Cconserve228 avdd.t733 avss 1.1012900898745e-18
Cconserve229 avdd.n156 avss 5.7856126197514e-18
Cconserve230 avdd.n157 avss 3.6557521367752e-18
Cconserve231 avdd.t728 avss 1.1012900898745e-18
Cconserve232 avdd.t729 avss 1.1012900898745e-18
Cconserve233 avdd.n158 avss 5.7856126197514e-18
Cconserve234 avdd.n159 avss 3.6557521367752e-18
Cconserve235 avdd.t724 avss 1.1012900898745e-18
Cconserve236 avdd.t725 avss 1.1012900898745e-18
Cconserve237 avdd.n160 avss 5.7856126197514e-18
Cconserve238 avdd.n161 avss 3.6557521367752e-18
Cconserve239 avdd.t720 avss 1.1012900898745e-18
Cconserve240 avdd.t721 avss 1.1012900898745e-18
Cconserve241 avdd.n162 avss 5.7856126197514e-18
Cconserve242 avdd.n163 avss 3.6557521367752e-18
Cconserve243 avdd.t716 avss 1.1012900898745e-18
Cconserve244 avdd.t717 avss 1.1012900898745e-18
Cconserve245 avdd.n164 avss 5.7856126197514e-18
Cconserve246 avdd.n165 avss 3.6557521367752e-18
Cconserve247 avdd.t712 avss 1.1012900898745e-18
Cconserve248 avdd.t713 avss 1.1012900898745e-18
Cconserve249 avdd.n166 avss 5.7856126197514e-18
Cconserve250 avdd.n167 avss 3.6557521367752e-18
Cconserve251 avdd.t708 avss 1.1012900898745e-18
Cconserve252 avdd.t709 avss 1.1012900898745e-18
Cconserve253 avdd.n168 avss 5.7856126197514e-18
Cconserve254 avdd.n169 avss 1.9660914129787e-18
Cconserve255 avdd.n170 avss 1.1541466470675e-18
Cconserve256 avdd.n171 avss 1.9660914129787e-18
Cconserve257 avdd.n172 avss 1.1541466470675e-18
Cconserve258 avdd.n173 avss 1.9660914129787e-18
Cconserve259 avdd.n174 avss 1.1541466470675e-18
Cconserve260 avdd.n175 avss 1.9660914129787e-18
Cconserve261 avdd.n176 avss 1.1541466470675e-18
Cconserve262 avdd.n177 avss 1.9660914129787e-18
Cconserve263 avdd.n178 avss 1.1541466470675e-18
Cconserve264 avdd.n179 avss 1.9660914129787e-18
Cconserve265 avdd.n180 avss 1.1541466470675e-18
Cconserve266 avdd.n181 avss 1.9660914129787e-18
Cconserve267 avdd.n182 avss 1.1541466470675e-18
Cconserve268 avdd.n183 avss 1.9660914129787e-18
Cconserve269 avdd.n184 avss 1.1541466470675e-18
Cconserve270 avdd.n185 avss 1.9660914129787e-18
Cconserve271 avdd.n186 avss 1.1541466470675e-18
Cconserve272 avdd.n187 avss 1.9660914129787e-18
Cconserve273 avdd.n188 avss 1.155200902968e-18
Cconserve274 avdd.n189 avss 1.9660914129787e-18
Cconserve275 avdd.n190 avss 1.1541466470675e-18
Cconserve276 avdd.n191 avss 1.9660914129787e-18
Cconserve277 avdd.n192 avss 1.1541466470675e-18
Cconserve278 avdd.n193 avss 1.9660914129787e-18
Cconserve279 avdd.n194 avss 1.1541466470675e-18
Cconserve280 avdd.n195 avss 1.9660914129787e-18
Cconserve281 avdd.n196 avss 1.1541466470675e-18
Cconserve282 avdd.n197 avss 1.9660914129787e-18
Cconserve283 avdd.n198 avss 1.1541466470675e-18
Cconserve284 avdd.n199 avss 1.9660914129787e-18
Cconserve285 avdd.n200 avss 1.1541466470675e-18
Cconserve286 avdd.n201 avss 1.9660914129787e-18
Cconserve287 avdd.n202 avss 1.1541466470675e-18
Cconserve288 avdd.n203 avss 1.9660914129787e-18
Cconserve289 avdd.n204 avss 1.1541466470675e-18
Cconserve290 avdd.n205 avss 1.9660914129787e-18
Cconserve291 avdd.n206 avss 1.1541466470675e-18
Cconserve292 avdd.n207 avss 1.9660914129787e-18
Cconserve293 avdd.n208 avss 1.9660914129787e-18
Cconserve294 avdd.n209 avss 1.5180326552681e-18
Cconserve295 avdd.n210 avss 1.9660914129787e-18
Cconserve296 avdd.n211 avss 1.1541466470675e-18
Cconserve297 avdd.n212 avss 1.9660914129787e-18
Cconserve298 avdd.n213 avss 1.1541466470675e-18
Cconserve299 avdd.n214 avss 1.9660914129787e-18
Cconserve300 avdd.n215 avss 1.1541466470675e-18
Cconserve301 avdd.n216 avss 1.9660914129787e-18
Cconserve302 avdd.n217 avss 1.1541466470675e-18
Cconserve303 avdd.n218 avss 1.9660914129787e-18
Cconserve304 avdd.n219 avss 1.1541466470675e-18
Cconserve305 avdd.n220 avss 1.9660914129787e-18
Cconserve306 avdd.n221 avss 1.1610951518662e-18
Cconserve307 avdd.n222 avss 1.9660914129787e-18
Cconserve308 avdd.n223 avss 1.1541466470675e-18
Cconserve309 avdd.n224 avss 1.9660914129787e-18
Cconserve310 avdd.n225 avss 1.1541466470675e-18
Cconserve311 avdd.n226 avss 1.9660914129787e-18
Cconserve312 avdd.n227 avss 1.1606878257229e-18
Cconserve313 avdd.n228 avss 1.9660914129787e-18
Cconserve314 avdd.n229 avss 1.1541466470675e-18
Cconserve315 avdd.n230 avss 1.9660914129787e-18
Cconserve316 avdd.n231 avss 1.1541466470675e-18
Cconserve317 avdd.n232 avss 1.9660914129787e-18
Cconserve318 avdd.n233 avss 1.1541466470675e-18
Cconserve319 avdd.n234 avss 1.9660914129787e-18
Cconserve320 avdd.n235 avss 1.1541466470675e-18
Cconserve321 avdd.n236 avss 1.2658738121587e-18
Cconserve322 avdd.n237 avss 1.4588984833949e-18
Cconserve323 avdd.n238 avss 4.1129158318083e-18
Cconserve324 avdd.n239 avss 3.3974354807924e-18
Cconserve325 avdd.n240 avss 4.065857682068e-18
Cconserve326 avdd.n241 avss 3.3974354807924e-18
Cconserve327 avdd.n242 avss 2.4379188491732e-18
Cconserve328 avdd.n243 avss 3.3974354807924e-18
Cconserve329 avdd.n244 avss 2.4379188491732e-18
Cconserve330 avdd.n245 avss 3.3974354807924e-18
Cconserve331 avdd.n246 avss 2.4379188491732e-18
Cconserve332 avdd.n247 avss 3.3974354807924e-18
Cconserve333 avdd.n248 avss 2.4379188491732e-18
Cconserve334 avdd.n249 avss 3.3974354807924e-18
Cconserve335 avdd.n250 avss 3.6494026410109e-18
Cconserve336 avdd.n251 avss 3.3974354807924e-18
Cconserve337 avdd.n252 avss 4.0870626018848e-18
Cconserve338 avdd.n253 avss 3.3974354807924e-18
Cconserve339 avdd.n254 avss 2.4379188491732e-18
Cconserve340 avdd.n255 avss 3.3974354807924e-18
Cconserve341 avdd.n256 avss 2.4379188491732e-18
Cconserve342 avdd.n257 avss 3.3974354807924e-18
Cconserve343 avdd.n258 avss 2.4379188491732e-18
Cconserve344 avdd.n259 avss 3.3974354807924e-18
Cconserve345 avdd.n260 avss 2.4379188491732e-18
Cconserve346 avdd.n261 avss 3.3974354807924e-18
Cconserve347 avdd.n262 avss 2.4379188491732e-18
Cconserve348 avdd.n263 avss 3.3974354807924e-18
Cconserve349 avdd.n264 avss 2.4379188491732e-18
Cconserve350 avdd.n265 avss 3.3974354807924e-18
Cconserve351 avdd.n266 avss 2.4379188491732e-18
Cconserve352 avdd.n267 avss 3.3974354807924e-18
Cconserve353 avdd.n268 avss 4.0870626018848e-18
Cconserve354 avdd.n269 avss 3.3974354807924e-18
Cconserve355 avdd.n270 avss 2.4427828025323e-18
Cconserve356 avdd.n271 avss 3.3974354807924e-18
Cconserve357 avdd.n272 avss 3.3974354807924e-18
Cconserve358 avdd.n273 avss 4.0749146986677e-18
Cconserve359 avdd.n274 avss 3.3974354807924e-18
Cconserve360 avdd.n275 avss 2.4379188491732e-18
Cconserve361 avdd.n276 avss 3.3974354807924e-18
Cconserve362 avdd.n277 avss 2.4379188491732e-18
Cconserve363 avdd.n278 avss 3.3974354807924e-18
Cconserve364 avdd.n279 avss 2.4379188491732e-18
Cconserve365 avdd.n280 avss 3.3974354807924e-18
Cconserve366 avdd.n281 avss 2.4379188491732e-18
Cconserve367 avdd.n282 avss 3.3974354807924e-18
Cconserve368 avdd.n283 avss 2.4379188491732e-18
Cconserve369 avdd.n284 avss 3.3974354807924e-18
Cconserve370 avdd.n285 avss 2.4379188491732e-18
Cconserve371 avdd.n286 avss 3.3974354807924e-18
Cconserve372 avdd.n287 avss 2.4379188491732e-18
Cconserve373 avdd.n288 avss 3.3974354807924e-18
Cconserve374 avdd.n289 avss 2.4379188491732e-18
Cconserve375 avdd.n290 avss 3.3974354807924e-18
Cconserve376 avdd.n291 avss 2.4379188491732e-18
Cconserve377 avdd.n292 avss 3.3974354807924e-18
Cconserve378 avdd.n293 avss 2.4379188491732e-18
Cconserve379 avdd.n294 avss 3.3974354807924e-18
Cconserve380 avdd.n295 avss 3.4341667147802e-18
Cconserve381 avdd.n296 avss 2.4670067278824e-18
Cconserve382 avdd.n297 avss 3.4280568226296e-18
Cconserve383 avdd.n298 avss 3.6976108880972e-18
Cconserve384 avdd.n299 avss 3.4280568226296e-18
Cconserve385 avdd.n300 avss 4.1161984013167e-18
Cconserve386 avdd.n301 avss 3.4280568226296e-18
Cconserve387 avdd.n302 avss 2.4621667348846e-18
Cconserve388 avdd.n303 avss 3.4280568226296e-18
Cconserve389 avdd.n304 avss 4.1219968087694e-18
Cconserve390 avdd.n305 avss 3.9315358962003e-18
Cconserve391 avdd.n306 avss 4.1775608867978e-18
Cconserve392 avdd.n307 avss 3.9315358962003e-18
Cconserve393 avdd.n308 avss 2.8576804201001e-18
Cconserve394 avdd.n309 avss 3.9315358962003e-18
Cconserve395 avdd.n310 avss 2.8576804201001e-18
Cconserve396 avdd.n311 avss 3.9315358962003e-18
Cconserve397 avdd.n312 avss 2.8576804201001e-18
Cconserve398 avdd.n313 avss 3.9315358962003e-18
Cconserve399 avdd.n314 avss 2.8576804201001e-18
Cconserve400 avdd.n315 avss 3.9315358962003e-18
Cconserve401 avdd.n316 avss 2.8576804201001e-18
Cconserve402 avdd.n317 avss 3.9315358962003e-18
Cconserve403 avdd.n318 avss 2.8576804201001e-18
Cconserve404 avdd.n319 avss 3.9315358962003e-18
Cconserve405 avdd.n320 avss 2.8713378260838e-18
Cconserve406 avdd.n321 avss 3.9315358962003e-18
Cconserve407 avdd.n322 avss 2.8576804201001e-18
Cconserve408 avdd.n323 avss 3.9315358962003e-18
Cconserve409 avdd.n324 avss 2.8576804201001e-18
Cconserve410 avdd.n325 avss 3.9315358962003e-18
Cconserve411 avdd.n326 avss 4.2493700898383e-18
Cconserve412 avdd.n327 avss 3.9315358962003e-18
Cconserve413 avdd.n328 avss 2.8576804201001e-18
Cconserve414 avdd.n329 avss 3.9315358962003e-18
Cconserve415 avdd.n330 avss 4.1867616655657e-18
Cconserve416 avdd.n331 avss 3.9315358962003e-18
Cconserve417 avdd.n332 avss 2.8576804201001e-18
Cconserve418 avdd.n333 avss 3.9315358962003e-18
Cconserve419 avdd.n334 avss 2.8576804201001e-18
Cconserve420 avdd.n335 avss 3.9315358962003e-18
Cconserve421 avdd.n336 avss 2.8576804201001e-18
Cconserve422 avdd.n337 avss 3.9315358962003e-18
Cconserve423 avdd.n338 avss 2.8576804201001e-18
Cconserve424 avdd.n339 avss 3.9315358962003e-18
Cconserve425 avdd.n340 avss 2.8576804201001e-18
Cconserve426 avdd.n341 avss 3.9315358962003e-18
Cconserve427 avdd.n342 avss 2.8576804201001e-18
Cconserve428 avdd.n343 avss 3.9315358962003e-18
Cconserve429 avdd.n344 avss 2.8576804201001e-18
Cconserve430 avdd.n345 avss 3.4280568226296e-18
Cconserve431 avdd.n346 avss 4.0971978347464e-18
Cconserve432 avdd.n347 avss 3.4280568226296e-18
Cconserve433 avdd.n348 avss 2.4621667348846e-18
Cconserve434 avdd.n349 avss 3.4280568226296e-18
Cconserve435 avdd.n350 avss 2.4621667348846e-18
Cconserve436 avdd.n351 avss 3.4280568226296e-18
Cconserve437 avdd.n352 avss 2.4621667348846e-18
Cconserve438 avdd.n353 avss 3.4280568226296e-18
Cconserve439 avdd.n354 avss 2.4621667348846e-18
Cconserve440 avdd.n355 avss 3.4280568226296e-18
Cconserve441 avdd.n356 avss 2.4621667348846e-18
Cconserve442 avdd.n357 avss 3.4280568226296e-18
Cconserve443 avdd.n358 avss 2.4621667348846e-18
Cconserve444 avdd.n359 avss 3.4280568226296e-18
Cconserve445 avdd.n360 avss 2.4621667348846e-18
Cconserve446 avdd.n361 avss 3.4280568226296e-18
Cconserve447 avdd.n362 avss 2.4737635497901e-18
Cconserve448 avdd.n363 avss 3.4280568226296e-18
Cconserve449 avdd.n364 avss 4.1268607621285e-18
Cconserve450 avdd.n365 avss 3.4280568226296e-18
Cconserve451 avdd.n366 avss 4.1268607621285e-18
Cconserve452 avdd.n367 avss 3.4280568226296e-18
Cconserve453 avdd.n368 avss 4.1161984013167e-18
Cconserve454 avdd.n369 avss 3.4280568226296e-18
Cconserve455 avdd.n370 avss 2.4621667348846e-18
Cconserve456 avdd.n371 avss 3.4280568226296e-18
Cconserve457 avdd.n372 avss 2.4621667348846e-18
Cconserve458 avdd.n373 avss 3.4280568226296e-18
Cconserve459 avdd.n374 avss 2.4621667348846e-18
Cconserve460 avdd.n375 avss 3.4280568226296e-18
Cconserve461 avdd.n376 avss 2.4621667348846e-18
Cconserve462 avdd.n377 avss 3.4280568226296e-18
Cconserve463 avdd.n378 avss 2.4621667348846e-18
Cconserve464 avdd.n379 avss 3.4280568226296e-18
Cconserve465 avdd.n380 avss 2.4621667348846e-18
Cconserve466 avdd.n381 avss 3.4280568226296e-18
Cconserve467 avdd.n382 avss 2.4668629657141e-18
Cconserve468 avdd.n384 avss 3.4341667147802e-18
Cconserve469 avdd.n385 avss 1.1422862681869e-18
Cconserve470 avdd.n386 avss 3.4341667147802e-18
Cconserve471 avdd.n387 avss 2.4670067278824e-18
Cconserve472 avdd.n388 avss 3.4341667147802e-18
Cconserve473 avdd.n389 avss 2.4670067278824e-18
Cconserve474 avdd.n390 avss 3.4341667147802e-18
Cconserve475 avdd.n391 avss 2.4670067278824e-18
Cconserve476 avdd.n392 avss 3.4341667147802e-18
Cconserve477 avdd.n393 avss 2.4670067278824e-18
Cconserve478 avdd.n394 avss 3.4341667147802e-18
Cconserve479 avdd.n395 avss 2.4670067278824e-18
Cconserve480 avdd.n396 avss 3.4341667147802e-18
Cconserve481 avdd.n397 avss 2.4670067278824e-18
Cconserve482 avdd.n398 avss 3.4341667147802e-18
Cconserve483 avdd.n399 avss 2.4670067278824e-18
Cconserve484 avdd.n400 avss 3.4341667147802e-18
Cconserve485 avdd.n401 avss 2.4670067278824e-18
Cconserve486 avdd.n402 avss 3.4341667147802e-18
Cconserve487 avdd.n403 avss 2.4670067278824e-18
Cconserve488 avdd.n404 avss 3.4341667147802e-18
Cconserve489 avdd.n405 avss 2.4670067278824e-18
Cconserve490 avdd.n406 avss 3.4341667147802e-18
Cconserve491 avdd.n407 avss 2.4670067278824e-18
Cconserve492 avdd.n408 avss 3.4341667147802e-18
Cconserve493 avdd.n409 avss 2.4670067278824e-18
Cconserve494 avdd.n410 avss 3.4341667147802e-18
Cconserve495 avdd.n411 avss 2.4670067278824e-18
Cconserve496 avdd.n412 avss 3.4341667147802e-18
Cconserve497 avdd.n413 avss 2.4670067278824e-18
Cconserve498 avdd.n414 avss 3.4341667147802e-18
Cconserve499 avdd.n415 avss 2.4670067278824e-18
Cconserve500 avdd.n416 avss 3.4341667147802e-18
Cconserve501 avdd.n417 avss 2.4670067278824e-18
Cconserve502 avdd.n418 avss 3.4341667147802e-18
Cconserve503 avdd.n419 avss 2.9430511876788e-18
Cconserve504 avdd.n420 avss 3.4341667147802e-18
Cconserve505 avdd.n421 avss 2.4670067278824e-18
Cconserve506 avdd.t264 avss 1.2189594245866e-18
Cconserve507 avdd.t265 avss 7.1794826823747e-19
Cconserve508 avdd.t266 avss 7.1794826823747e-19
Cconserve509 avdd.t33 avss 6.0540884689571e-18
Cconserve510 avdd.t35 avss 6.0470920434356e-18
Cconserve511 avdd.t32 avss 1.3914740264859e-18
Cconserve512 avdd.t61 avss 6.047499369579e-18
Cconserve513 avdd.t71 avss 6.0546155969074e-18
Cconserve514 avdd.t55 avss 6.0482181804203e-18
Cconserve515 avdd.t348 avss 1.2168029920629e-18
Cconserve516 avdd.t349 avss 7.1646272583223e-19
Cconserve517 avdd.t350 avss 7.1646272583223e-19
Cconserve518 avdd.t48 avss 1.3910667003425e-18
Cconserve519 avdd.n422 avss 5.349965329233e-18
Cconserve520 avdd.t68 avss 1.4479485982465e-18
Cconserve521 avdd.n423 avss 1.6148325152227e-18
Cconserve522 avdd.t49 avss 6.1594900986453e-18
Cconserve523 avdd.t69 avss 6.0482181804203e-18
Cconserve524 avdd.t70 avss 1.4479485982465e-18
Cconserve525 avdd.n426 avss 1.6060151022367e-18
Cconserve526 avdd.t54 avss 1.4479485982465e-18
Cconserve527 avdd.n427 avss 1.5972935306963e-18
Cconserve528 avdd.t18 avss 1.3910667003425e-18
Cconserve529 avdd.t344 avss 1.2168029920629e-18
Cconserve530 avdd.t345 avss 7.1646272583223e-19
Cconserve531 avdd.t346 avss 7.1646272583223e-19
Cconserve532 avdd.t352 avss 1.2168029920629e-18
Cconserve533 avdd.t353 avss 7.1646272583223e-19
Cconserve534 avdd.t354 avss 7.1646272583223e-19
Cconserve535 avdd.t1024 avss 8.8444881943165e-18
Cconserve536 avdd.t1022 avss 8.739326168242e-18
Cconserve537 avdd.t1023 avss 1.4735143038335e-18
Cconserve538 avdd.t1021 avss 1.4409521727251e-18
Cconserve539 avdd.n428 avss 3.1052628341869e-18
Cconserve540 avdd.t82 avss 8.786360357621e-18
Cconserve541 avdd.t968 avss 1.4792647905635e-18
Cconserve542 avdd.t967 avss 1.446510976564e-18
Cconserve543 avdd.n429 avss 3.1675118530389e-18
Cconserve544 avdd.t973 avss 1.446510976564e-18
Cconserve545 avdd.n430 avss 1.6136584575153e-18
Cconserve546 avdd.t1043 avss 1.446510976564e-18
Cconserve547 avdd.n431 avss 1.594466208054e-18
Cconserve548 avdd.t17 avss 2.7880995306674e-18
Cconserve549 avdd.t16 avss 8.6106350672975e-19
Cconserve550 avdd.t707 avss 1.8993378461882e-18
Cconserve551 avdd.n432 avss 5.3080586571883e-18
Cconserve552 avdd.t930 avss 3.1254853791873e-18
Cconserve553 avdd.t27 avss 3.1263958729196e-18
Cconserve554 avdd.n434 avss 1.184983632157e-18
Cconserve555 avdd.t1020 avss 3.0592349799857e-18
Cconserve556 avdd.t1027 avss 3.0592349799857e-18
Cconserve557 avdd.t664 avss 1.8993378461882e-18
Cconserve558 avdd.t65 avss 3.0592349799857e-18
Cconserve559 avdd.t751 avss 1.8993378461882e-18
Cconserve560 avdd.t747 avss 1.8993378461882e-18
Cconserve561 avdd.t743 avss 1.8993378461882e-18
Cconserve562 avdd.t739 avss 1.8993378461882e-18
Cconserve563 avdd.t735 avss 1.8993378461882e-18
Cconserve564 avdd.t731 avss 1.8993378461882e-18
Cconserve565 avdd.t727 avss 1.8993378461882e-18
Cconserve566 avdd.t723 avss 1.8993378461882e-18
Cconserve567 avdd.t719 avss 1.8993378461882e-18
Cconserve568 avdd.t715 avss 1.8993378461882e-18
Cconserve569 avdd.t711 avss 1.8993378461882e-18
Cconserve570 avdd.n435 avss 5.3080586571883e-18
Cconserve571 avdd.n436 avss 5.3080586571883e-18
Cconserve572 avdd.n437 avss 5.3080586571883e-18
Cconserve573 avdd.n438 avss 5.3080586571883e-18
Cconserve574 avdd.n439 avss 5.3080586571883e-18
Cconserve575 avdd.n440 avss 5.3080586571883e-18
Cconserve576 avdd.n441 avss 5.3080586571883e-18
Cconserve577 avdd.n442 avss 5.3080586571883e-18
Cconserve578 avdd.n443 avss 5.3080586571883e-18
Cconserve579 avdd.n444 avss 5.3080586571883e-18
Cconserve580 avdd.t700 avss 1.3939898644302e-18
Cconserve581 avdd.t701 avss 8.3458730741048e-19
Cconserve582 avdd.t702 avss 8.3458730741048e-19
Cconserve583 avdd.t696 avss 1.3939898644302e-18
Cconserve584 avdd.t697 avss 8.3458730741048e-19
Cconserve585 avdd.t698 avss 8.3458730741048e-19
Cconserve586 avdd.n445 avss 7.3205373297888e-18
Cconserve587 avdd.t692 avss 1.3939898644302e-18
Cconserve588 avdd.t693 avss 8.3458730741048e-19
Cconserve589 avdd.t694 avss 8.3458730741048e-19
Cconserve590 avdd.n446 avss 4.3324167023637e-18
Cconserve591 avdd.t688 avss 1.3939898644302e-18
Cconserve592 avdd.t689 avss 8.3458730741048e-19
Cconserve593 avdd.t690 avss 8.3458730741048e-19
Cconserve594 avdd.n447 avss 4.3324167023637e-18
Cconserve595 avdd.t684 avss 1.3939898644302e-18
Cconserve596 avdd.t685 avss 8.3458730741048e-19
Cconserve597 avdd.t686 avss 8.3458730741048e-19
Cconserve598 avdd.n448 avss 4.3324167023637e-18
Cconserve599 avdd.t680 avss 1.3939898644302e-18
Cconserve600 avdd.t681 avss 8.3458730741048e-19
Cconserve601 avdd.t682 avss 8.3458730741048e-19
Cconserve602 avdd.n449 avss 4.3324167023637e-18
Cconserve603 avdd.t676 avss 1.3939898644302e-18
Cconserve604 avdd.t677 avss 8.3458730741048e-19
Cconserve605 avdd.t678 avss 8.3458730741048e-19
Cconserve606 avdd.n450 avss 4.3319135347749e-18
Cconserve607 avdd.t672 avss 1.3939898644302e-18
Cconserve608 avdd.t673 avss 8.3458730741048e-19
Cconserve609 avdd.t674 avss 8.3458730741048e-19
Cconserve610 avdd.n451 avss 4.6802253080818e-18
Cconserve611 avdd.t87 avss 2.5407567201943e-19
Cconserve612 avdd.t88 avss 2.5991241605035e-18
Cconserve613 avdd.n452 avss 4.913072099923e-19
Cconserve614 avdd.t879 avss 7.880802459818e-19
Cconserve615 avdd.t880 avss 4.260152252457e-19
Cconserve616 avdd.t881 avss 4.260152252457e-19
Cconserve617 avdd.t875 avss 7.880802459818e-19
Cconserve618 avdd.t876 avss 4.260152252457e-19
Cconserve619 avdd.t877 avss 4.260152252457e-19
Cconserve620 avdd.n453 avss 3.642957303801e-18
Cconserve621 avdd.t871 avss 7.880802459818e-19
Cconserve622 avdd.t872 avss 4.260152252457e-19
Cconserve623 avdd.t873 avss 4.260152252457e-19
Cconserve624 avdd.n454 avss 2.0586982096927e-18
Cconserve625 avdd.t867 avss 7.880802459818e-19
Cconserve626 avdd.t868 avss 4.260152252457e-19
Cconserve627 avdd.t869 avss 4.260152252457e-19
Cconserve628 avdd.n455 avss 2.0586982096927e-18
Cconserve629 avdd.t863 avss 7.880802459818e-19
Cconserve630 avdd.t864 avss 4.260152252457e-19
Cconserve631 avdd.t865 avss 4.260152252457e-19
Cconserve632 avdd.n456 avss 2.0586982096927e-18
Cconserve633 avdd.t859 avss 7.880802459818e-19
Cconserve634 avdd.t860 avss 4.260152252457e-19
Cconserve635 avdd.t861 avss 4.260152252457e-19
Cconserve636 avdd.n457 avss 2.0586982096927e-18
Cconserve637 avdd.t855 avss 7.880802459818e-19
Cconserve638 avdd.t856 avss 4.260152252457e-19
Cconserve639 avdd.t857 avss 4.260152252457e-19
Cconserve640 avdd.n458 avss 2.0586982096927e-18
Cconserve641 avdd.t851 avss 7.880802459818e-19
Cconserve642 avdd.t852 avss 4.260152252457e-19
Cconserve643 avdd.t853 avss 4.260152252457e-19
Cconserve644 avdd.n459 avss 2.0626037485968e-18
Cconserve645 avdd.n460 avss 2.8177384976881e-19
Cconserve646 avdd.t902 avss 9.9282153393032e-19
Cconserve647 avdd.n462 avss 2.7822771628533e-19
Cconserve648 avdd.n464 avss 3.0393718404059e-19
Cconserve649 avdd.t847 avss 7.880802459818e-19
Cconserve650 avdd.t848 avss 4.260152252457e-19
Cconserve651 avdd.t849 avss 4.260152252457e-19
Cconserve652 avdd.t923 avss 1.004370428113e-18
Cconserve653 avdd.n465 avss 2.703136089232e-18
Cconserve654 avdd.t921 avss 1.0681768704544e-18
Cconserve655 avdd.n466 avss 1.1156183859767e-18
Cconserve656 avdd.t927 avss 1.0695426110527e-18
Cconserve657 avdd.n467 avss 1.102919394448e-18
Cconserve658 avdd.t925 avss 1.0681768704544e-18
Cconserve659 avdd.n468 avss 1.102536028666e-18
Cconserve660 avdd.t975 avss 1.0695426110527e-18
Cconserve661 avdd.n469 avss 1.102919394448e-18
Cconserve662 avdd.t945 avss 1.0681768704544e-18
Cconserve663 avdd.n470 avss 1.0885910983458e-18
Cconserve664 avdd.t791 avss 7.880802459818e-19
Cconserve665 avdd.t792 avss 4.260152252457e-19
Cconserve666 avdd.t793 avss 4.260152252457e-19
Cconserve667 avdd.t787 avss 7.880802459818e-19
Cconserve668 avdd.t788 avss 4.260152252457e-19
Cconserve669 avdd.t789 avss 4.260152252457e-19
Cconserve670 avdd.n471 avss 3.642957303801e-18
Cconserve671 avdd.t783 avss 7.880802459818e-19
Cconserve672 avdd.t784 avss 4.260152252457e-19
Cconserve673 avdd.t785 avss 4.260152252457e-19
Cconserve674 avdd.n472 avss 2.0586982096927e-18
Cconserve675 avdd.t779 avss 7.880802459818e-19
Cconserve676 avdd.t780 avss 4.260152252457e-19
Cconserve677 avdd.t781 avss 4.260152252457e-19
Cconserve678 avdd.t775 avss 7.880802459818e-19
Cconserve679 avdd.t776 avss 4.260152252457e-19
Cconserve680 avdd.t777 avss 4.260152252457e-19
Cconserve681 avdd.t771 avss 7.880802459818e-19
Cconserve682 avdd.t772 avss 4.260152252457e-19
Cconserve683 avdd.t773 avss 4.260152252457e-19
Cconserve684 avdd.t767 avss 7.880802459818e-19
Cconserve685 avdd.t768 avss 4.260152252457e-19
Cconserve686 avdd.t769 avss 4.260152252457e-19
Cconserve687 avdd.t763 avss 7.880802459818e-19
Cconserve688 avdd.t764 avss 4.260152252457e-19
Cconserve689 avdd.t765 avss 4.260152252457e-19
Cconserve690 avdd.n473 avss 3.642957303801e-18
Cconserve691 avdd.n474 avss 2.0586982096927e-18
Cconserve692 avdd.n475 avss 2.0583148439107e-18
Cconserve693 avdd.t948 avss 5.5957507162167e-18
Cconserve694 avdd.t950 avss 5.5254270555813e-18
Cconserve695 avdd.t952 avss 5.5307702161679e-18
Cconserve696 avdd.t959 avss 5.5270563601548e-18
Cconserve697 avdd.t961 avss 5.5307702161679e-18
Cconserve698 avdd.t963 avss 5.5319442738753e-18
Cconserve699 avdd.t807 avss 7.880802459818e-19
Cconserve700 avdd.t808 avss 4.260152252457e-19
Cconserve701 avdd.t809 avss 4.260152252457e-19
Cconserve702 avdd.t947 avss 1.004945476786e-18
Cconserve703 avdd.n481 avss 2.7078083597001e-18
Cconserve704 avdd.t949 avss 1.0693269678004e-18
Cconserve705 avdd.n482 avss 1.1158819499518e-18
Cconserve706 avdd.t951 avss 1.0701416200871e-18
Cconserve707 avdd.n483 avss 1.1037340467347e-18
Cconserve708 avdd.t958 avss 1.0693269678004e-18
Cconserve709 avdd.n484 avss 1.1027995926411e-18
Cconserve710 avdd.t960 avss 1.0701416200871e-18
Cconserve711 avdd.n485 avss 1.0897891164145e-18
Cconserve712 avdd.t803 avss 7.880802459818e-19
Cconserve713 avdd.t804 avss 4.260152252457e-19
Cconserve714 avdd.t805 avss 4.260152252457e-19
Cconserve715 avdd.t962 avss 1.0041547848606e-18
Cconserve716 avdd.n487 avss 2.7544112625743e-18
Cconserve717 avdd.t926 avss 5.5298357620743e-18
Cconserve718 avdd.t928 avss 5.5344361514583e-18
Cconserve719 avdd.t922 avss 5.5298357620743e-18
Cconserve720 avdd.t924 avss 5.6000156605414e-18
Cconserve721 avdd.t976 avss 5.5344361514583e-18
Cconserve722 avdd.t946 avss 5.3787417232442e-18
Cconserve723 avdd.t843 avss 7.880802459818e-19
Cconserve724 avdd.t844 avss 4.260152252457e-19
Cconserve725 avdd.t845 avss 4.260152252457e-19
Cconserve726 avdd.n495 avss 2.0642570135317e-18
Cconserve727 avdd.n499 avss 4.3936114653152e-19
Cconserve728 avdd.n500 avss 4.9075612168068e-19
Cconserve729 avdd.t932 avss 2.0397910885318e-17
Cconserve730 avdd.n502 avss 2.489481546852e-19
Cconserve731 avdd.t759 avss 1.3939898644302e-18
Cconserve732 avdd.t760 avss 8.3458730741048e-19
Cconserve733 avdd.t761 avss 8.3458730741048e-19
Cconserve734 avdd.n503 avss 4.5162885155547e-18
Cconserve735 avdd.t954 avss 1.6234582453177e-18
Cconserve736 avdd.n504 avss 1.8416892167202e-18
Cconserve737 avdd.t955 avss 1.6932308176414e-18
Cconserve738 avdd.n505 avss 1.8076894639293e-18
Cconserve739 avdd.t956 avss 1.6234582453177e-18
Cconserve740 avdd.n506 avss 1.8412818905769e-18
Cconserve741 avdd.t964 avss 1.6932308176414e-18
Cconserve742 avdd.n507 avss 1.8076894639293e-18
Cconserve743 avdd.t965 avss 1.6234582453177e-18
Cconserve744 avdd.n508 avss 1.8437258474371e-18
Cconserve745 avdd.t966 avss 1.6220445839965e-18
Cconserve746 avdd.n509 avss 1.8735564973489e-18
Cconserve747 avdd.t755 avss 1.3939898644302e-18
Cconserve748 avdd.t756 avss 8.3458730741048e-19
Cconserve749 avdd.t757 avss 8.3458730741048e-19
Cconserve750 avdd.t799 avss 1.3939898644302e-18
Cconserve751 avdd.t800 avss 8.3458730741048e-19
Cconserve752 avdd.t801 avss 8.3458730741048e-19
Cconserve753 avdd.t971 avss 1.6234582453177e-18
Cconserve754 avdd.n510 avss 4.7602289547126e-18
Cconserve755 avdd.t977 avss 1.6937339852302e-18
Cconserve756 avdd.n511 avss 1.8048142205643e-18
Cconserve757 avdd.t978 avss 1.6946444789625e-18
Cconserve758 avdd.n512 avss 1.7887607784431e-18
Cconserve759 avdd.t979 avss 1.6937339852302e-18
Cconserve760 avdd.n513 avss 1.787922165795e-18
Cconserve761 avdd.t980 avss 1.6946444789625e-18
Cconserve762 avdd.n514 avss 1.7887607784431e-18
Cconserve763 avdd.t953 avss 1.6937339852302e-18
Cconserve764 avdd.n515 avss 1.7879700865177e-18
Cconserve765 avdd.t795 avss 1.3939898644302e-18
Cconserve766 avdd.t796 avss 8.3458730741048e-19
Cconserve767 avdd.t797 avss 8.3458730741048e-19
Cconserve768 avdd.t839 avss 1.3939898644302e-18
Cconserve769 avdd.t840 avss 8.3458730741048e-19
Cconserve770 avdd.t841 avss 8.3458730741048e-19
Cconserve771 avdd.t835 avss 1.3939898644302e-18
Cconserve772 avdd.t836 avss 8.3458730741048e-19
Cconserve773 avdd.t837 avss 8.3458730741048e-19
Cconserve774 avdd.n516 avss 7.3113365510208e-18
Cconserve775 avdd.t831 avss 1.3939898644302e-18
Cconserve776 avdd.t832 avss 8.3458730741048e-19
Cconserve777 avdd.t833 avss 8.3458730741048e-19
Cconserve778 avdd.n517 avss 4.3324167023637e-18
Cconserve779 avdd.t827 avss 1.3939898644302e-18
Cconserve780 avdd.t828 avss 8.3458730741048e-19
Cconserve781 avdd.t829 avss 8.3458730741048e-19
Cconserve782 avdd.n518 avss 4.3324167023637e-18
Cconserve783 avdd.t823 avss 1.3939898644302e-18
Cconserve784 avdd.t824 avss 8.3458730741048e-19
Cconserve785 avdd.t825 avss 8.3458730741048e-19
Cconserve786 avdd.n519 avss 4.3324167023637e-18
Cconserve787 avdd.t819 avss 1.3939898644302e-18
Cconserve788 avdd.t820 avss 8.3458730741048e-19
Cconserve789 avdd.t821 avss 8.3458730741048e-19
Cconserve790 avdd.n520 avss 4.3324167023637e-18
Cconserve791 avdd.t815 avss 1.3939898644302e-18
Cconserve792 avdd.t816 avss 8.3458730741048e-19
Cconserve793 avdd.t817 avss 8.3458730741048e-19
Cconserve794 avdd.n521 avss 4.3387901584895e-18
Cconserve795 avdd.t811 avss 1.3939898644302e-18
Cconserve796 avdd.t812 avss 8.3458730741048e-19
Cconserve797 avdd.t813 avss 8.3458730741048e-19
Cconserve798 avdd.n522 avss 1.3813387936243e-18
Cconserve799 avdd.t668 avss 1.8993378461882e-18
Cconserve800 avdd.n523 avss 5.2839305732837e-18
Cconserve801 avdd.t64 avss 3.2561172694033e-18
Cconserve802 avdd.n524 avss 1.842695551898e-18
Cconserve803 avdd.t1029 avss 3.2582257812043e-18
Cconserve804 avdd.n525 avss 1.8233835006298e-18
Cconserve805 avdd.t1028 avss 3.2561172694033e-18
Cconserve806 avdd.n526 avss 1.8237668664118e-18
Cconserve807 avdd.t882 avss 3.2582257812043e-18
Cconserve808 avdd.n527 avss 1.8364658579405e-18
Cconserve809 avdd.n528 avss 2.0522289121215e-18
Cconserve810 avdd.n529 avss 2.7018182693564e-18
Cconserve811 avdd.n530 avss 2.0002828486607e-18
Cconserve812 avdd.t1026 avss 3.2582257812043e-18
Cconserve813 avdd.n531 avss 1.8278161674842e-18
Cconserve814 avdd.t1040 avss 3.2561172694033e-18
Cconserve815 avdd.n532 avss 1.8237668664118e-18
Cconserve816 avdd.t1025 avss 3.2582257812043e-18
Cconserve817 avdd.n533 avss 1.8364658579405e-18
Cconserve818 avdd.n534 avss 2.0350493330157e-18
Cconserve819 avdd.t660 avss 1.8993378461882e-18
Cconserve820 avdd.n535 avss 5.2682125762218e-18
Cconserve821 avdd.n536 avss 2.546746810538e-19
Cconserve822 avdd.n537 avss 1.6235301264018e-18
Cconserve823 avdd.t704 avss 1.8993378461882e-18
Cconserve824 avdd.n538 avss 1.0357105807914e-18
Cconserve825 avdd.n539 avss 4.9166421937679e-18
Cconserve826 avdd.t929 avss 3.5019984978325e-18
Cconserve827 avdd.n540 avss 9.5786336668434e-19
Cconserve828 avdd.t26 avss 3.5008004797637e-18
Cconserve829 avdd.n541 avss 9.5863009824833e-19
Cconserve830 avdd.t28 avss 9.0955927815254e-19
Cconserve831 avdd.n542 avss 1.0176205079533e-18
Cconserve832 avdd.t42 avss 9.1025412863241e-19
Cconserve833 avdd.n543 avss 1.006478939914e-18
Cconserve834 avdd.t44 avss 9.0955927815254e-19
Cconserve835 avdd.n544 avss 1.0054246840135e-18
Cconserve836 avdd.t939 avss 9.1025412863241e-19
Cconserve837 avdd.n545 avss 1.006478939914e-18
Cconserve838 avdd.t941 avss 9.0955927815254e-19
Cconserve839 avdd.n546 avss 1.0054246840135e-18
Cconserve840 avdd.t14 avss 9.1025412863241e-19
Cconserve841 avdd.n547 avss 1.0082280462944e-18
Cconserve842 avdd.t942 avss 2.7828522115263e-18
Cconserve843 avdd.t29 avss 2.7875724027171e-18
Cconserve844 avdd.t43 avss 2.7874046801875e-18
Cconserve845 avdd.t45 avss 2.7844815160998e-18
Cconserve846 avdd.t940 avss 2.7874046801875e-18
Cconserve847 avdd.t15 avss 2.7874046801875e-18
Cconserve848 avdd.n554 avss 1.0602459908393e-18
Cconserve849 avdd.t1006 avss 9.6938830050566e-19
Cconserve850 avdd.n556 avss 1.0100250733975e-18
Cconserve851 avdd.t970 avss 1.446510976564e-18
Cconserve852 avdd.n558 avss 1.6049368859749e-18
Cconserve853 avdd.t974 avss 1.446510976564e-18
Cconserve854 avdd.n559 avss 1.6349112980549e-18
Cconserve855 avdd.t957 avss 1.4792168698408e-18
Cconserve856 avdd.t969 avss 1.4464630558413e-18
Cconserve857 avdd.n560 avss 3.1664815574998e-18
Cconserve858 avdd.t1044 avss 1.4464630558413e-18
Cconserve859 avdd.n561 avss 1.6166295423258e-18
Cconserve860 avdd.t972 avss 1.3896769993828e-18
Cconserve861 avdd.n563 avss 1.6539358249865e-18
Cconserve862 avdd.t6 avss 1.4736580660018e-18
Cconserve863 avdd.t905 avss 1.4409282123637e-18
Cconserve864 avdd.n564 avss 3.1228257790747e-18
Cconserve865 avdd.t903 avss 1.4408802916409e-18
Cconserve866 avdd.n565 avss 1.5939390801038e-18
Cconserve867 avdd.t81 avss 1.3849568081919e-18
Cconserve868 avdd.n567 avss 1.605583815732e-18
Cconserve869 avdd.t904 avss 8.7410992349838e-18
Cconserve870 avdd.t906 avss 8.7402127016129e-18
Cconserve871 avdd.t910 avss 8.8495917512893e-18
Cconserve872 avdd.t912 avss 8.8540483785051e-18
Cconserve873 avdd.t1034 avss 1.9034829887061e-18
Cconserve874 avdd.t943 avss 1.8550351380061e-18
Cconserve875 avdd.n568 avss 3.3166651025976e-18
Cconserve876 avdd.t987 avss 1.8553226623426e-18
Cconserve877 avdd.n569 avss 1.6919609184885e-18
Cconserve878 avdd.t1041 avss 1.8559456317383e-18
Cconserve879 avdd.n570 avss 1.691865077043e-18
Cconserve880 avdd.t913 avss 1.8548913758378e-18
Cconserve881 avdd.n571 avss 1.6779920278069e-18
Cconserve882 avdd.t78 avss 1.0066418703714e-17
Cconserve883 avdd.t1035 avss 9.2411040561552e-18
Cconserve884 avdd.n572 avss 7.9306400114778e-19
Cconserve885 avdd.t944 avss 9.125543233244e-18
Cconserve886 avdd.t988 avss 9.1276996657678e-18
Cconserve887 avdd.t1042 avss 9.1303832262418e-18
Cconserve888 avdd.t914 avss 9.1245129377049e-18
Cconserve889 avdd.t916 avss 8.5291698386228e-18
Cconserve890 avdd.t915 avss 1.7549527085431e-18
Cconserve891 avdd.n579 avss 1.927059984299e-18
Cconserve892 avdd.t524 avss 1.8993378461882e-18
Cconserve893 avdd.n580 avss 5.4249852206978e-18
Cconserve894 avdd.t520 avss 1.8993378461882e-18
Cconserve895 avdd.n581 avss 5.3080586571883e-18
Cconserve896 avdd.t516 avss 1.8993378461882e-18
Cconserve897 avdd.n582 avss 5.3080586571883e-18
Cconserve898 avdd.t512 avss 1.8993378461882e-18
Cconserve899 avdd.n583 avss 5.3080586571883e-18
Cconserve900 avdd.t508 avss 1.8993378461882e-18
Cconserve901 avdd.n584 avss 5.3080586571883e-18
Cconserve902 avdd.t504 avss 1.8993378461882e-18
Cconserve903 avdd.n585 avss 5.3080586571883e-18
Cconserve904 avdd.t500 avss 1.8993378461882e-18
Cconserve905 avdd.n586 avss 5.3080586571883e-18
Cconserve906 avdd.t496 avss 1.8993378461882e-18
Cconserve907 avdd.n587 avss 5.3080586571883e-18
Cconserve908 avdd.t492 avss 1.8993378461882e-18
Cconserve909 avdd.n588 avss 5.3080586571883e-18
Cconserve910 avdd.t488 avss 1.8993378461882e-18
Cconserve911 avdd.n589 avss 5.3080586571883e-18
Cconserve912 avdd.t484 avss 1.8993378461882e-18
Cconserve913 avdd.n590 avss 5.3080586571883e-18
Cconserve914 avdd.t480 avss 1.8993378461882e-18
Cconserve915 avdd.n591 avss 5.3291437751982e-18
Cconserve916 avdd.t476 avss 1.8993378461882e-18
Cconserve917 avdd.n592 avss 5.3387039593867e-18
Cconserve918 avdd.t911 avss 1.4410719745319e-18
Cconserve919 avdd.n593 avss 1.6626094758042e-18
Cconserve920 avdd.t909 avss 1.4415991024822e-18
Cconserve921 avdd.n594 avss 1.6030679777876e-18
Cconserve922 avdd.t7 avss 8.8666515285883e-18
Cconserve923 avdd.t989 avss 2.6380357873764e-19
Cconserve924 avdd.t920 avss 4.7214850503694e-18
Cconserve925 avdd.t1037 avss 4.7361967122535e-18
Cconserve926 avdd.t917 avss 8.9650088120322e-19
Cconserve927 avdd.t919 avss 8.781951651128e-19
Cconserve928 avdd.n603 avss 2.0881454938224e-18
Cconserve929 avdd.t472 avss 4.3775580231941e-19
Cconserve930 avdd.t444 avss 4.3775580231941e-19
Cconserve931 avdd.t440 avss 6.4676203459265e-19
Cconserve932 avdd.t441 avss 3.4002148827119e-19
Cconserve933 avdd.t442 avss 3.4002148827119e-19
Cconserve934 avdd.t436 avss 6.4676203459265e-19
Cconserve935 avdd.t437 avss 3.4002148827119e-19
Cconserve936 avdd.t438 avss 3.4002148827119e-19
Cconserve937 avdd.t996 avss 7.9368697054353e-19
Cconserve938 avdd.t396 avss 6.4676203459265e-19
Cconserve939 avdd.t397 avss 3.4002148827119e-19
Cconserve940 avdd.t398 avss 3.4002148827119e-19
Cconserve941 avdd.t392 avss 6.4676203459265e-19
Cconserve942 avdd.t393 avss 3.4002148827119e-19
Cconserve943 avdd.t394 avss 3.4002148827119e-19
Cconserve944 avdd.t388 avss 6.4676203459265e-19
Cconserve945 avdd.t389 avss 3.4002148827119e-19
Cconserve946 avdd.t390 avss 3.4002148827119e-19
Cconserve947 avdd.t384 avss 6.4676203459265e-19
Cconserve948 avdd.t385 avss 3.4002148827119e-19
Cconserve949 avdd.t386 avss 3.4002148827119e-19
Cconserve950 avdd.n604 avss 2.911040144882e-18
Cconserve951 avdd.n605 avss 1.6453100948916e-18
Cconserve952 avdd.t992 avss 7.9373489126628e-19
Cconserve953 avdd.t897 avss 4.0207882423218e-19
Cconserve954 avdd.t899 avss 3.9484279509696e-19
Cconserve955 avdd.n606 avss 1.0429226495652e-18
Cconserve956 avdd.t898 avss 2.511596960401e-18
Cconserve957 avdd.t91 avss 2.5314121792581e-19
Cconserve958 avdd.t92 avss 1.4117444922091e-18
Cconserve959 avdd.n607 avss 5.1081094415147e-19
Cconserve960 avdd.t900 avss 2.5349583127416e-18
Cconserve961 avdd.n610 avss 3.9187171028647e-19
Cconserve962 avdd.n611 avss 6.4776836977039e-19
Cconserve963 avdd.t404 avss 6.4676203459265e-19
Cconserve964 avdd.t405 avss 3.4002148827119e-19
Cconserve965 avdd.t406 avss 3.4002148827119e-19
Cconserve966 avdd.t400 avss 6.4676203459265e-19
Cconserve967 avdd.t401 avss 3.4002148827119e-19
Cconserve968 avdd.t402 avss 3.4002148827119e-19
Cconserve969 avdd.n612 avss 1.6451184120006e-18
Cconserve970 avdd.n613 avss 1.6447829669413e-18
Cconserve971 avdd.t408 avss 6.4676203459265e-19
Cconserve972 avdd.t409 avss 3.4002148827119e-19
Cconserve973 avdd.t410 avss 3.4002148827119e-19
Cconserve974 avdd.n614 avss 1.6266689337419e-18
Cconserve975 avdd.n616 avss 2.5342874226231e-19
Cconserve976 avdd.n617 avss 5.5487404871991e-19
Cconserve977 avdd.t424 avss 6.4676203459265e-19
Cconserve978 avdd.t425 avss 3.3836822333632e-19
Cconserve979 avdd.t426 avss 3.3836822333632e-19
Cconserve980 avdd.n618 avss 4.8186682761059e-19
Cconserve981 avdd.n619 avss 4.8994146939394e-19
Cconserve982 avdd.t420 avss 6.4676203459265e-19
Cconserve983 avdd.t421 avss 3.4002148827119e-19
Cconserve984 avdd.t422 avss 3.4002148827119e-19
Cconserve985 avdd.n620 avss 1.6463164300693e-18
Cconserve986 avdd.t993 avss 7.9373489126628e-19
Cconserve987 avdd.n621 avss 1.0081561652103e-18
Cconserve988 avdd.n622 avss 1.0025254802871e-18
Cconserve989 avdd.t416 avss 6.4676203459265e-19
Cconserve990 avdd.t417 avss 3.4002148827119e-19
Cconserve991 avdd.t418 avss 3.4002148827119e-19
Cconserve992 avdd.n624 avss 1.6488562283751e-18
Cconserve993 avdd.t991 avss 7.9373489126628e-19
Cconserve994 avdd.n625 avss 1.0134993257969e-18
Cconserve995 avdd.t412 avss 6.4676203459265e-19
Cconserve996 avdd.t413 avss 3.4002148827119e-19
Cconserve997 avdd.t414 avss 3.4002148827119e-19
Cconserve998 avdd.n626 avss 1.8254920124308e-18
Cconserve999 avdd.t428 avss 6.4676203459265e-19
Cconserve1000 avdd.t429 avss 3.4002148827119e-19
Cconserve1001 avdd.t430 avss 3.4002148827119e-19
Cconserve1002 avdd.t528 avss 6.4676203459265e-19
Cconserve1003 avdd.t529 avss 3.4002148827119e-19
Cconserve1004 avdd.t530 avss 3.4002148827119e-19
Cconserve1005 avdd.t532 avss 6.4676203459265e-19
Cconserve1006 avdd.t533 avss 3.4002148827119e-19
Cconserve1007 avdd.t534 avss 3.4002148827119e-19
Cconserve1008 avdd.n627 avss 1.6569308701584e-18
Cconserve1009 avdd.t552 avss 6.4676203459265e-19
Cconserve1010 avdd.t553 avss 3.4002148827119e-19
Cconserve1011 avdd.t554 avss 3.4002148827119e-19
Cconserve1012 avdd.t556 avss 6.4676203459265e-19
Cconserve1013 avdd.t557 avss 3.4002148827119e-19
Cconserve1014 avdd.t558 avss 3.4002148827119e-19
Cconserve1015 avdd.n628 avss 1.455520072441e-18
Cconserve1016 avdd.t576 avss 6.4676203459265e-19
Cconserve1017 avdd.t577 avss 3.4002148827119e-19
Cconserve1018 avdd.t578 avss 3.4002148827119e-19
Cconserve1019 avdd.t580 avss 6.4676203459265e-19
Cconserve1020 avdd.t581 avss 3.4002148827119e-19
Cconserve1021 avdd.t582 avss 3.4002148827119e-19
Cconserve1022 avdd.n629 avss 1.2148622027915e-18
Cconserve1023 avdd.t600 avss 6.4676203459265e-19
Cconserve1024 avdd.t601 avss 3.4002148827119e-19
Cconserve1025 avdd.t602 avss 3.4002148827119e-19
Cconserve1026 avdd.t656 avss 4.3775580231941e-19
Cconserve1027 avdd.t652 avss 4.3775580231941e-19
Cconserve1028 avdd.n630 avss 6.5117074108563e-19
Cconserve1029 avdd.t648 avss 4.3775580231941e-19
Cconserve1030 avdd.n631 avss 3.1263479521968e-19
Cconserve1031 avdd.t644 avss 4.3775580231941e-19
Cconserve1032 avdd.n632 avss 4.7602049943512e-19
Cconserve1033 avdd.t640 avss 4.3775580231941e-19
Cconserve1034 avdd.n633 avss 4.7295357317913e-19
Cconserve1035 avdd.t636 avss 4.3775580231941e-19
Cconserve1036 avdd.n634 avss 3.014453064576e-19
Cconserve1037 avdd.t632 avss 4.3775580231941e-19
Cconserve1038 avdd.n635 avss 2.8802750408766e-19
Cconserve1039 avdd.t588 avss 6.4676203459265e-19
Cconserve1040 avdd.t589 avss 3.4002148827119e-19
Cconserve1041 avdd.t590 avss 3.4002148827119e-19
Cconserve1042 avdd.t1005 avss 7.9351924801391e-19
Cconserve1043 avdd.t584 avss 6.4676203459265e-19
Cconserve1044 avdd.t585 avss 3.4002148827119e-19
Cconserve1045 avdd.t586 avss 3.4002148827119e-19
Cconserve1046 avdd.t1004 avss 7.9351924801391e-19
Cconserve1047 avdd.t1003 avss 8.415358122092e-19
Cconserve1048 avdd.n636 avss 1.4076712307753e-18
Cconserve1049 avdd.n637 avss 9.9497796645406e-19
Cconserve1050 avdd.n638 avss 1.4587307608652e-18
Cconserve1051 avdd.n639 avss 1.1967002488693e-18
Cconserve1052 avdd.n640 avss 1.276632014416e-18
Cconserve1053 avdd.t596 avss 4.3775580231941e-19
Cconserve1054 avdd.t1030 avss 6.0221972279671e-19
Cconserve1055 avdd.n641 avss 9.1840065149988e-19
Cconserve1056 avdd.t93 avss 6.5246460059988e-19
Cconserve1057 avdd.n642 avss 7.1435421403124e-19
Cconserve1058 avdd.t30 avss 6.5246460059988e-19
Cconserve1059 avdd.n643 avss 6.9624018083182e-19
Cconserve1060 avdd.t1038 avss 6.0221972279671e-19
Cconserve1061 avdd.n644 avss 7.5077396332109e-19
Cconserve1062 avdd.t1047 avss 6.5246460059988e-19
Cconserve1063 avdd.n645 avss 7.1435421403124e-19
Cconserve1064 avdd.t1014 avss 6.5246460059988e-19
Cconserve1065 avdd.n646 avss 7.009364116613e-19
Cconserve1066 avdd.t564 avss 6.4676203459265e-19
Cconserve1067 avdd.t565 avss 3.4002148827119e-19
Cconserve1068 avdd.t566 avss 3.4002148827119e-19
Cconserve1069 avdd.t1000 avss 7.9359112909803e-19
Cconserve1070 avdd.n647 avss 1.2244463473415e-18
Cconserve1071 avdd.t1001 avss 7.9359112909803e-19
Cconserve1072 avdd.n648 avss 1.0001054837883e-18
Cconserve1073 avdd.t1002 avss 8.4158373293195e-19
Cconserve1074 avdd.n649 avss 9.6035524426733e-19
Cconserve1075 avdd.t560 avss 6.4676203459265e-19
Cconserve1076 avdd.t561 avss 3.4002148827119e-19
Cconserve1077 avdd.t562 avss 3.4002148827119e-19
Cconserve1078 avdd.n650 avss 1.658248690034e-18
Cconserve1079 avdd.n651 avss 1.2763924108022e-18
Cconserve1080 avdd.t540 avss 6.4676203459265e-19
Cconserve1081 avdd.t541 avss 3.4002148827119e-19
Cconserve1082 avdd.t542 avss 3.4002148827119e-19
Cconserve1083 avdd.t999 avss 7.9363904982078e-19
Cconserve1084 avdd.t998 avss 7.9363904982078e-19
Cconserve1085 avdd.t997 avss 7.3968031600451e-19
Cconserve1086 avdd.n652 avss 1.0565800555489e-18
Cconserve1087 avdd.t536 avss 6.4676203459265e-19
Cconserve1088 avdd.t537 avss 3.4002148827119e-19
Cconserve1089 avdd.t538 avss 3.4002148827119e-19
Cconserve1090 avdd.n653 avss 1.6632803659227e-18
Cconserve1091 avdd.n654 avss 9.9847617921479e-19
Cconserve1092 avdd.n655 avss 1.0152723925386e-18
Cconserve1093 avdd.n656 avss 1.276823697307e-18
Cconserve1094 avdd.t984 avss 3.9204662092451e-18
Cconserve1095 avdd.t986 avss 3.9176388866029e-18
Cconserve1096 avdd.n657 avss 2.4415608241022e-19
Cconserve1097 avdd.t884 avss 3.9176388866029e-18
Cconserve1098 avdd.t886 avss 3.9176388866029e-18
Cconserve1099 avdd.t888 avss 3.9176388866029e-18
Cconserve1100 avdd.t896 avss 3.9176388866029e-18
Cconserve1101 avdd.n661 avss 2.4096935434736e-19
Cconserve1102 avdd.t548 avss 4.3775580231941e-19
Cconserve1103 avdd.t983 avss 6.5251252132263e-19
Cconserve1104 avdd.n662 avss 9.4700932298151e-19
Cconserve1105 avdd.t985 avss 6.5251252132263e-19
Cconserve1106 avdd.n663 avss 7.0350017032841e-19
Cconserve1107 avdd.t883 avss 6.5251252132263e-19
Cconserve1108 avdd.n664 avss 6.9659958625244e-19
Cconserve1109 avdd.t885 avss 6.0226764351946e-19
Cconserve1110 avdd.n665 avss 7.5115732910308e-19
Cconserve1111 avdd.t887 avss 6.5251252132263e-19
Cconserve1112 avdd.n666 avss 7.2595102893669e-19
Cconserve1113 avdd.t895 avss 6.0226764351946e-19
Cconserve1114 avdd.n667 avss 7.4200447105787e-19
Cconserve1115 avdd.t544 avss 4.3775580231941e-19
Cconserve1116 avdd.n668 avss 7.352955698729e-19
Cconserve1117 avdd.t572 avss 4.3775580231941e-19
Cconserve1118 avdd.t1016 avss 6.52919847466e-19
Cconserve1119 avdd.n670 avss 9.4686556081326e-19
Cconserve1120 avdd.t1018 avss 6.52919847466e-19
Cconserve1121 avdd.n671 avss 7.0393145683316e-19
Cconserve1122 avdd.t0 avss 6.52919847466e-19
Cconserve1123 avdd.n672 avss 6.9703087275719e-19
Cconserve1124 avdd.t2 avss 6.0265100930146e-19
Cconserve1125 avdd.n673 avss 7.5161257596921e-19
Cconserve1126 avdd.t4 avss 6.52919847466e-19
Cconserve1127 avdd.n674 avss 7.2638231544144e-19
Cconserve1128 avdd.t981 avss 6.0265100930146e-19
Cconserve1129 avdd.n675 avss 7.4210031250337e-19
Cconserve1130 avdd.t1017 avss 3.950752106023e-18
Cconserve1131 avdd.t1019 avss 3.9162012649204e-18
Cconserve1132 avdd.n676 avss 2.4415608241022e-19
Cconserve1133 avdd.t1 avss 3.9162012649204e-18
Cconserve1134 avdd.t3 avss 3.8217974411033e-18
Cconserve1135 avdd.t5 avss 3.9162012649204e-18
Cconserve1136 avdd.t982 avss 3.9162012649204e-18
Cconserve1137 avdd.n681 avss 3.6994797962844e-19
Cconserve1138 avdd.t568 avss 4.3775580231941e-19
Cconserve1139 avdd.n683 avss 5.5604810642728e-19
Cconserve1140 avdd.t1031 avss 3.9218798705662e-18
Cconserve1141 avdd.t94 avss 3.9190285875626e-18
Cconserve1142 avdd.n685 avss 2.4415608241022e-19
Cconserve1143 avdd.t31 avss 3.9190285875626e-18
Cconserve1144 avdd.t1039 avss 3.823762190736e-18
Cconserve1145 avdd.t1048 avss 3.9190285875626e-18
Cconserve1146 avdd.t1015 avss 3.9190285875626e-18
Cconserve1147 avdd.n690 avss 3.6970837601469e-19
Cconserve1148 avdd.t592 avss 4.3775580231941e-19
Cconserve1149 avdd.n693 avss 6.3399116197983e-19
Cconserve1150 avdd.t628 avss 4.3775580231941e-19
Cconserve1151 avdd.n694 avss 5.8451301574066e-19
Cconserve1152 avdd.t624 avss 6.4676203459265e-19
Cconserve1153 avdd.t625 avss 3.4002148827119e-19
Cconserve1154 avdd.t626 avss 3.4002148827119e-19
Cconserve1155 avdd.n695 avss 1.6727207483045e-18
Cconserve1156 avdd.t620 avss 6.4676203459265e-19
Cconserve1157 avdd.t621 avss 3.4002148827119e-19
Cconserve1158 avdd.t622 avss 3.4002148827119e-19
Cconserve1159 avdd.n696 avss 1.6454059363371e-18
Cconserve1160 avdd.t616 avss 6.4676203459265e-19
Cconserve1161 avdd.t617 avss 3.4002148827119e-19
Cconserve1162 avdd.t618 avss 3.4002148827119e-19
Cconserve1163 avdd.n697 avss 1.654223349323e-18
Cconserve1164 avdd.t612 avss 6.4676203459265e-19
Cconserve1165 avdd.t613 avss 3.4002148827119e-19
Cconserve1166 avdd.t614 avss 3.4002148827119e-19
Cconserve1167 avdd.n698 avss 1.6398710928595e-18
Cconserve1168 avdd.t608 avss 6.4676203459265e-19
Cconserve1169 avdd.t609 avss 3.4002148827119e-19
Cconserve1170 avdd.t610 avss 3.4002148827119e-19
Cconserve1171 avdd.n699 avss 1.6453100948916e-18
Cconserve1172 avdd.t604 avss 6.4676203459265e-19
Cconserve1173 avdd.t605 avss 3.4002148827119e-19
Cconserve1174 avdd.t606 avss 3.4002148827119e-19
Cconserve1175 avdd.n700 avss 1.6449986101937e-18
Cconserve1176 avdd.n701 avss 1.4449295927133e-18
Cconserve1177 avdd.t994 avss 7.9368697054353e-19
Cconserve1178 avdd.n702 avss 1.0075331958145e-18
Cconserve1179 avdd.t995 avss 8.4170353473883e-19
Cconserve1180 avdd.n703 avss 9.5558713235372e-19
Cconserve1181 avdd.t432 avss 6.4676203459265e-19
Cconserve1182 avdd.t433 avss 3.4002148827119e-19
Cconserve1183 avdd.t434 avss 3.4002148827119e-19
Cconserve1184 avdd.n704 avss 1.6513001852353e-18
Cconserve1185 avdd.n705 avss 1.0139785330244e-18
Cconserve1186 avdd.n706 avss 1.6465320733217e-18
Cconserve1187 avdd.n707 avss 1.5212673040537e-18
Cconserve1188 avdd.n708 avss 6.5610657552886e-19
Cconserve1189 avdd.t448 avss 4.3775580231941e-19
Cconserve1190 avdd.n709 avss 4.7290565245638e-19
Cconserve1191 avdd.t452 avss 4.3775580231941e-19
Cconserve1192 avdd.n710 avss 3.0072649561636e-19
Cconserve1193 avdd.t456 avss 4.3775580231941e-19
Cconserve1194 avdd.n711 avss 2.895130464929e-19
Cconserve1195 avdd.t460 avss 4.3775580231941e-19
Cconserve1196 avdd.n712 avss 2.895130464929e-19
Cconserve1197 avdd.t464 avss 4.3775580231941e-19
Cconserve1198 avdd.n713 avss 2.895130464929e-19
Cconserve1199 avdd.t468 avss 4.3775580231941e-19
Cconserve1200 avdd.n714 avss 3.0072649561636e-19
Cconserve1201 avdd.n715 avss 5.982183424471e-19
Cconserve1202 avdd.t1036 avss 8.0226477991574e-19
Cconserve1203 avdd.n716 avss 1.2680302446824e-18
Cconserve1204 avdd.t918 avss 4.7433368999433e-18
Cconserve1205 avdd.n721 avss 5.1191312077472e-19
Cconserve1206 avdd.t9 avss 8.8851968482924e-18
Cconserve1207 avdd.t8 avss 1.3850047289147e-18
Cconserve1208 avdd.n723 avss 1.6169410270237e-18
Cconserve1209 avdd.t380 avss 1.2168029920629e-18
Cconserve1210 avdd.t381 avss 7.1646272583223e-19
Cconserve1211 avdd.t382 avss 7.1646272583223e-19
Cconserve1212 avdd.t376 avss 1.2168029920629e-18
Cconserve1213 avdd.t377 avss 7.1646272583223e-19
Cconserve1214 avdd.t378 avss 7.1646272583223e-19
Cconserve1215 avdd.n727 avss 9.1007921799438e-18
Cconserve1216 avdd.t372 avss 1.2168029920629e-18
Cconserve1217 avdd.t373 avss 7.1646272583223e-19
Cconserve1218 avdd.t374 avss 7.1646272583223e-19
Cconserve1219 avdd.n728 avss 5.3801314242039e-18
Cconserve1220 avdd.t368 avss 1.2168029920629e-18
Cconserve1221 avdd.t369 avss 7.1646272583223e-19
Cconserve1222 avdd.t370 avss 7.1646272583223e-19
Cconserve1223 avdd.n729 avss 5.3801314242039e-18
Cconserve1224 avdd.t364 avss 1.2168029920629e-18
Cconserve1225 avdd.t365 avss 7.1646272583223e-19
Cconserve1226 avdd.t366 avss 7.1646272583223e-19
Cconserve1227 avdd.n730 avss 5.379939741313e-18
Cconserve1228 avdd.t360 avss 1.2168029920629e-18
Cconserve1229 avdd.t361 avss 7.1646272583223e-19
Cconserve1230 avdd.t362 avss 7.1646272583223e-19
Cconserve1231 avdd.t356 avss 1.2168029920629e-18
Cconserve1232 avdd.t357 avss 7.1646272583223e-19
Cconserve1233 avdd.t358 avss 7.1646272583223e-19
Cconserve1234 avdd.n731 avss 5.3796522169765e-18
Cconserve1235 avdd.n732 avss 4.986247043562e-18
Cconserve1236 avdd.n733 avss 5.7288265632929e-18
Cconserve1237 avdd.n734 avss 1.6472029634402e-18
Cconserve1238 avdd.t57 avss 6.0489369912615e-18
Cconserve1239 avdd.t19 avss 5.6057661472714e-18
Cconserve1240 avdd.t56 avss 1.4479485982465e-18
Cconserve1241 avdd.n737 avss 1.5885719591558e-18
Cconserve1242 avdd.t340 avss 1.2168029920629e-18
Cconserve1243 avdd.t341 avss 7.1646272583223e-19
Cconserve1244 avdd.t342 avss 7.1646272583223e-19
Cconserve1245 avdd.t20 avss 1.3914500661245e-18
Cconserve1246 avdd.n741 avss 5.345364939849e-18
Cconserve1247 avdd.t22 avss 1.4483319640285e-18
Cconserve1248 avdd.n742 avss 1.6151200395592e-18
Cconserve1249 avdd.t21 avss 6.1585556445517e-18
Cconserve1250 avdd.t23 avss 6.047499369579e-18
Cconserve1251 avdd.t24 avss 1.4483319640285e-18
Cconserve1252 avdd.n745 avss 1.6063026265732e-18
Cconserve1253 avdd.t60 avss 1.4483319640285e-18
Cconserve1254 avdd.n746 avss 1.6334257556496e-18
Cconserve1255 avdd.t62 avss 1.3914500661245e-18
Cconserve1256 avdd.t935 avss 1.3914500661245e-18
Cconserve1257 avdd.t336 avss 1.2168029920629e-18
Cconserve1258 avdd.t337 avss 7.1646272583223e-19
Cconserve1259 avdd.t338 avss 7.1646272583223e-19
Cconserve1260 avdd.n747 avss 5.3629039243754e-18
Cconserve1261 avdd.n748 avss 1.6501021671665e-18
Cconserve1262 avdd.t25 avss 6.0555260906396e-18
Cconserve1263 avdd.t63 avss 6.0500152075234e-18
Cconserve1264 avdd.t936 avss 6.0636246927843e-18
Cconserve1265 avdd.t332 avss 1.2168029920629e-18
Cconserve1266 avdd.t333 avss 7.1646272583223e-19
Cconserve1267 avdd.t334 avss 7.1646272583223e-19
Cconserve1268 avdd.t328 avss 1.2168029920629e-18
Cconserve1269 avdd.t329 avss 7.1646272583223e-19
Cconserve1270 avdd.t330 avss 7.1646272583223e-19
Cconserve1271 avdd.n754 avss 9.083037552165e-18
Cconserve1272 avdd.t937 avss 1.3914740264859e-18
Cconserve1273 avdd.n755 avss 1.6452382138074e-18
Cconserve1274 avdd.t938 avss 6.1484443720515e-18
Cconserve1275 avdd.t50 avss 1.4483559243899e-18
Cconserve1276 avdd.n757 avss 1.6063026265732e-18
Cconserve1277 avdd.t52 avss 1.4483559243899e-18
Cconserve1278 avdd.n758 avss 1.5976050153941e-18
Cconserve1279 avdd.t51 avss 6.0662363721742e-18
Cconserve1280 avdd.t53 avss 6.0454866992235e-18
Cconserve1281 avdd.n762 avss 1.6448788083868e-18
Cconserve1282 avdd.t34 avss 1.3914740264859e-18
Cconserve1283 avdd.n763 avss 1.6544869132982e-18
Cconserve1284 avdd.t324 avss 1.2168029920629e-18
Cconserve1285 avdd.t325 avss 7.1646272583223e-19
Cconserve1286 avdd.t326 avss 7.1646272583223e-19
Cconserve1287 avdd.n764 avss 4.1447591520755e-18
Cconserve1288 avdd.t320 avss 1.2168029920629e-18
Cconserve1289 avdd.t321 avss 7.1646272583223e-19
Cconserve1290 avdd.t322 avss 7.1646272583223e-19
Cconserve1291 avdd.t316 avss 1.2168029920629e-18
Cconserve1292 avdd.t317 avss 7.1646272583223e-19
Cconserve1293 avdd.t318 avss 7.1646272583223e-19
Cconserve1294 avdd.n767 avss 9.0817916133735e-18
Cconserve1295 avdd.t312 avss 1.2168029920629e-18
Cconserve1296 avdd.t313 avss 7.1646272583223e-19
Cconserve1297 avdd.t314 avss 7.1646272583223e-19
Cconserve1298 avdd.n768 avss 5.3801314242039e-18
Cconserve1299 avdd.t308 avss 1.2168029920629e-18
Cconserve1300 avdd.t309 avss 7.1646272583223e-19
Cconserve1301 avdd.t310 avss 7.1646272583223e-19
Cconserve1302 avdd.n769 avss 5.3801314242039e-18
Cconserve1303 avdd.t304 avss 1.2168029920629e-18
Cconserve1304 avdd.t305 avss 7.1646272583223e-19
Cconserve1305 avdd.t306 avss 7.1646272583223e-19
Cconserve1306 avdd.n770 avss 5.3801314242039e-18
Cconserve1307 avdd.t300 avss 1.2168029920629e-18
Cconserve1308 avdd.t301 avss 7.1646272583223e-19
Cconserve1309 avdd.t302 avss 7.1646272583223e-19
Cconserve1310 avdd.n771 avss 5.3801314242039e-18
Cconserve1311 avdd.t296 avss 1.2168029920629e-18
Cconserve1312 avdd.t297 avss 7.1646272583223e-19
Cconserve1313 avdd.t298 avss 7.1646272583223e-19
Cconserve1314 avdd.t292 avss 1.2168029920629e-18
Cconserve1315 avdd.t293 avss 7.1646272583223e-19
Cconserve1316 avdd.t294 avss 7.1646272583223e-19
Cconserve1317 avdd.n772 avss 5.2001411895557e-18
Cconserve1318 avdd.t260 avss 1.2189594245866e-18
Cconserve1319 avdd.t261 avss 7.1794826823747e-19
Cconserve1320 avdd.t262 avss 7.1794826823747e-19
Cconserve1321 avdd.n773 avss 2.7917894263191e-18
Cconserve1322 avdd.t83 avss 1.3944690716577e-18
Cconserve1323 avdd.t85 avss 1.3944690716577e-18
Cconserve1324 avdd.t252 avss 1.2189594245866e-18
Cconserve1325 avdd.t253 avss 7.1794826823747e-19
Cconserve1326 avdd.t254 avss 7.1794826823747e-19
Cconserve1327 avdd.t79 avss 1.3938700626234e-18
Cconserve1328 avdd.t75 avss 6.0767549708178e-18
Cconserve1329 avdd.t67 avss 6.055933416783e-18
Cconserve1330 avdd.n778 avss 2.7020099522474e-19
Cconserve1331 avdd.t891 avss 1.4509436434184e-18
Cconserve1332 avdd.t176 avss 1.2189594245866e-18
Cconserve1333 avdd.t177 avss 7.1794826823747e-19
Cconserve1334 avdd.t178 avss 7.1794826823747e-19
Cconserve1335 avdd.t172 avss 1.2189594245866e-18
Cconserve1336 avdd.t173 avss 7.1794826823747e-19
Cconserve1337 avdd.t174 avss 7.1794826823747e-19
Cconserve1338 avdd.t168 avss 1.2189594245866e-18
Cconserve1339 avdd.t169 avss 7.1794826823747e-19
Cconserve1340 avdd.t170 avss 7.1794826823747e-19
Cconserve1341 avdd.t164 avss 1.2189594245866e-18
Cconserve1342 avdd.t165 avss 7.1794826823747e-19
Cconserve1343 avdd.t166 avss 7.1794826823747e-19
Cconserve1344 avdd.n780 avss 2.8830544427961e-18
Cconserve1345 avdd.t160 avss 1.2189594245866e-18
Cconserve1346 avdd.t161 avss 7.1794826823747e-19
Cconserve1347 avdd.t162 avss 7.1794826823747e-19
Cconserve1348 avdd.n781 avss 2.8887090880806e-18
Cconserve1349 avdd.t156 avss 1.2189594245866e-18
Cconserve1350 avdd.t157 avss 7.1794826823747e-19
Cconserve1351 avdd.t158 avss 7.1794826823747e-19
Cconserve1352 avdd.t152 avss 1.2189594245866e-18
Cconserve1353 avdd.t153 avss 7.1794826823747e-19
Cconserve1354 avdd.t154 avss 7.1794826823747e-19
Cconserve1355 avdd.t80 avss 6.0645831072393e-18
Cconserve1356 avdd.t59 avss 6.0575866817178e-18
Cconserve1357 avdd.t148 avss 1.2189594245866e-18
Cconserve1358 avdd.t149 avss 7.1794826823747e-19
Cconserve1359 avdd.t150 avss 7.1794826823747e-19
Cconserve1360 avdd.n784 avss 2.9199294389521e-18
Cconserve1361 avdd.n785 avss 1.6091299492155e-18
Cconserve1362 avdd.n786 avss 2.6855012632601e-18
Cconserve1363 avdd.n787 avss 1.624632303025e-18
Cconserve1364 avdd.n788 avss 1.3971286717704e-18
Cconserve1365 avdd.n789 avss 1.571967428723e-18
Cconserve1366 avdd.n790 avss 2.8798677147332e-18
Cconserve1367 avdd.n791 avss 2.8798677147332e-18
Cconserve1368 avdd.t889 avss 1.3938700626234e-18
Cconserve1369 avdd.n792 avss 1.6449506894709e-18
Cconserve1370 avdd.t196 avss 1.2189594245866e-18
Cconserve1371 avdd.t197 avss 7.1794826823747e-19
Cconserve1372 avdd.t198 avss 7.1794826823747e-19
Cconserve1373 avdd.n793 avss 2.8632631843004e-18
Cconserve1374 avdd.n794 avss 2.4579257509213e-18
Cconserve1375 avdd.t256 avss 1.2189594245866e-18
Cconserve1376 avdd.t257 avss 7.1794826823747e-19
Cconserve1377 avdd.t258 avss 7.1794826823747e-19
Cconserve1378 avdd.t10 avss 1.3944690716577e-18
Cconserve1379 avdd.t40 avss 1.4515186920914e-18
Cconserve1380 avdd.n795 avss 1.5998572893634e-18
Cconserve1381 avdd.t38 avss 1.4515186920914e-18
Cconserve1382 avdd.n796 avss 1.6085788609038e-18
Cconserve1383 avdd.t11 avss 6.1681877098244e-18
Cconserve1384 avdd.t13 avss 6.0570116330448e-18
Cconserve1385 avdd.t12 avss 1.4515186920914e-18
Cconserve1386 avdd.n799 avss 1.6173962738898e-18
Cconserve1387 avdd.n800 avss 1.6564277025695e-18
Cconserve1388 avdd.n801 avss 2.8632631843004e-18
Cconserve1389 avdd.n802 avss 2.3451443299296e-18
Cconserve1390 avdd.n803 avss 8.1683267963168e-19
Cconserve1391 avdd.n804 avss 2.195296229891e-18
Cconserve1392 avdd.t288 avss 1.2189594245866e-18
Cconserve1393 avdd.t289 avss 7.1794826823747e-19
Cconserve1394 avdd.t290 avss 7.1794826823747e-19
Cconserve1395 avdd.n805 avss 2.8730390117414e-18
Cconserve1396 avdd.t284 avss 1.2189594245866e-18
Cconserve1397 avdd.t285 avss 7.1794826823747e-19
Cconserve1398 avdd.t286 avss 7.1794826823747e-19
Cconserve1399 avdd.t280 avss 1.2189594245866e-18
Cconserve1400 avdd.t281 avss 7.1794826823747e-19
Cconserve1401 avdd.t282 avss 7.1794826823747e-19
Cconserve1402 avdd.t276 avss 1.2189594245866e-18
Cconserve1403 avdd.t277 avss 7.1794826823747e-19
Cconserve1404 avdd.t278 avss 7.1794826823747e-19
Cconserve1405 avdd.t272 avss 1.2189594245866e-18
Cconserve1406 avdd.t273 avss 7.1794826823747e-19
Cconserve1407 avdd.t274 avss 7.1794826823747e-19
Cconserve1408 avdd.n806 avss 2.8965441262502e-18
Cconserve1409 avdd.n807 avss 2.5138252740089e-18
Cconserve1410 avdd.n808 avss 2.4909191685345e-18
Cconserve1411 avdd.n809 avss 2.8967118487798e-18
Cconserve1412 avdd.n810 avss 2.8940043279444e-18
Cconserve1413 avdd.n811 avss 2.8937886846921e-18
Cconserve1414 avdd.n812 avss 2.1988423633745e-18
Cconserve1415 avdd.n813 avss 5.9924863798622e-19
Cconserve1416 avdd.n814 avss 3.5636245472887e-19
Cconserve1417 avdd.n815 avss 2.0181572782464e-18
Cconserve1418 avdd.n816 avss 8.2150495009979e-19
Cconserve1419 avdd.n817 avss 2.8939324468603e-19
Cconserve1420 avdd.n818 avss 2.7020099522474e-19
Cconserve1421 avdd.n819 avss 1.6107352934276e-18
Cconserve1422 avdd.t890 avss 6.1668459295874e-18
Cconserve1423 avdd.t892 avss 6.055933416783e-18
Cconserve1424 avdd.t74 avss 1.4509436434184e-18
Cconserve1425 avdd.n822 avss 1.6195527064135e-18
Cconserve1426 avdd.t66 avss 1.4509436434184e-18
Cconserve1427 avdd.t39 avss 6.0631934062796e-18
Cconserve1428 avdd.t41 avss 6.0570116330448e-18
Cconserve1429 avdd.n825 avss 1.6467956372968e-18
Cconserve1430 avdd.n826 avss 3.9592101135883e-19
Cconserve1431 avdd.n828 avss 1.6470831616333e-18
Cconserve1432 avdd.t58 avss 1.3938700626234e-18
Cconserve1433 avdd.n829 avss 1.6566673061833e-18
Cconserve1434 avdd.t192 avss 1.2189594245866e-18
Cconserve1435 avdd.t193 avss 7.1794826823747e-19
Cconserve1436 avdd.t194 avss 7.1794826823747e-19
Cconserve1437 avdd.n831 avss 2.8474733061544e-18
Cconserve1438 avdd.n832 avss 3.2856603949785e-18
Cconserve1439 avdd.n833 avss 2.114382089528e-18
Cconserve1440 avdd.n834 avss 1.3560366520124e-18
Cconserve1441 avdd.t86 avss 6.0586648979797e-18
Cconserve1442 avdd.t84 avss 6.0656373631398e-18
Cconserve1443 avdd.t188 avss 1.20594894836e-18
Cconserve1444 avdd.t189 avss 7.0905897416739e-19
Cconserve1445 avdd.t190 avss 7.0905897416739e-19
Cconserve1446 avdd.t76 avss 1.3776488979726e-18
Cconserve1447 avdd.t184 avss 1.20594894836e-18
Cconserve1448 avdd.t185 avss 7.0905897416739e-19
Cconserve1449 avdd.t186 avss 7.0905897416739e-19
Cconserve1450 avdd.n835 avss 5.2876204689355e-18
Cconserve1451 avdd.t77 avss 5.9937802393765e-18
Cconserve1452 avdd.t144 avss 1.20594894836e-18
Cconserve1453 avdd.t145 avss 7.0905897416739e-19
Cconserve1454 avdd.t146 avss 7.0905897416739e-19
Cconserve1455 avdd.t140 avss 1.20594894836e-18
Cconserve1456 avdd.t141 avss 7.0905897416739e-19
Cconserve1457 avdd.t142 avss 7.0905897416739e-19
Cconserve1458 avdd.n836 avss 8.9968042115767e-18
Cconserve1459 avdd.t136 avss 1.20594894836e-18
Cconserve1460 avdd.t137 avss 7.0905897416739e-19
Cconserve1461 avdd.t138 avss 7.0905897416739e-19
Cconserve1462 avdd.n837 avss 5.3245673461756e-18
Cconserve1463 avdd.t132 avss 1.20594894836e-18
Cconserve1464 avdd.t133 avss 7.0905897416739e-19
Cconserve1465 avdd.t134 avss 7.0905897416739e-19
Cconserve1466 avdd.n838 avss 5.3245673461756e-18
Cconserve1467 avdd.t128 avss 1.20594894836e-18
Cconserve1468 avdd.t129 avss 7.0905897416739e-19
Cconserve1469 avdd.t130 avss 7.0905897416739e-19
Cconserve1470 avdd.n839 avss 5.3245673461756e-18
Cconserve1471 avdd.t124 avss 1.20594894836e-18
Cconserve1472 avdd.t125 avss 7.0905897416739e-19
Cconserve1473 avdd.t126 avss 7.0905897416739e-19
Cconserve1474 avdd.t120 avss 1.20594894836e-18
Cconserve1475 avdd.t121 avss 7.0905897416739e-19
Cconserve1476 avdd.t122 avss 7.0905897416739e-19
Cconserve1477 avdd.t116 avss 1.20594894836e-18
Cconserve1478 avdd.t117 avss 7.0905897416739e-19
Cconserve1479 avdd.t118 avss 7.0905897416739e-19
Cconserve1480 avdd.t112 avss 1.20594894836e-18
Cconserve1481 avdd.t113 avss 7.0905897416739e-19
Cconserve1482 avdd.t114 avss 7.0905897416739e-19
Cconserve1483 avdd.t108 avss 1.20594894836e-18
Cconserve1484 avdd.t109 avss 7.0905897416739e-19
Cconserve1485 avdd.t110 avss 7.0905897416739e-19
Cconserve1486 avdd.t104 avss 1.20594894836e-18
Cconserve1487 avdd.t105 avss 7.0905897416739e-19
Cconserve1488 avdd.t106 avss 7.0905897416739e-19
Cconserve1489 avdd.t100 avss 1.20594894836e-18
Cconserve1490 avdd.t101 avss 7.0905897416739e-19
Cconserve1491 avdd.t102 avss 7.0905897416739e-19
Cconserve1492 avdd.t96 avss 1.20594894836e-18
Cconserve1493 avdd.t97 avss 7.0905897416739e-19
Cconserve1494 avdd.t98 avss 7.0905897416739e-19
Cconserve1495 avdd.t73 avss 6.082265853934e-18
Cconserve1496 avdd.t934 avss 5.9973024124986e-18
Cconserve1497 avdd.t933 avss 1.4444983062085e-18
Cconserve1498 avdd.n840 avss 1.6229790380902e-18
Cconserve1499 avdd.t89 avss 1.4336921832285e-18
Cconserve1500 avdd.n841 avss 1.5983477865968e-18
Cconserve1501 avdd.t36 avss 1.3776488979726e-18
Cconserve1502 avdd.n842 avss 1.6335215970951e-18
Cconserve1503 avdd.t90 avss 6.0123015987193e-18
Cconserve1504 avdd.t37 avss 5.9913123221549e-18
Cconserve1505 avdd.t46 avss 1.4336921832285e-18
Cconserve1506 avdd.n845 avss 1.5954006621477e-18
Cconserve1507 avdd.t72 avss 1.3776488979726e-18
Cconserve1508 avdd.t180 avss 1.20594894836e-18
Cconserve1509 avdd.t181 avss 7.0905897416739e-19
Cconserve1510 avdd.t182 avss 7.0905897416739e-19
Cconserve1511 avdd.n846 avss 5.2823971101557e-18
Cconserve1512 avdd.t47 avss 5.9967273638256e-18
Cconserve1513 avdd.n850 avss 4.1157431544505e-18
Cconserve1514 avdd.n851 avss 5.3073877670698e-18
Cconserve1515 avdd.n852 avss 5.3245673461756e-18
Cconserve1516 avdd.n853 avss 5.3245673461756e-18
Cconserve1517 avdd.n854 avss 5.3245673461756e-18
Cconserve1518 avdd.n855 avss 5.3245673461756e-18
Cconserve1519 avdd.n856 avss 5.3243996236459e-18
Cconserve1520 avdd.t1046 avss 5.9919113311892e-18
Cconserve1521 avdd.t1045 avss 1.4336921832285e-18
Cconserve1522 avdd.n860 avss 1.5779575190667e-18
Cconserve1523 avdd.t908 avss 6.0114150653484e-18
Cconserve1524 avdd.t907 avss 1.4336921832285e-18
Cconserve1525 avdd.n862 avss 1.5762323730477e-18
Cconserve1526 avdd.t1033 avss 6.0122297176352e-18
Cconserve1527 avdd.t1032 avss 1.4336921832285e-18
Cconserve1528 avdd.n864 avss 1.5779575190667e-18
Cconserve1529 avdd.t894 avss 6.0114150653484e-18
Cconserve1530 avdd.t893 avss 1.4336921832285e-18
Cconserve1531 avdd.n866 avss 3.0916773092873e-18
Cconserve1532 avdd.n867 avss 3.794937876002e-18
Cconserve1533 avdd.t249 avss 7.0903501380601e-19
Cconserve1534 avdd.t250 avss 7.0903501380601e-19
Cconserve1535 avdd.t248 avss 1.20594894836e-18
Cconserve1536 avdd.t240 avss 1.20594894836e-18
Cconserve1537 avdd.t241 avss 7.0905897416739e-19
Cconserve1538 avdd.t242 avss 7.0905897416739e-19
Cconserve1539 avdd.t236 avss 1.20594894836e-18
Cconserve1540 avdd.t237 avss 7.0905897416739e-19
Cconserve1541 avdd.t238 avss 7.0905897416739e-19
Cconserve1542 avdd.t232 avss 1.20594894836e-18
Cconserve1543 avdd.t233 avss 7.0905897416739e-19
Cconserve1544 avdd.t234 avss 7.0905897416739e-19
Cconserve1545 avdd.t228 avss 1.20594894836e-18
Cconserve1546 avdd.t229 avss 7.0905897416739e-19
Cconserve1547 avdd.t230 avss 7.0905897416739e-19
Cconserve1548 avdd.t224 avss 1.20594894836e-18
Cconserve1549 avdd.t225 avss 7.0905897416739e-19
Cconserve1550 avdd.t226 avss 7.0905897416739e-19
Cconserve1551 avdd.t220 avss 1.20594894836e-18
Cconserve1552 avdd.t221 avss 7.0905897416739e-19
Cconserve1553 avdd.t222 avss 7.0905897416739e-19
Cconserve1554 avdd.t216 avss 1.20594894836e-18
Cconserve1555 avdd.t217 avss 7.0905897416739e-19
Cconserve1556 avdd.t218 avss 7.0905897416739e-19
Cconserve1557 avdd.t212 avss 1.20594894836e-18
Cconserve1558 avdd.t213 avss 7.0905897416739e-19
Cconserve1559 avdd.t214 avss 7.0905897416739e-19
Cconserve1560 avdd.t208 avss 1.20594894836e-18
Cconserve1561 avdd.t209 avss 7.0905897416739e-19
Cconserve1562 avdd.t210 avss 7.0905897416739e-19
Cconserve1563 avdd.t204 avss 1.20594894836e-18
Cconserve1564 avdd.t205 avss 7.0905897416739e-19
Cconserve1565 avdd.t206 avss 7.0905897416739e-19
Cconserve1566 avdd.t200 avss 1.20594894836e-18
Cconserve1567 avdd.t201 avss 7.0905897416739e-19
Cconserve1568 avdd.t202 avss 7.0905897416739e-19
Cconserve1569 avdd.n868 avss 8.987747194977e-18
Cconserve1570 avdd.n869 avss 5.3245673461756e-18
Cconserve1571 avdd.n870 avss 5.3245673461756e-18
Cconserve1572 avdd.n871 avss 5.3245673461756e-18
Cconserve1573 avdd.n872 avss 5.3245673461756e-18
Cconserve1574 avdd.n873 avss 5.3245673461756e-18
Cconserve1575 avdd.n874 avss 5.3245673461756e-18
Cconserve1576 avdd.n875 avss 5.3245673461756e-18
Cconserve1577 avdd.n876 avss 5.3245673461756e-18
Cconserve1578 avdd.n877 avss 7.617741652283e-18
Cconserve1579 avdd.t244 avss 1.20594894836e-18
Cconserve1580 avdd.t245 avss 7.0903501380601e-19
Cconserve1581 avdd.t246 avss 7.0903501380601e-19
Cconserve1582 avdd.n878 avss 4.2826989525108e-18
Cconserve1583 avdd.n879 avss 1.5490373628872e-18
Cconserve1584 avdd.n883 avss 1.656906909797e-18
Cconserve1585 avdd.n884 avss 1.6473227652471e-18
Cconserve1586 avdd.t269 avss 7.173492592031e-19
Cconserve1587 avdd.t270 avss 7.173492592031e-19
Cconserve1588 avdd.t268 avss 1.2189594245866e-18
Cconserve1589 avdd.n886 avss 1.5862478041024e-18
Cconserve1590 avdd.n887 avss 1.5920462115552e-18
Cconserve1591 avdd.n888 avss 1.2569126370045e-18
Cconserve1592 avdd.n889 avss 3.5310384558189e-19
Cconserve1593 avdd.n890 avss 2.8981494704623e-18
Cconserve1594 avdd bgsu1 1.00868e-15
Cconserve1595 iref_gate avdd 2.08364e-14
Cconserve1596 net3 avdd 4.40795e-15
Cconserve1597 pm1 avdd 3.22079e-14
Cconserve1598 pm2 avdd 3.1909e-14
Cconserve1599 avdd psrg_m3_feed 5.48926e-14
Cconserve1600 avdd psrg_vnc 1.63334e-14
Cconserve1601 rb_mid avdd 1.00229e-15
Cconserve1602 su_state avdd 3.91082e-15
Cconserve1603 v1 avdd 1.95682e-14
Cconserve1604 avdd v2 1.96802e-14
Cconserve1605 avdd vaux 4.46554e-15
Cconserve1606 avdd vbn 2.00673e-15
Cconserve1607 avdd vbn_fold 4.06125e-14
Cconserve1608 avdd vbn_i 1.81783e-14
Cconserve1609 vbn_sink avdd 4.12057e-14
Cconserve1610 vbp_bias avdd 7.13381e-14
Cconserve1611 avdd vbp_cas 8.86687e-14
Cconserve1612 avdd vbp_i 2.0617e-13
Cconserve1613 vbp_tail avdd 3.66034e-14
Cconserve1614 vcasp avdd 4.6192e-14
Cconserve1615 avdd vgn1 1.98104e-14
Cconserve1616 avdd vgn2 1.94907e-14
Cconserve1617 avdd vnx_bias 3.2289e-16
Cconserve1618 vq3 avdd 1.63694e-14
Cconserve1619 vref avdd 2.81483e-14
Cconserve1620 avdd vsp 7.361671e-14
Cconserve1621 vsu avdd 4.032e-15
Cconserve1622 vsu1 avdd 5.438e-16
Cconserve1623 vsu2 avdd 1.20354e-15
Cconserve1624 vsua avdd 6.9736e-16
Cconserve1625 vx1 avdd 2.54361e-14
Cconserve1626 avdd vx2 2.66506e-14
Cconserve1627 avdd vx3 2.58418e-14
Cconserve1628 avdd xf1 3.3834e-14
Cconserve1629 avdd xf2 3.1138e-14
Cconserve1630 y1 avdd 4.94663e-14
Cconserve1631 b1_b avss 3.4373011076131e-16
Cconserve1632 b1_b.t1 avss 5.0765355700071e-17
Cconserve1633 b1_b.t0 avss 1.3362471553646e-16
Cconserve1634 b1_b.n0 avss 4.9996206728405e-16
Cconserve1635 b1_b.n1 avss 4.1820221720247e-16
Cconserve1636 b1_b.n2 avss 2.1124553351564e-16
Cconserve1637 b2_b avss 2.4627698188883e-16
Cconserve1638 b2_b.t1 avss 1.9200441306389e-17
Cconserve1639 b2_b.t0 avss 9.5047111543946e-17
Cconserve1640 b2_b.n0 avss 3.3387500225085e-16
Cconserve1641 b2_b.n1 avss 3.1178761849774e-16
Cconserve1642 b2_b.n2 avss 8.3492844512241e-17
Cconserve1643 b5_b avss 5.3171194511715e-16
Cconserve1644 b5_b.t1 avss 3.3051716844594e-17
Cconserve1645 b5_b.t0 avss 7.2063294834133e-17
Cconserve1646 b5_b.n0 avss 3.3209304320413e-16
Cconserve1647 dvdd avss 1.5571758898574e-13
Cconserve1648 dvdd.n0 avss 1.9590710914692e-16
Cconserve1649 dvdd.n1 avss 1.8372524890542e-15
Cconserve1650 dvdd.n2 avss 1.8858831525804e-16
Cconserve1651 dvdd.t5 avss 4.947612199375e-16
Cconserve1652 dvdd.n3 avss 9.4917162398073e-16
Cconserve1653 dvdd.n4 avss 9.2565605022755e-16
Cconserve1654 dvdd.t16 avss 1.1632715476889e-15
Cconserve1655 dvdd.n5 avss 1.5771631194492e-15
Cconserve1656 dvdd.t25 avss 1.5778083023816e-16
Cconserve1657 dvdd.t10 avss 2.9685807609361e-16
Cconserve1658 dvdd.t11 avss 1.4049530417552e-16
Cconserve1659 dvdd.n6 avss 1.0824287821339e-16
Cconserve1660 dvdd.n7 avss 6.5365767899619e-16
Cconserve1661 dvdd.t17 avss 2.6171576824698e-16
Cconserve1662 dvdd.n8 avss 6.9363885883547e-16
Cconserve1663 dvdd.n9 avss 1.050438461738e-16
Cconserve1664 dvdd.t24 avss 2.4881883025546e-16
Cconserve1665 dvdd.n10 avss 6.1769545117302e-16
Cconserve1666 dvdd.t27 avss 1.6840618665535e-16
Cconserve1667 dvdd.t26 avss 2.9870625636858e-16
Cconserve1668 dvdd.n11 avss 6.0842766717599e-16
Cconserve1669 dvdd.t29 avss 1.7236465277157e-16
Cconserve1670 dvdd.t28 avss 2.9769143738123e-16
Cconserve1671 dvdd.t2 avss 2.4247856381397e-15
Cconserve1672 dvdd.n12 avss 1.5626935480601e-15
Cconserve1673 dvdd.t1 avss 1.7774789786339e-16
Cconserve1674 dvdd.t0 avss 2.7385327216188e-16
Cconserve1675 dvdd.n13 avss 6.0089381230965e-16
Cconserve1676 dvdd.n14 avss 6.7871900352479e-17
Cconserve1677 dvdd.t6 avss 2.967975901937e-16
Cconserve1678 dvdd.t8 avss 2.9734868394842e-16
Cconserve1679 dvdd.t19 avss 3.4590004373913e-15
Cconserve1680 dvdd.t22 avss 3.4136628950824e-15
Cconserve1681 dvdd.n15 avss 3.0337576784149e-15
Cconserve1682 dvdd.t3 avss 3.4136360124602e-15
Cconserve1683 dvdd.n16 avss 1.5510869759333e-15
Cconserve1684 dvdd.t18 avss 3.41597480059e-15
Cconserve1685 dvdd.n17 avss 1.5381429933529e-15
Cconserve1686 dvdd.t14 avss 3.4658756680142e-15
Cconserve1687 dvdd.t13 avss 3.4165460563113e-15
Cconserve1688 dvdd.n18 avss 3.0273864969579e-15
Cconserve1689 dvdd.t12 avss 3.4136292918046e-15
Cconserve1690 dvdd.n19 avss 1.5551596931938e-15
Cconserve1691 dvdd.t21 avss 3.4168283238442e-15
Cconserve1692 dvdd.n20 avss 1.5594071474984e-15
Cconserve1693 dvdd.t15 avss 3.4136763363935e-15
Cconserve1694 dvdd.n21 avss 1.5327530276056e-15
Cconserve1695 dvdd.n22 avss 9.3729622563209e-16
Cconserve1696 dvdd.n23 avss 1.5664839977877e-15
Cconserve1697 dvdd.t4 avss 1.0959574617467e-15
Cconserve1698 dvdd.n24 avss 1.3076715527363e-15
Cconserve1699 dvdd.n25 avss 5.7116835283257e-16
Cconserve1700 dvdd.t9 avss 1.6495849036059e-16
Cconserve1701 dvdd.t7 avss 1.5688026239508e-16
Cconserve1702 dvdd.n28 avss 7.0654251748254e-17
Cconserve1703 dvdd.n29 avss 6.2830064562358e-16
Cconserve1704 dvdd.n30 avss 1.130602441083e-15
Cconserve1705 dvdd.n31 avss 4.5867129965898e-16
Cconserve1706 dvdd.n32 avss 5.864511235427e-16
Cconserve1707 dvdd.n33 avss 8.347726252878e-17
Cconserve1708 dvdd.n34 avss 1.1933868051876e-16
Cconserve1709 dvdd.n35 avss 1.2487381242591e-15
Cconserve1710 dvdd.n36 avss 1.2347255574471e-15
Cconserve1711 dvdd.t20 avss 1.5103934066062e-15
Cconserve1712 dvdd.n37 avss 1.2291003687556e-15
Cconserve1713 dvdd.t23 avss 1.5092979397523e-15
Cconserve1714 dvdd.n38 avss 1.2009475426761e-15
Cconserve1715 dvdd.n39 avss 2.2110956744198e-16
Cconserve1716 dvdd.n40 avss 1.7703550837558e-15
Cconserve1717 dvss avss 3.17432e-14
Cconserve1718 net3.t0 avss 4.4354986851225e-15
Cconserve1719 net3 avss 1.0954701314877e-14
Cconserve1720 net4.t0 avss 1.3742282660576e-15
Cconserve1721 net4 avss 8.8169173394243e-16
Cconserve1722 pm1 avss 1.9598272705096e-15
Cconserve1723 pm1.t10 avss 1.0192026936876e-15
Cconserve1724 pm1.t11 avss 9.7655327707796e-16
Cconserve1725 pm1.n0 avss 2.7252004316542e-16
Cconserve1726 pm1.t1 avss 9.9067257665556e-16
Cconserve1727 pm1.t4 avss 8.3196919081891e-16
Cconserve1728 pm1.t5 avss 8.3061872547374e-16
Cconserve1729 pm1.t6 avss 8.6312648100618e-16
Cconserve1730 pm1.t8 avss 8.3464202340064e-16
Cconserve1731 pm1.t9 avss 8.4271671736305e-16
Cconserve1732 pm1.t7 avss 8.7281154781842e-16
Cconserve1733 pm1.n1 avss 6.1709768586663e-16
Cconserve1734 pm1.n2 avss 3.7594566870307e-16
Cconserve1735 pm1.n3 avss 1.2897031852965e-16
Cconserve1736 pm1.n4 avss 9.4690801636038e-16
Cconserve1737 pm1.n5 avss 1.1134261886548e-15
Cconserve1738 pm1.t2 avss 9.9378444218435e-16
Cconserve1739 pm1.n6 avss 4.1287185181477e-16
Cconserve1740 pm1.t3 avss 9.9852775414443e-16
Cconserve1741 pm1.n7 avss 3.7621962526204e-16
Cconserve1742 pm1.n8 avss 4.6131650332565e-16
Cconserve1743 pm1.t0 avss 9.4272139817718e-16
Cconserve1744 pm2 avss 3.6371913010263e-15
Cconserve1745 pm2.t1 avss 1.7074703198856e-15
Cconserve1746 pm2.t2 avss 1.8706043879783e-15
Cconserve1747 pm2.n0 avss 8.1518477695977e-16
Cconserve1748 pm2.t0 avss 1.7081757612029e-15
Cconserve1749 pm2.n1 avss 6.6794909630388e-16
Cconserve1750 pm2.t9 avss 1.7262546036205e-15
Cconserve1751 pm2.t3 avss 1.4260083958541e-15
Cconserve1752 pm2.t5 avss 1.4431985654434e-15
Cconserve1753 pm2.t4 avss 1.427941488295e-15
Cconserve1754 pm2.n2 avss 5.3736610613845e-16
Cconserve1755 pm2.n3 avss 6.2749768639435e-16
Cconserve1756 pm2.t6 avss 1.432198567067e-15
Cconserve1757 pm2.t7 avss 1.4299967350766e-15
Cconserve1758 pm2.t8 avss 1.5277324230386e-15
Cconserve1759 pm2.n4 avss 6.1475698866353e-16
Cconserve1760 pm2.n5 avss 4.443944374622e-16
Cconserve1761 pm2.n6 avss 2.037598533236e-15
Cconserve1762 pm2.n7 avss 1.7431027410561e-15
Cconserve1763 pm2.n8 avss 5.2622868412878e-16
Cconserve1764 pm2.t10 avss 1.7055769276053e-15
Cconserve1765 pm2.n9 avss 4.7780364963268e-16
Cconserve1766 pm2.t11 avss 1.6894678239308e-15
Cconserve1767 psrg_m3_protected avss 2.2749632418512e-15
Cconserve1768 psrg_m3_protected.t2 avss 1.3343271133161e-15
Cconserve1769 psrg_m3_protected.t3 avss 1.3169462563329e-15
Cconserve1770 psrg_m3_protected.n0 avss 4.9406567948989e-16
Cconserve1771 psrg_m3_protected.t0 avss 5.3095619636542e-16
Cconserve1772 psrg_m3_protected.n1 avss 5.6843622789272e-16
Cconserve1773 psrg_m3_protected.t1 avss 3.6552528475174e-16
Cconserve1774 psrg_mf1_protected avss 1.8849745711446e-15
Cconserve1775 psrg_mf1_protected.t1 avss 2.9884292292364e-15
Cconserve1776 psrg_mf1_protected.t0 avss 1.464876199619e-15
Cconserve1777 rbit0top avss 6.5319325343515e-15
Cconserve1778 rbit0top.t3 avss 1.1126903070215e-15
Cconserve1779 rbit0top.t8 avss 1.1382015285181e-15
Cconserve1780 rbit0top.t9 avss 1.1334232553545e-15
Cconserve1781 rbit0top.n0 avss 1.4434329212289e-15
Cconserve1782 rbit0top.t4 avss 1.1141867164496e-15
Cconserve1783 rbit0top.t6 avss 1.113316570927e-15
Cconserve1784 rbit0top.t7 avss 1.1078668705955e-15
Cconserve1785 rbit0top.t0 avss 9.0892571053822e-16
Cconserve1786 rbit0top.t1 avss 3.1067206038977e-16
Cconserve1787 rbit0top.n1 avss 2.284475237472e-15
Cconserve1788 rbit0top.n2 avss 7.9241352615801e-16
Cconserve1789 rbit0top.t2 avss 1.1158547462748e-15
Cconserve1790 rbit0top.n3 avss 1.3015751139809e-16
Cconserve1791 rbit0top.n4 avss 9.3484942316487e-17
Cconserve1792 rbit0top.n5 avss 8.0255117312827e-17
Cconserve1793 rbit0top.n6 avss 2.343307913979e-15
Cconserve1794 rbit0top.n7 avss 8.5650621729431e-17
Cconserve1795 rbit0top.t5 avss 1.0976419079846e-15
Cconserve1796 rbit1top avss 1.5999190096056e-15
Cconserve1797 rbit1top.t1 avss 7.2512086095596e-16
Cconserve1798 rbit1top.t7 avss 7.4573735002963e-16
Cconserve1799 rbit1top.t8 avss 7.4803160922119e-16
Cconserve1800 rbit1top.n0 avss 2.9889814973188e-16
Cconserve1801 rbit1top.t2 avss 7.3629798223884e-16
Cconserve1802 rbit1top.t3 avss 7.3565807650266e-16
Cconserve1803 rbit1top.t4 avss 7.3583397476189e-16
Cconserve1804 rbit1top.t5 avss 7.3634195680365e-16
Cconserve1805 rbit1top.t10 avss 7.4875643135837e-16
Cconserve1806 rbit1top.t0 avss 1.3241044736696e-16
Cconserve1807 rbit1top.t9 avss 1.727214760176e-16
Cconserve1808 rbit1top.n1 avss 7.3395823211817e-16
Cconserve1809 rbit1top.n2 avss 7.456069426995e-16
Cconserve1810 rbit1top.t11 avss 7.4126255896929e-16
Cconserve1811 rbit1top.n3 avss 7.4398898198741e-17
Cconserve1812 rbit1top.t13 avss 7.4043614042375e-16
Cconserve1813 rbit1top.n4 avss 6.8494175599974e-17
Cconserve1814 rbit1top.t12 avss 7.4133837718447e-16
Cconserve1815 rbit1top.n5 avss 6.377828261534e-17
Cconserve1816 rbit1top.t6 avss 7.3533963999887e-16
Cconserve1817 rbit1top.n6 avss 5.8660553090215e-17
Cconserve1818 rbit1top.n7 avss 6.1200463298981e-17
Cconserve1819 rbit1top.n8 avss 5.6962225070025e-17
Cconserve1820 rbit1top.n9 avss 5.8372443872504e-17
Cconserve1821 rbit1top.n10 avss 6.0449862968629e-17
Cconserve1822 rbit1top.n11 avss 2.5453387929733e-16
Cconserve1823 rbit2top avss 2.3393054443877e-15
Cconserve1824 rbit2top.t7 avss 9.7981503815938e-16
Cconserve1825 rbit2top.t6 avss 9.9900312125516e-16
Cconserve1826 rbit2top.t1 avss 1.7610794256817e-16
Cconserve1827 rbit2top.t5 avss 3.6990943456325e-16
Cconserve1828 rbit2top.n0 avss 1.1570593203766e-15
Cconserve1829 rbit2top.n1 avss 7.7428989706758e-16
Cconserve1830 rbit2top.t9 avss 9.96627512641e-16
Cconserve1831 rbit2top.n2 avss 1.0720088265345e-16
Cconserve1832 rbit2top.t8 avss 9.9388547566175e-16
Cconserve1833 rbit2top.n3 avss 8.4082958271343e-17
Cconserve1834 rbit2top.t2 avss 5.1863612047902e-16
Cconserve1835 rbit2top.t4 avss 5.1596407543468e-16
Cconserve1836 rbit2top.t3 avss 5.2044355926865e-16
Cconserve1837 rbit2top.n4 avss 1.3145720527094e-16
Cconserve1838 rbit2top.n5 avss 3.5585752433776e-16
Cconserve1839 rbit2top.t0 avss 5.2843910853847e-16
Cconserve1840 rbit2top.n6 avss 6.6511894730517e-16
Cconserve1841 rbit2top.n7 avss 3.9341643175998e-16
Cconserve1842 rbit3top avss 9.5943472812375e-15
Cconserve1843 rbit3top.t1 avss 8.7721459773404e-16
Cconserve1844 rbit3top.t0 avss 6.2561984529854e-16
Cconserve1845 rbit3top.t6 avss 1.9314657322063e-16
Cconserve1846 rbit3top.t2 avss 8.5119428084639e-16
Cconserve1847 rbit3top.n0 avss 8.0381830622631e-15
Cconserve1848 rbit3top.t7 avss 4.3284220421109e-16
Cconserve1849 rbit3top.t3 avss 6.0739374979933e-16
Cconserve1850 rbit3top.n1 avss 3.1786683723345e-16
Cconserve1851 rbit3top.t4 avss 6.122237923246e-16
Cconserve1852 rbit3top.n2 avss 8.2683203825846e-17
Cconserve1853 rbit3top.n3 avss 7.8110565673963e-16
Cconserve1854 rbit3top.t5 avss 6.099593123347e-16
Cconserve1855 rbit3top.n4 avss 2.8601993700101e-16
Cconserve1856 rbit3top.n5 avss 7.3587966593018e-16
Cconserve1857 rbit4top avss 6.3321341547816e-15
Cconserve1858 rbit4top.t0 avss 7.7771108889152e-16
Cconserve1859 rbit4top.t5 avss 6.4270155212638e-16
Cconserve1860 rbit4top.t1 avss 3.2833787522158e-16
Cconserve1861 rbit4top.n0 avss 1.3204827118703e-15
Cconserve1862 rbit4top.n1 avss 1.3132166865978e-15
Cconserve1863 rbit4top.t4 avss 9.918891543775e-16
Cconserve1864 rbit4top.t3 avss 3.2706411263382e-16
Cconserve1865 rbit4top.n2 avss 2.1826572768822e-15
Cconserve1866 rbit4top.n3 avss 1.604480632486e-15
Cconserve1867 rbit4top.t2 avss 1.4352747541313e-15
Cconserve1868 rbit5top avss 1.2998033517514e-14
Cconserve1869 rbit5top.t2 avss 4.3159366315706e-16
Cconserve1870 rbit5top.t3 avss 3.6951310462351e-16
Cconserve1871 rbit5top.n0 avss 3.5985679692328e-16
Cconserve1872 rbit5top.t5 avss 1.5186437841754e-15
Cconserve1873 rbit5top.t4 avss 3.3895684327073e-16
Cconserve1874 rbit5top.n1 avss 3.0433182511798e-15
Cconserve1875 rbit5top.n2 avss 2.6677444005028e-15
Cconserve1876 rbit5top.t0 avss 5.3222730075279e-16
Cconserve1877 rbit5top.t1 avss 8.5796233790098e-16
Cconserve1878 rbit6top avss 1.016860708401e-14
Cconserve1879 rbit6top.n0 avss 1.5481466518464e-15
Cconserve1880 rbit6top.n1 avss 6.1931990760506e-16
Cconserve1881 rbit6top.t1 avss 1.9256735378651e-16
Cconserve1882 rbit6top.t0 avss 9.9703293606114e-16
Cconserve1883 rbit6top.t3 avss 7.9569887393262e-16
Cconserve1884 rbit6top.n2 avss 2.5287450120636e-15
Cconserve1885 rbit6top.t5 avss 7.7963658296352e-17
Cconserve1886 rbit6top.t4 avss 2.1764254148256e-16
Cconserve1887 rbit6top.n3 avss 1.2086228460309e-15
Cconserve1888 rbit6top.t2 avss 3.8569313488521e-16
Cconserve1889 rfix0 avss 9.6286e-15
Cconserve1890 rfix1 avss 1.11355e-14
Cconserve1891 rfix2 avss 1.1172e-14
Cconserve1892 su_state avss 1.1050210259795e-14
Cconserve1893 su_state.t0 avss 2.0704057171725e-15
Cconserve1894 su_state.t1 avss 4.6936749138827e-15
Cconserve1895 su_state.n0 avss 9.0601458529251e-15
Cconserve1896 su_state.t2 avss 1.4344325622489e-16
Cconserve1897 v1.n0 avss 5.3946086613653e-16
Cconserve1898 v1.n1 avss 2.316786039032e-15
Cconserve1899 v1.t1 avss 6.7869865077112e-16
Cconserve1900 v1.t0 avss 6.8580242875507e-16
Cconserve1901 v1.n2 avss 5.6734102945534e-16
Cconserve1902 v1.n3 avss 1.3506348717234e-16
Cconserve1903 v1.n4 avss 3.1283285647772e-16
Cconserve1904 v1.n5 avss 6.017136009101e-16
Cconserve1905 v1.n6 avss 3.4188311375564e-16
Cconserve1906 v1.n7 avss 1.0924499884099e-16
Cconserve1907 v1.n8 avss 1.3484169577748e-15
Cconserve1908 v1.n9 avss 4.0619242876793e-16
Cconserve1909 v1.n10 avss 1.9307569275013e-16
Cconserve1910 v1 avss 6.2914678494003e-15
Cconserve1911 vaux avss 1.5054768259035e-15
Cconserve1912 vaux.t2 avss 1.344816498643e-15
Cconserve1913 vaux.t0 avss 5.1400223179089e-16
Cconserve1914 vaux.n0 avss 1.8167873155225e-15
Cconserve1915 vaux.t1 avss 5.0525712814012e-16
Cconserve1916 vq2.t0 avss 3.9780700275876e-16
Cconserve1917 vq2 avss 6.3004129972412e-15
Cconserve1918 vq3.t1 avss 1.5270757846914e-16
Cconserve1919 vq3.n0 avss 4.6828764231608e-16
Cconserve1920 vq3.n1 avss 1.313846714449e-14
Cconserve1921 vq3.t0 avss 2.2963330619985e-16
Cconserve1922 vq3.n2 avss 2.8052153389383e-14
Cconserve1923 vq3 avss 9.0658750939142e-14
Cconserve1924 vsp avss 2.2465401820747e-15
Cconserve1925 vsp.t8 avss 2.7044951873366e-15
Cconserve1926 vsp.t14 avss 2.7319212143337e-15
Cconserve1927 vsp.t9 avss 2.7043419693087e-15
Cconserve1928 vsp.t10 avss 2.7025170331548e-15
Cconserve1929 vsp.t1 avss 2.749037856881e-15
Cconserve1930 vsp.t2 avss 2.750876473216e-15
Cconserve1931 vsp.t11 avss 2.7025170331548e-15
Cconserve1932 vsp.t4 avss 1.9146398372089e-15
Cconserve1933 vsp.t13 avss 2.017205626718e-15
Cconserve1934 vsp.t5 avss 1.982143322651e-15
Cconserve1935 vsp.n0 avss 3.6565755965936e-16
Cconserve1936 vsp.t6 avss 1.9852022111369e-15
Cconserve1937 vsp.n1 avss 2.4550726541056e-16
Cconserve1938 vsp.t15 avss 1.9854375102512e-15
Cconserve1939 vsp.n2 avss 2.4555104198996e-16
Cconserve1940 vsp.t3 avss 1.9821788911218e-15
Cconserve1941 vsp.n3 avss 2.4853879353434e-16
Cconserve1942 vsp.n4 avss 1.4061146746259e-15
Cconserve1943 vsp.t0 avss 2.749037856881e-15
Cconserve1944 vsp.n5 avss 1.3709648174001e-15
Cconserve1945 vsp.t12 avss 2.7104624823167e-15
Cconserve1946 vsp.n6 avss 2.1525491300565e-16
Cconserve1947 vsp.n7 avss 2.1396623994942e-16
Cconserve1948 vsp.n8 avss 2.1525491300565e-16
Cconserve1949 vsp.n9 avss 8.7225108067614e-16
Cconserve1950 vsp.n10 avss 8.5843409780151e-16
Cconserve1951 vsp.n11 avss 2.1525491300565e-16
Cconserve1952 vsp.n12 avss 2.1396623994942e-16
Cconserve1953 vsp.n13 avss 3.0675343603403e-16
Cconserve1954 vsp.t7 avss 2.7065253262065e-15
Cconserve1955 vsu1 avss 6.17161e-15
Cconserve1956 vsu2 avss 1.050051e-14
Cconserve1957 vx1 avss 1.0933745106412e-15
Cconserve1958 vx1.t7 avss 5.0598040612639e-16
Cconserve1959 vx1.t6 avss 8.0577259524843e-16
Cconserve1960 vx1.n0 avss 7.5757259857838e-16
Cconserve1961 vx1.t8 avss 5.0580284339e-16
Cconserve1962 vx1.n1 avss 4.2930644904813e-16
Cconserve1963 vx1.t9 avss 5.1297164293403e-16
Cconserve1964 vx1.n2 avss 6.1816217547724e-16
Cconserve1965 vx1.t1 avss 8.9790871541192e-16
Cconserve1966 vx1.t0 avss 8.970185342268e-16
Cconserve1967 vx1.n3 avss 2.8007325536965e-16
Cconserve1968 vx1.t3 avss 9.6189285559586e-16
Cconserve1969 vx1.t2 avss 9.5630554815732e-16
Cconserve1970 vx1.n4 avss 5.6129474976798e-16
Cconserve1971 vx1.n5 avss 5.1735389126824e-16
Cconserve1972 vx1.t5 avss 9.2370266225215e-16
Cconserve1973 vx1.t4 avss 9.2187494981886e-16
Cconserve1974 vx1.n6 avss 3.6789578479033e-16
Cconserve1975 vx1.n7 avss 1.5677463821862e-15
Cconserve1976 vx1.n8 avss 1.4522501084227e-15
Cconserve1977 vx1.t10 avss 4.9107934128817e-16
Cconserve1978 vx2 avss 9.4930994869846e-16
Cconserve1979 vx2.t8 avss 2.2361395798954e-16
Cconserve1980 vx2.t7 avss 2.5945919883439e-16
Cconserve1981 vx2.t6 avss 3.4519604647652e-16
Cconserve1982 vx2.n0 avss 4.6140872537996e-16
Cconserve1983 vx2.n1 avss 2.7196719860211e-16
Cconserve1984 vx2.t9 avss 2.2353305396745e-16
Cconserve1985 vx2.n2 avss 2.635484212449e-16
Cconserve1986 vx2.t1 avss 4.3716964240956e-16
Cconserve1987 vx2.t0 avss 4.3379903807759e-16
Cconserve1988 vx2.n3 avss 2.2600895499633e-16
Cconserve1989 vx2.t3 avss 4.2486390269705e-16
Cconserve1990 vx2.t2 avss 4.1844987941656e-16
Cconserve1991 vx2.n4 avss 7.4787440064615e-17
Cconserve1992 vx2.n5 avss 2.3503332275417e-16
Cconserve1993 vx2.t5 avss 4.4194535924278e-16
Cconserve1994 vx2.t4 avss 4.3757892158012e-16
Cconserve1995 vx2.n6 avss 2.3863593126712e-16
Cconserve1996 vx2.n7 avss 6.0409962504157e-16
Cconserve1997 vx2.n8 avss 6.9955566321946e-16
Cconserve1998 vx2.t10 avss 2.1819576803974e-16
Cconserve1999 vx3 avss 4.4301284654744e-15
Cconserve2000 vx3.t3 avss 1.2371716478784e-15
Cconserve2001 vx3.t2 avss 1.2436021147735e-15
Cconserve2002 vx3.n0 avss 8.7243646630572e-16
Cconserve2003 vx3.t9 avss 1.193622042663e-15
Cconserve2004 vx3.t0 avss 1.1983636675772e-15
Cconserve2005 vx3.n1 avss 4.5220754566009e-16
Cconserve2006 vx3.n2 avss 6.5422843184183e-16
Cconserve2007 vx3.t1 avss 1.1931942026945e-15
Cconserve2008 vx3.t10 avss 1.1830868855438e-15
Cconserve2009 vx3.n3 avss 2.3228171763844e-16
Cconserve2010 vx3.n4 avss 1.4567629243457e-15
Cconserve2011 vx3.t4 avss 1.2662036457413e-15
Cconserve2012 vx3.t5 avss 5.5640845251611e-15
Cconserve2013 vx3.n5 avss 8.4957437114651e-16
Cconserve2014 vx3.t6 avss 6.4396348943955e-16
Cconserve2015 vx3.n6 avss 5.491277743152e-16
Cconserve2016 vx3.t7 avss 6.530896698204e-16
Cconserve2017 vx3.n7 avss 9.8524467694921e-16
Cconserve2018 vx3.t8 avss 6.2521573503011e-16
Cconserve2019 xf1 avss 2.1231700223683e-14
Cconserve2020 xf1.t10 avss 6.6829743790061e-15
Cconserve2021 xf1.t0 avss 6.6652344195718e-15
Cconserve2022 xf1.t2 avss 2.8686902749889e-15
Cconserve2023 xf1.t1 avss 2.9282656865847e-15
Cconserve2024 xf1.n0 avss 1.1702819848022e-15
Cconserve2025 xf1.t3 avss 3.1737327339744e-15
Cconserve2026 xf1.t4 avss 2.8677492858363e-15
Cconserve2027 xf1.n1 avss 1.6558323875444e-15
Cconserve2028 xf1.t5 avss 2.8701326108212e-15
Cconserve2029 xf1.n2 avss 1.2285230429276e-15
Cconserve2030 xf1.n3 avss 1.0572090259733e-15
Cconserve2031 xf1.t11 avss 2.726801451618e-15
Cconserve2032 xf1.n4 avss 3.4984665479318e-15
Cconserve2033 xf1.n5 avss 9.1380844953751e-15
Cconserve2034 xf1.t9 avss 6.6613470545479e-15
Cconserve2035 xf1.n6 avss 3.873566420631e-15
Cconserve2036 xf1.t8 avss 6.702187526376e-15
Cconserve2037 xf1.n7 avss 2.2471515136442e-15
Cconserve2038 xf1.n8 avss 2.5967366968613e-15
Cconserve2039 xf1.t7 avss 6.706553099002e-15
Cconserve2040 xf1.n9 avss 1.1742619061362e-15
Cconserve2041 xf1.t6 avss 6.6445172321629e-15
Cconserve2042 xf2 avss 1.4702453775777e-14
Cconserve2043 xf2.t9 avss 3.9520911243233e-15
Cconserve2044 xf2.t2 avss 4.0145747058671e-15
Cconserve2045 xf2.t0 avss 4.2559685072279e-15
Cconserve2046 xf2.t3 avss 1.9257414118381e-15
Cconserve2047 xf2.t11 avss 1.6928789519314e-15
Cconserve2048 xf2.t5 avss 1.6916988901694e-15
Cconserve2049 xf2.t4 avss 1.7264257660671e-15
Cconserve2050 xf2.n0 avss 6.8191958129247e-16
Cconserve2051 xf2.t7 avss 1.8385591835333e-15
Cconserve2052 xf2.n1 avss 1.0074329603931e-15
Cconserve2053 xf2.t10 avss 1.6810002757517e-15
Cconserve2054 xf2.n2 avss 2.7243355821243e-16
Cconserve2055 xf2.n3 avss 6.2779744904259e-16
Cconserve2056 xf2.n4 avss 2.4504740114295e-15
Cconserve2057 xf2.n5 avss 5.4444927354417e-15
Cconserve2058 xf2.t1 avss 4.0033801900085e-15
Cconserve2059 xf2.n6 avss 2.3812865770746e-15
Cconserve2060 xf2.t6 avss 4.0054510376919e-15
Cconserve2061 xf2.n7 avss 4.3248574823824e-16
Cconserve2062 xf2.n8 avss 1.1521213891133e-15
Cconserve2063 xf2.n9 avss 1.8144436801333e-15
Cconserve2064 xf2.t8 avss 3.9515584894424e-15
Cconserve2065 b0 b0_b 1.57273e-15
Cconserve2066 b0 b1 2.8169e-16
Cconserve2067 b0 b1_b 1.1519e-16
Cconserve2068 b0 b2 2.3544e-16
Cconserve2069 b0 b2_b 6.6587e-16
Cconserve2070 b3 b0 1.1624e-16
Cconserve2071 b0 dvdd 2.26731e-15
Cconserve2072 dvss b0 1.53675e-15
Cconserve2073 b0 rbit0top 1.35816e-15
Cconserve2074 b0 rbit1top 9.5698e-16
Cconserve2075 b0 rbit2top 5.3646e-16
Cconserve2076 b0 rbit3top 2.6929e-16
Cconserve2077 b0 rbit4top 2.7314e-16
Cconserve2078 b0 rbit5top 6.5409e-16
Cconserve2079 b0 rbit6top 3.7638e-16
Cconserve2080 b2 b0_b 4.976e-16
Cconserve2081 b2_b b0_b 3.6378e-16
Cconserve2082 b3 b0_b 4.5596e-16
Cconserve2083 b4 b0_b 2.1404e-16
Cconserve2084 b5 b0_b 1.8986e-16
Cconserve2085 b6 b0_b 2.31e-16
Cconserve2086 dvdd b0_b 4.15922e-15
Cconserve2087 dvss b0_b 6.8818e-16
Cconserve2088 rbit0top b0_b 2.41895e-15
Cconserve2089 rbit1top b0_b 2.10517e-15
Cconserve2090 rbit2top b0_b 1.2093e-16
Cconserve2091 rbit4top b0_b 1.0611e-16
Cconserve2092 rbit5top b0_b 1.2174e-16
Cconserve2093 rbit6top b0_b 4.5445e-16
Cconserve2094 vref b0_b 4.6432e-16
Cconserve2095 b1 b1_b 2.00112e-15
Cconserve2096 b2 b1 6.1748e-16
Cconserve2097 b1 b2_b 1.6487e-16
Cconserve2098 b3 b1 1.4443e-16
Cconserve2099 b1 b3_b 1.9763e-16
Cconserve2100 b1 b4_b 2.1295e-16
Cconserve2101 b1 dvdd 1.9632e-15
Cconserve2102 dvss b1 1.39119e-15
Cconserve2103 b1 rbit0top 3.8571e-16
Cconserve2104 b1 rbit1top 8.303e-16
Cconserve2105 b1 rbit2top 9.9261e-16
Cconserve2106 vq3 b1 6.1141e-16
Cconserve2107 b1 vref 5.1763e-16
Cconserve2108 b4_b b1_b 1.3055e-16
Cconserve2109 b5_b b1_b 2.4169e-16
Cconserve2110 b6 b1_b 1.8908e-16
Cconserve2111 dvdd b1_b 1.71207e-15
Cconserve2112 dvss b1_b 4.0119e-16
Cconserve2113 rbit1top b1_b 1.0224e-15
Cconserve2114 rbit2top b1_b 1.0123e-15
Cconserve2115 rbit5top b1_b 1.5391e-16
Cconserve2116 rbit6top b1_b 6.1487e-16
Cconserve2117 vq3 b1_b 4.6662e-16
Cconserve2118 vref b1_b 4.6737e-16
Cconserve2119 b2 b2_b 6.365e-16
Cconserve2120 b3 b2 5.2826e-16
Cconserve2121 b4 b2 1.2242e-16
Cconserve2122 b5 b2 9.131e-16
Cconserve2123 b2 dvdd 2.80824e-15
Cconserve2124 dvss b2 1.02449e-15
Cconserve2125 b2 rbit0top 2.9231e-16
Cconserve2126 b2 rbit1top 5.9167e-16
Cconserve2127 b2 rbit2top 2.7743e-16
Cconserve2128 b2 rbit3top 2.8452e-16
Cconserve2129 b2 rbit4top 1.1838e-16
Cconserve2130 b2 rbit5top 1.5945e-16
Cconserve2131 b2 rbit6top 3.2719e-16
Cconserve2132 vq3 b2 5.3362e-16
Cconserve2133 b2 vref 2.7624e-16
Cconserve2134 b3 b2_b 8.6019e-16
Cconserve2135 b2_b b3_b 1.8346e-16
Cconserve2136 dvdd b2_b 2.9187e-15
Cconserve2137 dvss b2_b 1.29017e-15
Cconserve2138 b2_b rbit2top 6.2978e-16
Cconserve2139 rbit3top b2_b 1.34317e-15
Cconserve2140 rbit4top b2_b 1.7164e-16
Cconserve2141 rbit5top b2_b 2.5686e-16
Cconserve2142 rbit6top b2_b 2.5905e-16
Cconserve2143 vq3 b2_b 1.6987e-16
Cconserve2144 b3 b4 2.21325e-15
Cconserve2145 b3 b4_b 1.346e-16
Cconserve2146 b3 b5 5.4286e-16
Cconserve2147 b3 b5_b 1.781e-16
Cconserve2148 b3 b6 9.0951e-16
Cconserve2149 b3 b6_b 1.2306e-16
Cconserve2150 b3 dvdd 2.20454e-15
Cconserve2151 dvss b3 1.93871e-15
Cconserve2152 b3 rbit0top 5.3074e-16
Cconserve2153 b3 rbit1top 3.8125e-16
Cconserve2154 b3 rbit3top 3.6575e-16
Cconserve2155 b3 rbit4top 2.00367e-15
Cconserve2156 b3 rbit5top 3.1365e-16
Cconserve2157 b3 rbit6top 2.7467e-16
Cconserve2158 vq3 b3 7.3433e-16
Cconserve2159 b3 vref 1.6929e-16
Cconserve2160 b4 b3_b 3.7929e-16
Cconserve2161 b4_b b3_b 1.2044e-16
Cconserve2162 b5 b3_b 1.4928e-16
Cconserve2163 b5_b b3_b 1.0598e-16
Cconserve2164 b6 b3_b 2.8826e-16
Cconserve2165 b6_b b3_b 1.0274e-16
Cconserve2166 dvdd b3_b 9.8607e-16
Cconserve2167 dvss b3_b 4.4394e-16
Cconserve2168 rbit3top b3_b 5.0673e-16
Cconserve2169 rbit4top b3_b 2.8591e-16
Cconserve2170 rbit6top b3_b 2.6035e-16
Cconserve2171 vq3 b3_b 5.1249e-16
Cconserve2172 b4 b4_b 4.4717e-16
Cconserve2173 b4 b5 4.2193e-16
Cconserve2174 b4 b5_b 2.31201e-15
Cconserve2175 b4 b6 1.2575e-16
Cconserve2176 b4 b6_b 2.1254e-16
Cconserve2177 b4 dvdd 2.36989e-15
Cconserve2178 dvss b4 1.24793e-15
Cconserve2179 b4 rbit0top 3.3932e-16
Cconserve2180 b4 rbit1top 3.0293e-16
Cconserve2181 b4 rbit2top 1.416e-16
Cconserve2182 b4 rbit4top 1.5644e-16
Cconserve2183 b4 rbit5top 3.3512e-16
Cconserve2184 vq3 b4 1.2386e-16
Cconserve2185 b4 vref 3.2122e-16
Cconserve2186 b5 b4_b 5.1793e-16
Cconserve2187 b5_b b4_b 1.403e-16
Cconserve2188 b6 b4_b 1.8235e-16
Cconserve2189 b4_b b6_b 3.9921e-16
Cconserve2190 dvdd b4_b 2.04749e-15
Cconserve2191 dvss b4_b 1.03304e-15
Cconserve2192 rbit3top b4_b 1.6324e-16
Cconserve2193 rbit4top b4_b 5.2889e-16
Cconserve2194 rbit5top b4_b 6.4681e-16
Cconserve2195 b5 b5_b 7.1797e-16
Cconserve2196 b5 b6 7.4946e-16
Cconserve2197 b5 dvdd 1.97426e-15
Cconserve2198 dvss b5 1.66902e-15
Cconserve2199 b5 rbit0top 3.2229e-16
Cconserve2200 b5 rbit1top 2.6006e-16
Cconserve2201 b5 rbit3top 1.1617e-16
Cconserve2202 b5 rbit5top 1.8324e-16
Cconserve2203 b5 rbit6top 2.3277e-16
Cconserve2204 vq3 b5 2.3596e-16
Cconserve2205 b5 vref 2.878e-16
Cconserve2206 b6 b5_b 1.2061e-16
Cconserve2207 b5_b b6_b 1.2883e-16
Cconserve2208 dvdd b5_b 8.0288e-16
Cconserve2209 dvss b5_b 1.3604e-15
Cconserve2210 rbit3top b5_b 1.0112e-16
Cconserve2211 b5_b rbit5top 3.2349e-16
Cconserve2212 b5_b rbit6top 1.7822e-16
Cconserve2213 vq3 b5_b 2.0329e-16
Cconserve2214 b6 b6_b 4.6004e-16
Cconserve2215 b6 dvdd 2.30319e-15
Cconserve2216 dvss b6 1.48043e-15
Cconserve2217 b6 rbit0top 3.7201e-16
Cconserve2218 b6 rbit1top 3.938e-16
Cconserve2219 b6 rbit3top 2.2366e-16
Cconserve2220 b6 rbit4top 3.5582e-16
Cconserve2221 b6 rbit5top 1.69e-16
Cconserve2222 b6 rbit6top 2.1217e-16
Cconserve2223 vq3 b6 5.2063e-16
Cconserve2224 dvdd b6_b 8.9872e-16
Cconserve2225 dvss b6_b 1.414e-15
Cconserve2226 rbit3top b6_b 1.0124e-16
Cconserve2227 rbit6top b6_b 1.3315e-16
Cconserve2228 vq3 b6_b 4.4449e-16
Cconserve2229 bgsu2 bgsu1 3.0326e-16
Cconserve2230 bgsu1 psrg_m3_feed 1.22716e-14
Cconserve2231 psrg_vnc bgsu1 1.55387e-15
Cconserve2232 rb_mid bgsu1 1.0425e-16
Cconserve2233 bgsu1 vbn 8.43135e-15
Cconserve2234 vbn_i bgsu1 5.84265e-15
Cconserve2235 vcasp bgsu1 7.2817e-16
Cconserve2236 bgsu1 vnx_bias 7.65514e-15
Cconserve2237 vsu bgsu1 2.4904e-16
Cconserve2238 vsu2 bgsu1 3.0458e-16
Cconserve2239 vsu2 bgsu2 2.7649e-16
Cconserve2240 dvss dvdd 5.20602e-15
Cconserve2241 dvdd rbit0top 1.83773e-14
Cconserve2242 dvdd rbit1top 2.53067e-14
Cconserve2243 dvdd rbit2top 1.49452e-14
Cconserve2244 dvdd rbit3top 9.08135e-15
Cconserve2245 dvdd rbit4top 5.37254e-15
Cconserve2246 dvdd rbit5top 3.45499e-15
Cconserve2247 dvdd rbit6top 3.48836e-15
Cconserve2248 vq3 dvdd 2.5307e-15
Cconserve2249 vref dvdd 4.32753e-15
Cconserve2250 dvss rbit0top 5.07312e-15
Cconserve2251 dvss rbit1top 6.97969e-15
Cconserve2252 dvss rbit2top 3.44727e-15
Cconserve2253 dvss rbit3top 2.46367e-15
Cconserve2254 dvss rbit4top 2.4366e-15
Cconserve2255 dvss rbit5top 1.32184e-15
Cconserve2256 dvss rbit6top 9.5852e-16
Cconserve2257 vq3 dvss 8.8599e-16
Cconserve2258 dvss vref 1.7802e-16
Cconserve2259 iref_gate pm2 6.2637e-16
Cconserve2260 su_state iref_gate 8.37129e-15
Cconserve2261 v1 iref_gate 1.6482e-16
Cconserve2262 iref_gate v2 4.5614e-16
Cconserve2263 iref_gate vbn_fold 1.99656e-15
Cconserve2264 iref_gate vbn_i 4.8017e-16
Cconserve2265 vbn_sink iref_gate 5.317e-16
Cconserve2266 iref_gate vbp_cas 7.8455e-16
Cconserve2267 iref_gate vbp_i 3.93968e-15
Cconserve2268 vbp_tail iref_gate 8.785e-16
Cconserve2269 iref_gate vgn2 1.3452e-16
Cconserve2270 vref iref_gate 1.0308e-16
Cconserve2271 iref_gate vsp 1.0696e-16
Cconserve2272 net3 su_state 7.12065e-15
Cconserve2273 v1 net3 6.7149e-16
Cconserve2274 net3 v2 2.7754e-16
Cconserve2275 net3 vbn_fold 2.3177e-16
Cconserve2276 net3 vbn_i 4.5093e-16
Cconserve2277 net3 vbp_bias 2.1979e-16
Cconserve2278 net3 vbp_i 3.4493e-16
Cconserve2279 net3 vbp_tail 8.97717e-15
Cconserve2280 vq3 net3 6.4547e-16
Cconserve2281 net3 vref 1.3987e-16
Cconserve2282 net4 v2 5.2157e-16
Cconserve2283 net4 vbn_i 4.4444e-16
Cconserve2284 net4 vsu2 2.6004e-16
Cconserve2285 pm2 pm1 4.31442e-15
Cconserve2286 su_state pm1 4.197e-16
Cconserve2287 pm1 vbp_cas 9.1631e-15
Cconserve2288 pm1 vgn2 1.18525e-15
Cconserve2289 pm1 xf1 2.5666e-16
Cconserve2290 pm1 y1 1.08089e-14
Cconserve2291 su_state pm2 3.2515e-16
Cconserve2292 pm2 vbn_i 3.2466e-16
Cconserve2293 pm2 vbp_cas 9.40883e-15
Cconserve2294 pm2 vgn2 1.53172e-15
Cconserve2295 pm2 xf1 3.6394e-16
Cconserve2296 pm2 xf2 1.6092e-16
Cconserve2297 pm2 y1 9.01765e-15
Cconserve2298 psrg_m3_protected psrg_m3_feed 6.8933e-16
Cconserve2299 psrg_mf1_protected psrg_m3_feed 1.1778e-16
Cconserve2300 psrg_vnc psrg_m3_feed 8.85958e-15
Cconserve2301 v1 psrg_m3_feed 2.4565e-16
Cconserve2302 psrg_m3_feed v2 3.215e-16
Cconserve2303 psrg_m3_feed vaux 1.262e-15
Cconserve2304 vbn psrg_m3_feed 1.5731e-16
Cconserve2305 vbn_i psrg_m3_feed 1.96377e-15
Cconserve2306 vbp_cas psrg_m3_feed 5.05719e-15
Cconserve2307 vbp_i psrg_m3_feed 1.8956e-16
Cconserve2308 vcasp psrg_m3_feed 8.93628e-15
Cconserve2309 vgn1 psrg_m3_feed 1.093e-14
Cconserve2310 psrg_m3_feed vgn2 3.5919e-16
Cconserve2311 psrg_m3_feed vnx_bias 5.0386e-16
Cconserve2312 vref psrg_m3_feed 2.17415e-15
Cconserve2313 vsu psrg_m3_feed 1.4154e-16
Cconserve2314 vx1 psrg_m3_feed 5.51197e-15
Cconserve2315 vx2 psrg_m3_feed 5.74429e-15
Cconserve2316 psrg_m3_feed vx3 4.77775e-15
Cconserve2317 psrg_vnc psrg_m3_protected 1.61441e-15
Cconserve2318 v1 psrg_m3_protected 8.3811e-16
Cconserve2319 psrg_m3_protected v2 2.23226e-15
Cconserve2320 vcasp psrg_m3_protected 1.6753e-16
Cconserve2321 psrg_m3_protected vgn1 4.6888e-16
Cconserve2322 psrg_m3_protected vgn2 1.6241e-15
Cconserve2323 psrg_mf1_protected psrg_vnc 8.6885e-16
Cconserve2324 psrg_mf1_protected vbn 1.4469e-16
Cconserve2325 psrg_mf1_protected vbn_fold 1.13136e-15
Cconserve2326 psrg_mf1_protected vbn_i 2.1759e-16
Cconserve2327 vcasp psrg_mf1_protected 1.7385e-16
Cconserve2328 psrg_mf1_protected vgn2 1.0811e-16
Cconserve2329 rb_mid psrg_vnc 2.6276e-16
Cconserve2330 v1 psrg_vnc 2.4643e-16
Cconserve2331 psrg_vnc v2 5.2915e-16
Cconserve2332 psrg_vnc vaux 3.13776e-15
Cconserve2333 psrg_vnc vbn 1.41477e-14
Cconserve2334 vbn_i psrg_vnc 1.64813e-15
Cconserve2335 vbp_i psrg_vnc 6.79147e-15
Cconserve2336 vcasp psrg_vnc 1.50148e-14
Cconserve2337 psrg_vnc vgn1 4.2514e-16
Cconserve2338 psrg_vnc vgn2 2.5864e-16
Cconserve2339 psrg_vnc vnx_bias 1.6714e-16
Cconserve2340 y1 psrg_vnc 7.2307e-16
Cconserve2341 v1 rb_mid 1.7038e-16
Cconserve2342 rb_mid v2 1.7611e-16
Cconserve2343 rb_mid vaux 2.4947e-16
Cconserve2344 rb_mid vbn 1.6643e-16
Cconserve2345 rb_mid vbn_i 1.83745e-15
Cconserve2346 rb_mid vbp_i 1.9072e-16
Cconserve2347 rb_mid vbp_tail 5.0471e-16
Cconserve2348 rb_mid vcasp 4.1312e-16
Cconserve2349 rb_mid vnx_bias 1.3229e-16
Cconserve2350 vsu1 rb_mid 1.5385e-16
Cconserve2351 rbit1top rbit0top 1.75675e-14
Cconserve2352 rbit2top rbit0top 1.75658e-15
Cconserve2353 rbit3top rbit0top 1.9869e-16
Cconserve2354 rbit5top rbit0top 1.9532e-16
Cconserve2355 rbit6top rbit0top 1.802e-16
Cconserve2356 rbit0top rfix0 2.0304e-16
Cconserve2357 rbit0top rfix1 2.3203e-16
Cconserve2358 rfix2 rbit0top 2.4932e-16
Cconserve2359 vq3 rbit0top 4.3158e-16
Cconserve2360 vref rbit0top 2.59934e-15
Cconserve2361 rbit2top rbit1top 9.8513e-15
Cconserve2362 rbit3top rbit1top 1.2122e-16
Cconserve2363 vq3 rbit1top 7.2171e-16
Cconserve2364 vref rbit1top 2.41219e-15
Cconserve2365 rbit3top rbit2top 5.74144e-15
Cconserve2366 rbit4top rbit2top 1.33249e-15
Cconserve2367 rbit5top rbit2top 1.3796e-16
Cconserve2368 rbit6top rbit2top 2.7768e-16
Cconserve2369 rbit2top rfix0 4.6931e-16
Cconserve2370 rbit2top rfix1 4.7013e-16
Cconserve2371 rfix2 rbit2top 4.7492e-16
Cconserve2372 rbit2top vbn_i 1.6636e-16
Cconserve2373 vq3 rbit2top 5.1949e-16
Cconserve2374 vref rbit2top 2.42774e-15
Cconserve2375 rbit4top rbit3top 4.12866e-15
Cconserve2376 rbit3top rbit5top 5.74397e-15
Cconserve2377 rbit3top rbit6top 7.3333e-16
Cconserve2378 vq3 rbit3top 1.10979e-15
Cconserve2379 vref rbit3top 1.028e-16
Cconserve2380 rbit4top rbit5top 2.58032e-15
Cconserve2381 rbit4top rbit6top 5.9917e-16
Cconserve2382 rbit4top rfix0 5.693e-16
Cconserve2383 vq3 rbit4top 2.5004e-16
Cconserve2384 vref rbit4top 2.2388e-16
Cconserve2385 rbit5top rbit6top 1.10162e-15
Cconserve2386 vq3 rbit5top 3.7529e-16
Cconserve2387 vref rbit5top 1.0632e-16
Cconserve2388 rbit6top rfix0 2.51098e-15
Cconserve2389 vq3 rbit6top 1.81815e-15
Cconserve2390 vref rbit6top 1.484e-16
Cconserve2391 rfix0 rfix1 1.2694e-16
Cconserve2392 vq3 rfix0 4.8937e-16
Cconserve2393 vref rfix0 4.8258e-16
Cconserve2394 rfix2 rfix1 1.2712e-16
Cconserve2395 vref rfix1 4.8168e-16
Cconserve2396 vq3 rfix2 1.9915e-16
Cconserve2397 rfix2 vref 4.8703e-16
Cconserve2398 su_state vbn 1.4402e-16
Cconserve2399 su_state vbn_fold 5.6831e-16
Cconserve2400 su_state vbn_i 3.1895e-16
Cconserve2401 vbn_sink su_state 1.5202e-16
Cconserve2402 vbp_bias su_state 5.5381e-16
Cconserve2403 su_state vbp_i 1.9028e-16
Cconserve2404 vbp_tail su_state 1.01021e-14
Cconserve2405 su_state vgn2 1.80237e-15
Cconserve2406 vq2 su_state 2.4593e-16
Cconserve2407 vq3 su_state 5.1611e-16
Cconserve2408 su_state vref 1.1169e-16
Cconserve2409 su_state vsp 3.2471e-16
Cconserve2410 su_state vsu 2.5313e-16
Cconserve2411 v1 v2 1.90708e-14
Cconserve2412 v1 vaux 1.38295e-15
Cconserve2413 v1 vbn_i 2.6492e-16
Cconserve2414 v1 vbp_bias 1.3071e-15
Cconserve2415 v1 vbp_cas 2.35797e-15
Cconserve2416 v1 vbp_i 1.3259e-16
Cconserve2417 v1 vbp_tail 3.9653e-16
Cconserve2418 v1 vcasp 2.09942e-15
Cconserve2419 v1 vgn1 2.17754e-15
Cconserve2420 v1 vgn2 2.6813e-16
Cconserve2421 v1 vnx_bias 1.3405e-16
Cconserve2422 v1 vq2 4.5838e-16
Cconserve2423 vq3 v1 5.1915e-16
Cconserve2424 v1 vsp 1.0877e-14
Cconserve2425 v1 vsu2 3.0365e-16
Cconserve2426 v1 xf1 1.08469e-14
Cconserve2427 v1 xf2 8.5722e-16
Cconserve2428 vaux v2 4.7588e-16
Cconserve2429 vbn_i v2 4.67e-16
Cconserve2430 vbp_bias v2 4.0782e-16
Cconserve2431 vbp_cas v2 2.11532e-15
Cconserve2432 vbp_i v2 1.6368e-16
Cconserve2433 vbp_tail v2 2.4124e-16
Cconserve2434 vcasp v2 3.9417e-16
Cconserve2435 vgn1 v2 1.98185e-15
Cconserve2436 v2 vgn2 2.46456e-15
Cconserve2437 v2 vnx_bias 1.2642e-16
Cconserve2438 v2 vsp 1.10642e-14
Cconserve2439 vsu1 v2 1.1888e-16
Cconserve2440 vsu2 v2 3.4609e-16
Cconserve2441 xf1 v2 1.25868e-15
Cconserve2442 xf2 v2 1.15641e-14
Cconserve2443 vbp_i vaux 3.289e-16
Cconserve2444 vcasp vaux 3.49991e-15
Cconserve2445 vaux vnx_bias 1.1873e-16
Cconserve2446 vcasp vbn 2.53988e-15
Cconserve2447 vsu vbn 3.5354e-16
Cconserve2448 vbn_fold vbn_i 2.675e-16
Cconserve2449 vbn_sink vbn_fold 3.89325e-15
Cconserve2450 vbn_fold vbp_i 1.28191e-14
Cconserve2451 vbp_tail vbn_fold 4.9119e-16
Cconserve2452 vcasp vbn_fold 6.1735e-16
Cconserve2453 vbn_fold vgn2 2.94054e-15
Cconserve2454 vbn_fold vnx_bias 3.57721e-15
Cconserve2455 vq3 vbn_fold 2.10089e-15
Cconserve2456 vref vbn_fold 5.4268e-16
Cconserve2457 vsu vbn_fold 4.4257e-16
Cconserve2458 vsua vbn_fold 3.52e-16
Cconserve2459 vbn_fold xf1 4.20325e-15
Cconserve2460 vbn_fold xf2 2.50897e-15
Cconserve2461 y1 vbn_fold 1.8844e-16
Cconserve2462 vbp_i vbn_i 7.64192e-15
Cconserve2463 vbp_tail vbn_i 1.41501e-15
Cconserve2464 vcasp vbn_i 2.4227e-16
Cconserve2465 vbn_i vgn1 1.52543e-14
Cconserve2466 vbn_i vgn2 1.16074e-15
Cconserve2467 vbn_i vnx_bias 1.5854e-14
Cconserve2468 vq3 vbn_i 2.5936e-16
Cconserve2469 vref vbn_i 1.5089e-16
Cconserve2470 vsu2 vbn_i 1.2901e-16
Cconserve2471 vbn_sink vbp_i 1.8381e-14
Cconserve2472 vbn_sink vbp_tail 2.37557e-15
Cconserve2473 vbn_sink vgn2 1.02932e-15
Cconserve2474 vq3 vbn_sink 2.0844e-16
Cconserve2475 vbn_sink xf1 6.46388e-15
Cconserve2476 vbn_sink xf2 6.54073e-15
Cconserve2477 vbp_bias vbp_cas 1.45859e-14
Cconserve2478 vbp_bias vbp_i 3.0346e-16
Cconserve2479 vbp_bias vbp_tail 8.7928e-16
Cconserve2480 vbp_bias vref 1.11855e-15
Cconserve2481 vbp_i vbp_cas 4.1282e-16
Cconserve2482 vcasp vbp_cas 3.14978e-15
Cconserve2483 vbp_cas vgn1 1.53672e-15
Cconserve2484 vbp_cas vgn2 9.81598e-15
Cconserve2485 y1 vbp_cas 8.24885e-15
Cconserve2486 vbp_tail vbp_i 2.50901e-15
Cconserve2487 vcasp vbp_i 8.1813e-16
Cconserve2488 vbp_i vgn2 2.1338e-16
Cconserve2489 vq3 vbp_i 3.9704e-16
Cconserve2490 vref vbp_i 2.6276e-16
Cconserve2491 vsu1 vbp_i 3.2765e-16
Cconserve2492 vsu2 vbp_i 1.91139e-15
Cconserve2493 vcasp vbp_tail 5.3832e-16
Cconserve2494 vq2 vbp_tail 9.1017e-16
Cconserve2495 vq3 vbp_tail 3.5541e-16
Cconserve2496 vbp_tail vref 2.91169e-15
Cconserve2497 vbp_tail vsp 7.75864e-15
Cconserve2498 vsu2 vbp_tail 1.2196e-16
Cconserve2499 vcasp vgn1 5.27225e-15
Cconserve2500 vcasp vgn2 3.8385e-16
Cconserve2501 vcasp vnx_bias 7.9919e-16
Cconserve2502 vcasp vref 8.70622e-15
Cconserve2503 vcasp vsu 4.7883e-16
Cconserve2504 vsu1 vcasp 7.8354e-16
Cconserve2505 vcasp vsua 3.5493e-16
Cconserve2506 vcasp vx1 5.11514e-15
Cconserve2507 vcasp vx2 5.49219e-15
Cconserve2508 vcasp vx3 5.64491e-15
Cconserve2509 vgn1 vgn2 5.08749e-15
Cconserve2510 vref vgn1 1.04938e-15
Cconserve2511 vx1 vgn1 3.76652e-15
Cconserve2512 vgn1 vx2 7.2762e-16
Cconserve2513 vgn1 vx3 1.01119e-15
Cconserve2514 vnx_bias vgn2 6.124e-16
Cconserve2515 xf1 vgn2 1.58047e-15
Cconserve2516 xf2 vgn2 1.39178e-15
Cconserve2517 y1 vgn2 1.33614e-15
Cconserve2518 vsu1 vnx_bias 6.1064e-16
Cconserve2519 vq3 vq2 1.40221e-15
Cconserve2520 vq3 vref 3.57254e-14
Cconserve2521 vx1 vref 7.335e-16
Cconserve2522 vref vx2 9.3047e-16
Cconserve2523 vref vx3 2.39972e-15
Cconserve2524 xf1 vsp 4.97169e-15
Cconserve2525 xf2 vsp 4.80498e-15
Cconserve2526 vsua vsu 5.8394e-16
Cconserve2527 y1 vsua 1.3285e-16
Cconserve2528 vx1 vx2 6.69267e-15
Cconserve2529 vx1 vx3 6.5981e-15
Cconserve2530 vx2 vx3 2.72171e-15
Cconserve2531 xf2 xf1 1.32025e-14
.ends Bandgap_Core_Res
