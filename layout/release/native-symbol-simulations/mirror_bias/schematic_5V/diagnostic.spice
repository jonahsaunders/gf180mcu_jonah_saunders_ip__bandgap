.subckt Bandgap_Core_Res avdd avss vref b0 b1 b2 b3 b4 b5 b6 dvss dvdd
*.iopin avdd
*.iopin avss
*.iopin vref
*.iopin b0
*.iopin b1
*.iopin b2
*.iopin b3
*.iopin b4
*.iopin b5
*.iopin b6
*.iopin dvss
*.iopin dvdd
XQ3 avss avss vq3 pnp_05p00x05p00
XQ2 avss avss vq2 pnp_05p00x05p00 m=8
XQ1 avss avss v1 pnp_05p00x05p00
VAUD0 bgsu1 audit_d0 0
XM9 audit_d0 bgsu1 bgsu2 avss nfet_03v3 L=2u W=1u nf=1 ad='int((nf+1)/2) * W/nf * 0.18u' as='int((nf+2)/2) * W/nf * 0.18u' pd='2*int((nf+1)/2) * (W/nf + 0.18u)' ps='2*int((nf+2)/2) * (W/nf + 0.18u)' nrd='0.18u / W' nrs='0.18u / W' sa=0 sb=0 sd=0
VAUD1 bgsu2 audit_d1 0
XM10 audit_d1 bgsu2 avss avss nfet_03v3 L=2u W=1u nf=1 ad='int((nf+1)/2) * W/nf * 0.18u' as='int((nf+2)/2) * W/nf * 0.18u' pd='2*int((nf+1)/2) * (W/nf + 0.18u)' ps='2*int((nf+2)/2) * (W/nf + 0.18u)' nrd='0.18u / W' nrs='0.18u / W' sa=0 sb=0 sd=0
XR1 vq2 v2 avss ppolyf_u_1k r_width=4e-6 r_length=42.10e-6
VI1 net2 vgn1 0
VI2 vgp psrg_m3_feed 0
VI3 net1 vref 0
VAUD2 auxsu1 audit_d2 0
XM22 audit_d2 auxsu1 auxsu2 avss nfet_03v3 L=2u W=1u nf=1 ad='int((nf+1)/2) * W/nf * 0.18u' as='int((nf+2)/2) * W/nf * 0.18u' pd='2*int((nf+1)/2) * (W/nf + 0.18u)' ps='2*int((nf+2)/2) * (W/nf + 0.18u)' nrd='0.18u / W' nrs='0.18u / W' sa=0 sb=0 sd=0
VAUD3 auxsu2 audit_d3 0
XM23 audit_d3 auxsu2 avss avss nfet_03v3 L=2u W=1u nf=1 ad='int((nf+1)/2) * W/nf * 0.18u' as='int((nf+2)/2) * W/nf * 0.18u' pd='2*int((nf+1)/2) * (W/nf + 0.18u)' ps='2*int((nf+2)/2) * (W/nf + 0.18u)' nrd='0.18u / W' nrs='0.18u / W' sa=0 sb=0 sd=0
VAUD4 net2 audit_d4 0
XM11 audit_d4 vcasp vx1 avdd pfet_05v0 L=4u W=16.42u nf=1 ad='int((nf+1)/2) * W/nf * 0.18u' as='int((nf+2)/2) * W/nf * 0.18u' pd='2*int((nf+1)/2) * (W/nf + 0.18u)' ps='2*int((nf+2)/2) * (W/nf + 0.18u)' nrd='0.18u / W' nrs='0.18u / W' sa=0 sb=0 sd=0 m=5
VAUD5 vgp audit_d5 0
XM12 audit_d5 vcasp vx2 avdd pfet_05v0 L=4u W=16.42u nf=1 ad='int((nf+1)/2) * W/nf * 0.18u' as='int((nf+2)/2) * W/nf * 0.18u' pd='2*int((nf+1)/2) * (W/nf + 0.18u)' ps='2*int((nf+2)/2) * (W/nf + 0.18u)' nrd='0.18u / W' nrs='0.18u / W' sa=0 sb=0 sd=0 m=5
VAUD6 net1 audit_d6 0
XM13 audit_d6 vcasp vx3 avdd pfet_05v0 L=4u W=16.42u nf=1 ad='int((nf+1)/2) * W/nf * 0.18u' as='int((nf+2)/2) * W/nf * 0.18u' pd='2*int((nf+1)/2) * (W/nf + 0.18u)' ps='2*int((nf+2)/2) * (W/nf + 0.18u)' nrd='0.18u / W' nrs='0.18u / W' sa=0 sb=0 sd=0 m=5
VAUD7 vgn1 audit_d7 0
XM4 audit_d7 vgn1 v1 avss nfet_05v0 L=4u W=14.6u nf=1 ad='int((nf+1)/2) * W/nf * 0.18u' as='int((nf+2)/2) * W/nf * 0.18u' pd='2*int((nf+1)/2) * (W/nf + 0.18u)' ps='2*int((nf+2)/2) * (W/nf + 0.18u)' nrd='0.18u / W' nrs='0.18u / W' sa=0 sb=0 sd=0 m=2
VAUD8 psrg_m3_protected audit_d8 0
XM3 audit_d8 vgn2 v2 avss nfet_05v0 L=4u W=14.6u nf=1 ad='int((nf+1)/2) * W/nf * 0.18u' as='int((nf+2)/2) * W/nf * 0.18u' pd='2*int((nf+1)/2) * (W/nf + 0.18u)' ps='2*int((nf+2)/2) * (W/nf + 0.18u)' nrd='0.18u / W' nrs='0.18u / W' sa=0 sb=0 sd=0 m=2
VAUD9 vbn audit_d9 0
XM16 audit_d9 vbn avss avss nfet_05v0 L=4u W=7.55u nf=1 ad='int((nf+1)/2) * W/nf * 0.18u' as='int((nf+2)/2) * W/nf * 0.18u' pd='2*int((nf+1)/2) * (W/nf + 0.18u)' ps='2*int((nf+2)/2) * (W/nf + 0.18u)' nrd='0.18u / W' nrs='0.18u / W' sa=0 sb=0 sd=0
VAUD10 vcasp audit_d10 0
XM18 audit_d10 vbn avss avss nfet_05v0 L=4u W=7.55u nf=1 ad='int((nf+1)/2) * W/nf * 0.18u' as='int((nf+2)/2) * W/nf * 0.18u' pd='2*int((nf+1)/2) * (W/nf + 0.18u)' ps='2*int((nf+2)/2) * (W/nf + 0.18u)' nrd='0.18u / W' nrs='0.18u / W' sa=0 sb=0 sd=0
VAUD11 vbn audit_d11 0
XM15 audit_d11 vcasp vaux avdd pfet_05v0 L=4u W=16u nf=1 ad='int((nf+1)/2) * W/nf * 0.18u' as='int((nf+2)/2) * W/nf * 0.18u' pd='2*int((nf+1)/2) * (W/nf + 0.18u)' ps='2*int((nf+2)/2) * (W/nf + 0.18u)' nrd='0.18u / W' nrs='0.18u / W' sa=0 sb=0 sd=0
VAUD12 vcasp audit_d12 0
XM17 audit_d12 vcasp avdd avdd pfet_05v0 L=2u W=0.9u nf=1 ad='int((nf+1)/2) * W/nf * 0.18u' as='int((nf+2)/2) * W/nf * 0.18u' pd='2*int((nf+1)/2) * (W/nf + 0.18u)' ps='2*int((nf+2)/2) * (W/nf + 0.18u)' nrd='0.18u / W' nrs='0.18u / W' sa=0 sb=0 sd=0
VAUD13 vsu audit_d13 0
XM6 audit_d13 vgp avdd avdd pfet_05v0 L=2u W=2u nf=1 ad='int((nf+1)/2) * W/nf * 0.18u' as='int((nf+2)/2) * W/nf * 0.18u' pd='2*int((nf+1)/2) * (W/nf + 0.18u)' ps='2*int((nf+2)/2) * (W/nf + 0.18u)' nrd='0.18u / W' nrs='0.18u / W' sa=0 sb=0 sd=0
VAUD14 vsua audit_d14 0
XM19 audit_d14 vcasp avdd avdd pfet_05v0 L=2u W=2u nf=1 ad='int((nf+1)/2) * W/nf * 0.18u' as='int((nf+2)/2) * W/nf * 0.18u' pd='2*int((nf+1)/2) * (W/nf + 0.18u)' ps='2*int((nf+2)/2) * (W/nf + 0.18u)' nrd='0.18u / W' nrs='0.18u / W' sa=0 sb=0 sd=0
VAUD15 vsu audit_d15 0
XM8 audit_d15 vsu bgsu1 avss nfet_05v0 L=2u W=1u nf=1 ad='int((nf+1)/2) * W/nf * 0.18u' as='int((nf+2)/2) * W/nf * 0.18u' pd='2*int((nf+1)/2) * (W/nf + 0.18u)' ps='2*int((nf+2)/2) * (W/nf + 0.18u)' nrd='0.18u / W' nrs='0.18u / W' sa=0 sb=0 sd=0
VAUD16 vsua audit_d16 0
XM21 audit_d16 vsua auxsu1 avss nfet_05v0 L=2u W=1u nf=1 ad='int((nf+1)/2) * W/nf * 0.18u' as='int((nf+2)/2) * W/nf * 0.18u' pd='2*int((nf+1)/2) * (W/nf + 0.18u)' ps='2*int((nf+2)/2) * (W/nf + 0.18u)' nrd='0.18u / W' nrs='0.18u / W' sa=0 sb=0 sd=0
VAUD17 vx1 audit_d17 0
XM2 audit_d17 vgp avdd avdd pfet_05v0 L=2u W=16.75u nf=1 ad='int((nf+1)/2) * W/nf * 0.18u' as='int((nf+2)/2) * W/nf * 0.18u' pd='2*int((nf+1)/2) * (W/nf + 0.18u)' ps='2*int((nf+2)/2) * (W/nf + 0.18u)' nrd='0.18u / W' nrs='0.18u / W' sa=0 sb=0 sd=0 m=6
VAUD18 vx2 audit_d18 0
XM1 audit_d18 vgp avdd avdd pfet_05v0 L=2u W=16.75u nf=1 ad='int((nf+1)/2) * W/nf * 0.18u' as='int((nf+2)/2) * W/nf * 0.18u' pd='2*int((nf+1)/2) * (W/nf + 0.18u)' ps='2*int((nf+2)/2) * (W/nf + 0.18u)' nrd='0.18u / W' nrs='0.18u / W' sa=0 sb=0 sd=0 m=6
VAUD19 vx3 audit_d19 0
XM5 audit_d19 vgp avdd avdd pfet_05v0 L=2u W=16.75u nf=1 ad='int((nf+1)/2) * W/nf * 0.18u' as='int((nf+2)/2) * W/nf * 0.18u' pd='2*int((nf+1)/2) * (W/nf + 0.18u)' ps='2*int((nf+2)/2) * (W/nf + 0.18u)' nrd='0.18u / W' nrs='0.18u / W' sa=0 sb=0 sd=0 m=6
VAUD20 vaux audit_d20 0
XM14 audit_d20 vgp avdd avdd pfet_05v0 L=2u W=10u nf=1 ad='int((nf+1)/2) * W/nf * 0.18u' as='int((nf+2)/2) * W/nf * 0.18u' pd='2*int((nf+1)/2) * (W/nf + 0.18u)' ps='2*int((nf+2)/2) * (W/nf + 0.18u)' nrd='0.18u / W' nrs='0.18u / W' sa=0 sb=0 sd=0 m=2
VAUD21 psrg_m3_feed audit_d21 0
XM3C audit_d21 psrg_vnc psrg_m3_protected avss nfet_05v0 L=4u W=14.6u nf=1 ad='int((nf+1)/2) * W/nf * 0.18u' as='int((nf+2)/2) * W/nf * 0.18u' pd='2*int((nf+1)/2) * (W/nf + 0.18u)' ps='2*int((nf+2)/2) * (W/nf + 0.18u)' nrd='0.18u / W' nrs='0.18u / W' sa=0 sb=0 sd=0 m=2
XC2 vref avss cap_mim_2f0fF c_width=70.7e-6 c_length=70.7e-6
XC3 vref avss cap_mim_2f0fF c_width=70.7e-6 c_length=70.7e-6
XC4 vref avss cap_mim_2f0fF c_width=70.7e-6 c_length=70.7e-6
XC5 vref avss cap_mim_2f0fF c_width=70.7e-6 c_length=70.7e-6
XC6 vref avss cap_mim_2f0fF c_width=70.7e-6 c_length=70.7e-6
XC7 vref avss cap_mim_2f0fF c_width=70.7e-6 c_length=70.7e-6
XC8 vref avss cap_mim_2f0fF c_width=70.7e-6 c_length=70.7e-6
XC9 vref avss cap_mim_2f0fF c_width=70.7e-6 c_length=70.7e-6
XC10 vref avss cap_mim_2f0fF c_width=70.7e-6 c_length=70.7e-6
XC11 vref avss cap_mim_2f0fF c_width=70.7e-6 c_length=70.7e-6
VAUD22 vsp audit_d22 0
XMTAIL audit_d22 vbp_tail avdd avdd pfet_03v3 L=6u W=28.91u nf=1 ad='int((nf+1)/2) * W/nf * 0.18u' as='int((nf+2)/2) * W/nf * 0.18u' pd='2*int((nf+1)/2) * (W/nf + 0.18u)' ps='2*int((nf+2)/2) * (W/nf + 0.18u)' nrd='0.18u / W' nrs='0.18u / W' sa=0 sb=0 sd=0 m=6
XR3 net3 net4 avss nwell r_width=2e-6 r_length=20.19e-6
XR4 avss net3 avdd pplus_u r_width=1e-6 r_length=232.53e-6
VSENSE vrs net4 0
VSTARTSENSE net5 vbn_i 0
VAUD23 vgn2 audit_d23 0
XPCAS2 audit_d23 vbp_cas pm2 avdd pfet_05v0 L=8u W=22.21u nf=1 ad='int((nf+1)/2) * W/nf * 0.18u' as='int((nf+2)/2) * W/nf * 0.18u' pd='2*int((nf+1)/2) * (W/nf + 0.18u)' ps='2*int((nf+2)/2) * (W/nf + 0.18u)' nrd='0.18u / W' nrs='0.18u / W' sa=0 sb=0 sd=0 m=6
VAUD24 y1 audit_d24 0
XPCAS1 audit_d24 vbp_cas pm1 avdd pfet_05v0 L=8u W=22.21u nf=1 ad='int((nf+1)/2) * W/nf * 0.18u' as='int((nf+2)/2) * W/nf * 0.18u' pd='2*int((nf+1)/2) * (W/nf + 0.18u)' ps='2*int((nf+2)/2) * (W/nf + 0.18u)' nrd='0.18u / W' nrs='0.18u / W' sa=0 sb=0 sd=0 m=6
VAUD25 xf2 audit_d25 0
XMINN audit_d25 v2 vsp avdd pfet_05v0 L=4u W=54.89u nf=1 ad='int((nf+1)/2) * W/nf * 0.18u' as='int((nf+2)/2) * W/nf * 0.18u' pd='2*int((nf+1)/2) * (W/nf + 0.18u)' ps='2*int((nf+2)/2) * (W/nf + 0.18u)' nrd='0.18u / W' nrs='0.18u / W' sa=0 sb=0 sd=0 m=5
VAUD26 xf1 audit_d26 0
XMINP audit_d26 v1 vsp avdd pfet_05v0 L=4u W=54.89u nf=1 ad='int((nf+1)/2) * W/nf * 0.18u' as='int((nf+2)/2) * W/nf * 0.18u' pd='2*int((nf+1)/2) * (W/nf + 0.18u)' ps='2*int((nf+2)/2) * (W/nf + 0.18u)' nrd='0.18u / W' nrs='0.18u / W' sa=0 sb=0 sd=0 m=5
VAUD27 vgn2 audit_d27 0
XMFOLD2 audit_d27 vbn_fold xf2 avss nfet_05v0 L=6u W=18.49u nf=1 ad='int((nf+1)/2) * W/nf * 0.18u' as='int((nf+2)/2) * W/nf * 0.18u' pd='2*int((nf+1)/2) * (W/nf + 0.18u)' ps='2*int((nf+2)/2) * (W/nf + 0.18u)' nrd='0.18u / W' nrs='0.18u / W' sa=0 sb=0 sd=0
VAUD28 psrg_mf1_protected audit_d28 0
XMFOLD1 audit_d28 vbn_fold xf1 avss nfet_05v0 L=6u W=18.49u nf=1 ad='int((nf+1)/2) * W/nf * 0.18u' as='int((nf+2)/2) * W/nf * 0.18u' pd='2*int((nf+1)/2) * (W/nf + 0.18u)' ps='2*int((nf+2)/2) * (W/nf + 0.18u)' nrd='0.18u / W' nrs='0.18u / W' sa=0 sb=0 sd=0
VAUD29 vbn_i audit_d29 0
XN1 audit_d29 vbn_i avss avss nfet_05v0 L=8u W=7.78u nf=1 ad='int((nf+1)/2) * W/nf * 0.18u' as='int((nf+2)/2) * W/nf * 0.18u' pd='2*int((nf+1)/2) * (W/nf + 0.18u)' ps='2*int((nf+2)/2) * (W/nf + 0.18u)' nrd='0.18u / W' nrs='0.18u / W' sa=0 sb=0 sd=0
VAUD30 vbp_i audit_d30 0
XN2 audit_d30 vbn_i vrs avss nfet_05v0 L=8u W=9.13u nf=1 ad='int((nf+1)/2) * W/nf * 0.18u' as='int((nf+2)/2) * W/nf * 0.18u' pd='2*int((nf+1)/2) * (W/nf + 0.18u)' ps='2*int((nf+2)/2) * (W/nf + 0.18u)' nrd='0.18u / W' nrs='0.18u / W' sa=0 sb=0 sd=0
VAUD31 vbp_i audit_d31 0
XPREF audit_d31 vbp_i avdd avdd pfet_05v0 L=8u W=18.75u nf=1 ad='int((nf+1)/2) * W/nf * 0.18u' as='int((nf+2)/2) * W/nf * 0.18u' pd='2*int((nf+1)/2) * (W/nf + 0.18u)' ps='2*int((nf+2)/2) * (W/nf + 0.18u)' nrd='0.18u / W' nrs='0.18u / W' sa=0 sb=0 sd=0 m=5
VAUD32 vbn_i audit_d32 0
XPRMIR audit_d32 vbp_i avdd avdd pfet_05v0 L=8u W=18.75u nf=1 ad='int((nf+1)/2) * W/nf * 0.18u' as='int((nf+2)/2) * W/nf * 0.18u' pd='2*int((nf+1)/2) * (W/nf + 0.18u)' ps='2*int((nf+2)/2) * (W/nf + 0.18u)' nrd='0.18u / W' nrs='0.18u / W' sa=0 sb=0 sd=0 m=5
VAUD33 vbp_tail audit_d33 0
XNTAIL audit_d33 vbn_i avss avss nfet_05v0 L=8u W=13.95u nf=1 ad='int((nf+1)/2) * W/nf * 0.18u' as='int((nf+2)/2) * W/nf * 0.18u' pd='2*int((nf+1)/2) * (W/nf + 0.18u)' ps='2*int((nf+2)/2) * (W/nf + 0.18u)' nrd='0.18u / W' nrs='0.18u / W' sa=0 sb=0 sd=0
VAUD34 vbp_cas audit_d34 0
XN3 audit_d34 vbn_i avss avss nfet_05v0 L=8u W=0.65u nf=1 ad='int((nf+1)/2) * W/nf * 0.18u' as='int((nf+2)/2) * W/nf * 0.18u' pd='2*int((nf+1)/2) * (W/nf + 0.18u)' ps='2*int((nf+2)/2) * (W/nf + 0.18u)' nrd='0.18u / W' nrs='0.18u / W' sa=0 sb=0 sd=0
VAUD35 vbn_sink audit_d35 0
XMPSINK audit_d35 vbp_i avdd avdd pfet_05v0 L=8u W=18.95u nf=1 ad='int((nf+1)/2) * W/nf * 0.18u' as='int((nf+2)/2) * W/nf * 0.18u' pd='2*int((nf+1)/2) * (W/nf + 0.18u)' ps='2*int((nf+2)/2) * (W/nf + 0.18u)' nrd='0.18u / W' nrs='0.18u / W' sa=0 sb=0 sd=0 m=17
VAUD36 vbn_fold audit_d36 0
XMPFOLD audit_d36 vbp_i avdd avdd pfet_05v0 L=8u W=18.99u nf=1 ad='int((nf+1)/2) * W/nf * 0.18u' as='int((nf+2)/2) * W/nf * 0.18u' pd='2*int((nf+1)/2) * (W/nf + 0.18u)' ps='2*int((nf+2)/2) * (W/nf + 0.18u)' nrd='0.18u / W' nrs='0.18u / W' sa=0 sb=0 sd=0 m=12
VAUD37 vbn_fold audit_d37 0
XVBNFOLDHIGH audit_d37 vbn_fold vnx_bias avss nfet_05v0 L=6u W=4.62u nf=1 ad='int((nf+1)/2) * W/nf * 0.18u' as='int((nf+2)/2) * W/nf * 0.18u' pd='2*int((nf+1)/2) * (W/nf + 0.18u)' ps='2*int((nf+2)/2) * (W/nf + 0.18u)' nrd='0.18u / W' nrs='0.18u / W' sa=0 sb=0 sd=0
VAUD38 vbp_cas audit_d38 0
XVBPCASLOW audit_d38 vbp_cas vbp_bias avdd pfet_05v0 L=8u W=18.93u nf=1 ad='int((nf+1)/2) * W/nf * 0.18u' as='int((nf+2)/2) * W/nf * 0.18u' pd='2*int((nf+1)/2) * (W/nf + 0.18u)' ps='2*int((nf+2)/2) * (W/nf + 0.18u)' nrd='0.18u / W' nrs='0.18u / W' sa=0 sb=0 sd=0 m=10
VAUD39 vbp_tail audit_d39 0
XVBPTAIL audit_d39 vbp_tail avdd avdd pfet_03v3 L=6u W=13.75u nf=1 ad='int((nf+1)/2) * W/nf * 0.18u' as='int((nf+2)/2) * W/nf * 0.18u' pd='2*int((nf+1)/2) * (W/nf + 0.18u)' ps='2*int((nf+2)/2) * (W/nf + 0.18u)' nrd='0.18u / W' nrs='0.18u / W' sa=0 sb=0 sd=0 m=3
VAUD40 vnx_bias audit_d40 0
XVBNFOLDLOW audit_d40 vnx_bias avss avss nfet_03v3 L=8u W=1.62u nf=1 ad='int((nf+1)/2) * W/nf * 0.18u' as='int((nf+2)/2) * W/nf * 0.18u' pd='2*int((nf+1)/2) * (W/nf + 0.18u)' ps='2*int((nf+2)/2) * (W/nf + 0.18u)' nrd='0.18u / W' nrs='0.18u / W' sa=0 sb=0 sd=0
VAUD41 vbp_bias audit_d41 0
XVBPCASHIGHER audit_d41 vbp_bias avdd avdd pfet_03v3 L=8u W=19.06u nf=1 ad='int((nf+1)/2) * W/nf * 0.18u' as='int((nf+2)/2) * W/nf * 0.18u' pd='2*int((nf+1)/2) * (W/nf + 0.18u)' ps='2*int((nf+2)/2) * (W/nf + 0.18u)' nrd='0.18u / W' nrs='0.18u / W' sa=0 sb=0 sd=0 m=9
VAUD42 vsu1 audit_d42 0
XSUPN2 audit_d42 vbp_i vsu2 avss nfet_05v0 L=50u W=0.5u nf=1 ad='int((nf+1)/2) * W/nf * 0.18u' as='int((nf+2)/2) * W/nf * 0.18u' pd='2*int((nf+1)/2) * (W/nf + 0.18u)' ps='2*int((nf+2)/2) * (W/nf + 0.18u)' nrd='0.18u / W' nrs='0.18u / W' sa=0 sb=0 sd=0
VAUD43 vsu2 audit_d43 0
XSUPN3 audit_d43 vbp_i avss avss nfet_05v0 L=50u W=0.5u nf=1 ad='int((nf+1)/2) * W/nf * 0.18u' as='int((nf+2)/2) * W/nf * 0.18u' pd='2*int((nf+1)/2) * (W/nf + 0.18u)' ps='2*int((nf+2)/2) * (W/nf + 0.18u)' nrd='0.18u / W' nrs='0.18u / W' sa=0 sb=0 sd=0
VAUD44 pm1 audit_d44 0
XPLOAD1 audit_d44 y1 avdd avdd pfet_05v0 L=4u W=20.76u nf=1 ad='int((nf+1)/2) * W/nf * 0.18u' as='int((nf+2)/2) * W/nf * 0.18u' pd='2*int((nf+1)/2) * (W/nf + 0.18u)' ps='2*int((nf+2)/2) * (W/nf + 0.18u)' nrd='0.18u / W' nrs='0.18u / W' sa=0 sb=0 sd=0 m=6
VAUD45 pm2 audit_d45 0
XPLOAD2 audit_d45 y1 avdd avdd pfet_05v0 L=4u W=20.76u nf=1 ad='int((nf+1)/2) * W/nf * 0.18u' as='int((nf+2)/2) * W/nf * 0.18u' pd='2*int((nf+1)/2) * (W/nf + 0.18u)' ps='2*int((nf+2)/2) * (W/nf + 0.18u)' nrd='0.18u / W' nrs='0.18u / W' sa=0 sb=0 sd=0 m=6
VAUD46 y1 audit_d46 0
XMFOLD1C audit_d46 psrg_vnc psrg_mf1_protected avss nfet_05v0 L=6u W=18.49u nf=1 ad='int((nf+1)/2) * W/nf * 0.18u' as='int((nf+2)/2) * W/nf * 0.18u' pd='2*int((nf+1)/2) * (W/nf + 0.18u)' ps='2*int((nf+2)/2) * (W/nf + 0.18u)' nrd='0.18u / W' nrs='0.18u / W' sa=0 sb=0 sd=0
VAUD47 psrg_vnc audit_d47 0
XRB_P audit_d47 vbp_i avdd avdd pfet_05v0 L=4u W=17.74u nf=1 ad='int((nf+1)/2) * W/nf * 0.18u' as='int((nf+2)/2) * W/nf * 0.18u' pd='2*int((nf+1)/2) * (W/nf + 0.18u)' ps='2*int((nf+2)/2) * (W/nf + 0.18u)' nrd='0.18u / W' nrs='0.18u / W' sa=0 sb=0 sd=0 m=7
VAUD48 psrg_vnc audit_d48 0
XRB_NU audit_d48 psrg_vnc rb_mid avss nfet_05v0 L=20u W=0.71u nf=1 ad='int((nf+1)/2) * W/nf * 0.18u' as='int((nf+2)/2) * W/nf * 0.18u' pd='2*int((nf+1)/2) * (W/nf + 0.18u)' ps='2*int((nf+2)/2) * (W/nf + 0.18u)' nrd='0.18u / W' nrs='0.18u / W' sa=0 sb=0 sd=0
VAUD49 rb_mid audit_d49 0
XRB_NL audit_d49 rb_mid avss avss nfet_05v0 L=20u W=0.54u nf=1 ad='int((nf+1)/2) * W/nf * 0.18u' as='int((nf+2)/2) * W/nf * 0.18u' pd='2*int((nf+1)/2) * (W/nf + 0.18u)' ps='2*int((nf+2)/2) * (W/nf + 0.18u)' nrd='0.18u / W' nrs='0.18u / W' sa=0 sb=0 sd=0
VAUD50 su_state audit_d50 0
XMSU_LOAD audit_d50 vbp_tail avdd avdd pfet_05v0 L=8u W=1u nf=1 ad='int((nf+1)/2) * W/nf * 0.18u' as='int((nf+2)/2) * W/nf * 0.18u' pd='2*int((nf+1)/2) * (W/nf + 0.18u)' ps='2*int((nf+2)/2) * (W/nf + 0.18u)' nrd='0.18u / W' nrs='0.18u / W' sa=0 sb=0 sd=0
VAUD51 su_state audit_d51 0
XMSU_HYS audit_d51 vsu avdd avdd pfet_05v0 L=8u W=1u nf=1 ad='int((nf+1)/2) * W/nf * 0.18u' as='int((nf+2)/2) * W/nf * 0.18u' pd='2*int((nf+1)/2) * (W/nf + 0.18u)' ps='2*int((nf+2)/2) * (W/nf + 0.18u)' nrd='0.18u / W' nrs='0.18u / W' sa=0 sb=0 sd=0
VAUD52 su_state audit_d52 0
XMSU_SENSE audit_d52 vgn2 avss avss nfet_05v0 L=1u W=4u nf=1 ad='int((nf+1)/2) * W/nf * 0.18u' as='int((nf+2)/2) * W/nf * 0.18u' pd='2*int((nf+1)/2) * (W/nf + 0.18u)' ps='2*int((nf+2)/2) * (W/nf + 0.18u)' nrd='0.18u / W' nrs='0.18u / W' sa=0 sb=0 sd=0
XC1 vgn2 avss cap_mim_2f0fF c_width=59e-6 c_length=59e-6
VAUD53 vbn audit_d53 0
XM20 audit_d53 aux_gate avdd avdd pfet_05v0 L=8u W=0.5u nf=1 ad='int((nf+1)/2) * W/nf * 0.18u' as='int((nf+2)/2) * W/nf * 0.18u' pd='2*int((nf+1)/2) * (W/nf + 0.18u)' ps='2*int((nf+2)/2) * (W/nf + 0.18u)' nrd='0.18u / W' nrs='0.18u / W' sa=0 sb=0 sd=0
VAUD54 iref_gate audit_d54 0
XSUPPDET audit_d54 vbp_i avdd avdd pfet_05v0 L=1u W=80u nf=1 ad='int((nf+1)/2) * W/nf * 0.18u' as='int((nf+2)/2) * W/nf * 0.18u' pd='2*int((nf+1)/2) * (W/nf + 0.18u)' ps='2*int((nf+2)/2) * (W/nf + 0.18u)' nrd='0.18u / W' nrs='0.18u / W' sa=0 sb=0 sd=0 m=2
VAUD55 iref_gate audit_d55 0
XSUPN1 audit_d55 vbp_i vsu1 avss nfet_05v0 L=50u W=0.5u nf=1 ad='int((nf+1)/2) * W/nf * 0.18u' as='int((nf+2)/2) * W/nf * 0.18u' pd='2*int((nf+1)/2) * (W/nf + 0.18u)' ps='2*int((nf+2)/2) * (W/nf + 0.18u)' nrd='0.18u / W' nrs='0.18u / W' sa=0 sb=0 sd=0
VAUD56 net5 audit_d56 0
XSUPINJ audit_d56 iref_gate avdd avdd pfet_05v0 L=8u W=0.5u nf=1 ad='int((nf+1)/2) * W/nf * 0.18u' as='int((nf+2)/2) * W/nf * 0.18u' pd='2*int((nf+1)/2) * (W/nf + 0.18u)' ps='2*int((nf+2)/2) * (W/nf + 0.18u)' nrd='0.18u / W' nrs='0.18u / W' sa=0 sb=0 sd=0
VAUD57 vgn1 audit_d57 0
XM7 audit_d57 aux_gate vgp avdd pfet_05v0 L=2u W=2u nf=1 ad='int((nf+1)/2) * W/nf * 0.18u' as='int((nf+2)/2) * W/nf * 0.18u' pd='2*int((nf+1)/2) * (W/nf + 0.18u)' ps='2*int((nf+2)/2) * (W/nf + 0.18u)' nrd='0.18u / W' nrs='0.18u / W' sa=0 sb=0 sd=0
VAUD58 xf1 audit_d58 0
XMSINK1 audit_d58 vbn_sink avss avss nfet_05v0 L=8u W=16.34u nf=1 ad='int((nf+1)/2) * W/nf * 0.18u' as='int((nf+2)/2) * W/nf * 0.18u' pd='2*int((nf+1)/2) * (W/nf + 0.18u)' ps='2*int((nf+2)/2) * (W/nf + 0.18u)' nrd='0.18u / W' nrs='0.18u / W' sa=0 sb=0 sd=0 m=6
VAUD59 xf2 audit_d59 0
XMSINK2 audit_d59 vbn_sink avss avss nfet_05v0 L=8u W=16.34u nf=1 ad='int((nf+1)/2) * W/nf * 0.18u' as='int((nf+2)/2) * W/nf * 0.18u' pd='2*int((nf+1)/2) * (W/nf + 0.18u)' ps='2*int((nf+2)/2) * (W/nf + 0.18u)' nrd='0.18u / W' nrs='0.18u / W' sa=0 sb=0 sd=0 m=6
VAUD60 vbn_sink audit_d60 0
XVBNSINK audit_d60 vbn_sink avss avss nfet_05v0 L=8u W=12.31u nf=1 ad='int((nf+1)/2) * W/nf * 0.18u' as='int((nf+2)/2) * W/nf * 0.18u' pd='2*int((nf+1)/2) * (W/nf + 0.18u)' ps='2*int((nf+2)/2) * (W/nf + 0.18u)' nrd='0.18u / W' nrs='0.18u / W' sa=0 sb=0 sd=0 m=2
VAUD61 aux_gate audit_d61 0
XAP audit_d61 vcasp avdd avdd pfet_05v0 L=10u W=0.5u nf=1 ad='int((nf+1)/2) * W/nf * 0.18u' as='int((nf+2)/2) * W/nf * 0.18u' pd='2*int((nf+1)/2) * (W/nf + 0.18u)' ps='2*int((nf+2)/2) * (W/nf + 0.18u)' nrd='0.18u / W' nrs='0.18u / W' sa=0 sb=0 sd=0
VAUD62 aux_gate audit_d62 0
XAN audit_d62 vbn_i avss avss nfet_05v0 L=8u W=1u nf=1 ad='int((nf+1)/2) * W/nf * 0.18u' as='int((nf+2)/2) * W/nf * 0.18u' pd='2*int((nf+1)/2) * (W/nf + 0.18u)' ps='2*int((nf+2)/2) * (W/nf + 0.18u)' nrd='0.18u / W' nrs='0.18u / W' sa=0 sb=0 sd=0
XRFIXED rfix0 vref avss ppolyf_u_1k r_width=6.6e-6 r_length=128e-6
XRB0 rbit1top rbit0top avss ppolyf_u_1k r_width=6.6e-6 r_length=2e-6
XRB1 rbit2top rbit1top avss ppolyf_u_1k r_width=6.6e-6 r_length=4e-6
XRB2 rbit3top rbit2top avss ppolyf_u_1k r_width=6.6e-6 r_length=8e-6
XRB3 rbit4top rbit3top avss ppolyf_u_1k r_width=6.6e-6 r_length=16e-6
XRB4 rbit5top rbit4top avss ppolyf_u_1k r_width=6.6e-6 r_length=32e-6
XRB5 rbit6top rbit5top avss ppolyf_u_1k r_width=6.6e-6 r_length=64e-6
XRB6 vq3 rbit6top avss ppolyf_u_1k r_width=6.6e-6 r_length=128e-6
XRFIXED1 rfix1 rfix0 avss ppolyf_u_1k r_width=6.6e-6 r_length=128e-6
XRFIXED2 rfix2 rfix1 avss ppolyf_u_1k r_width=6.6e-6 r_length=128e-6
XRFIXED3 rbit0top rfix2 avss ppolyf_u_1k r_width=6.6e-6 r_length=128e-6
VAUD63 rbit1top audit_d63 0
XM24 audit_d63 b0_b rbit0top dvdd pfet_03v3 L=0.28u W=40u nf=1 ad='int((nf+1)/2) * W/nf * 0.18u' as='int((nf+2)/2) * W/nf * 0.18u' pd='2*int((nf+1)/2) * (W/nf + 0.18u)' ps='2*int((nf+2)/2) * (W/nf + 0.18u)' nrd='0.18u / W' nrs='0.18u / W' sa=0 sb=0 sd=0 m=6
VAUD64 rbit0top audit_d64 0
XM25 audit_d64 b0 rbit1top dvss nfet_03v3 L=0.28u W=40u nf=1 ad='int((nf+1)/2) * W/nf * 0.18u' as='int((nf+2)/2) * W/nf * 0.18u' pd='2*int((nf+1)/2) * (W/nf + 0.18u)' ps='2*int((nf+2)/2) * (W/nf + 0.18u)' nrd='0.18u / W' nrs='0.18u / W' sa=0 sb=0 sd=0 m=2
VAUD65 rbit2top audit_d65 0
XM26 audit_d65 b1_b rbit1top dvdd pfet_03v3 L=0.28u W=40u nf=1 ad='int((nf+1)/2) * W/nf * 0.18u' as='int((nf+2)/2) * W/nf * 0.18u' pd='2*int((nf+1)/2) * (W/nf + 0.18u)' ps='2*int((nf+2)/2) * (W/nf + 0.18u)' nrd='0.18u / W' nrs='0.18u / W' sa=0 sb=0 sd=0 m=3
VAUD66 rbit1top audit_d66 0
XM27 audit_d66 b1 rbit2top dvss nfet_03v3 L=0.28u W=40u nf=1 ad='int((nf+1)/2) * W/nf * 0.18u' as='int((nf+2)/2) * W/nf * 0.18u' pd='2*int((nf+1)/2) * (W/nf + 0.18u)' ps='2*int((nf+2)/2) * (W/nf + 0.18u)' nrd='0.18u / W' nrs='0.18u / W' sa=0 sb=0 sd=0
VAUD67 rbit3top audit_d67 0
XM28 audit_d67 b2_b rbit2top dvdd pfet_03v3 L=0.28u W=20u nf=1 ad='int((nf+1)/2) * W/nf * 0.18u' as='int((nf+2)/2) * W/nf * 0.18u' pd='2*int((nf+1)/2) * (W/nf + 0.18u)' ps='2*int((nf+2)/2) * (W/nf + 0.18u)' nrd='0.18u / W' nrs='0.18u / W' sa=0 sb=0 sd=0 m=3
VAUD68 rbit2top audit_d68 0
XM29 audit_d68 b2 rbit3top dvss nfet_03v3 L=0.28u W=20u nf=1 ad='int((nf+1)/2) * W/nf * 0.18u' as='int((nf+2)/2) * W/nf * 0.18u' pd='2*int((nf+1)/2) * (W/nf + 0.18u)' ps='2*int((nf+2)/2) * (W/nf + 0.18u)' nrd='0.18u / W' nrs='0.18u / W' sa=0 sb=0 sd=0
VAUD69 rbit4top audit_d69 0
XM30 audit_d69 b3_b rbit3top dvdd pfet_03v3 L=0.28u W=30u nf=1 ad='int((nf+1)/2) * W/nf * 0.18u' as='int((nf+2)/2) * W/nf * 0.18u' pd='2*int((nf+1)/2) * (W/nf + 0.18u)' ps='2*int((nf+2)/2) * (W/nf + 0.18u)' nrd='0.18u / W' nrs='0.18u / W' sa=0 sb=0 sd=0
VAUD70 rbit3top audit_d70 0
XM31 audit_d70 b3 rbit4top dvss nfet_03v3 L=0.28u W=10u nf=1 ad='int((nf+1)/2) * W/nf * 0.18u' as='int((nf+2)/2) * W/nf * 0.18u' pd='2*int((nf+1)/2) * (W/nf + 0.18u)' ps='2*int((nf+2)/2) * (W/nf + 0.18u)' nrd='0.18u / W' nrs='0.18u / W' sa=0 sb=0 sd=0
VAUD71 rbit5top audit_d71 0
XM32 audit_d71 b4_b rbit4top dvdd pfet_03v3 L=0.28u W=15u nf=1 ad='int((nf+1)/2) * W/nf * 0.18u' as='int((nf+2)/2) * W/nf * 0.18u' pd='2*int((nf+1)/2) * (W/nf + 0.18u)' ps='2*int((nf+2)/2) * (W/nf + 0.18u)' nrd='0.18u / W' nrs='0.18u / W' sa=0 sb=0 sd=0
VAUD72 rbit4top audit_d72 0
XM33 audit_d72 b4 rbit5top dvss nfet_03v3 L=0.28u W=5u nf=1 ad='int((nf+1)/2) * W/nf * 0.18u' as='int((nf+2)/2) * W/nf * 0.18u' pd='2*int((nf+1)/2) * (W/nf + 0.18u)' ps='2*int((nf+2)/2) * (W/nf + 0.18u)' nrd='0.18u / W' nrs='0.18u / W' sa=0 sb=0 sd=0
VAUD73 rbit6top audit_d73 0
XM34 audit_d73 b5_b rbit5top dvdd pfet_03v3 L=0.28u W=7.5u nf=1 ad='int((nf+1)/2) * W/nf * 0.18u' as='int((nf+2)/2) * W/nf * 0.18u' pd='2*int((nf+1)/2) * (W/nf + 0.18u)' ps='2*int((nf+2)/2) * (W/nf + 0.18u)' nrd='0.18u / W' nrs='0.18u / W' sa=0 sb=0 sd=0
VAUD74 rbit5top audit_d74 0
XM35 audit_d74 b5 rbit6top dvss nfet_03v3 L=0.28u W=2.5u nf=1 ad='int((nf+1)/2) * W/nf * 0.18u' as='int((nf+2)/2) * W/nf * 0.18u' pd='2*int((nf+1)/2) * (W/nf + 0.18u)' ps='2*int((nf+2)/2) * (W/nf + 0.18u)' nrd='0.18u / W' nrs='0.18u / W' sa=0 sb=0 sd=0
VAUD75 vq3 audit_d75 0
XM36 audit_d75 b6_b rbit6top dvdd pfet_03v3 L=0.28u W=3.75u nf=1 ad='int((nf+1)/2) * W/nf * 0.18u' as='int((nf+2)/2) * W/nf * 0.18u' pd='2*int((nf+1)/2) * (W/nf + 0.18u)' ps='2*int((nf+2)/2) * (W/nf + 0.18u)' nrd='0.18u / W' nrs='0.18u / W' sa=0 sb=0 sd=0
VAUD76 rbit6top audit_d76 0
XM37 audit_d76 b6 vq3 dvss nfet_03v3 L=0.28u W=1.25u nf=1 ad='int((nf+1)/2) * W/nf * 0.18u' as='int((nf+2)/2) * W/nf * 0.18u' pd='2*int((nf+1)/2) * (W/nf + 0.18u)' ps='2*int((nf+2)/2) * (W/nf + 0.18u)' nrd='0.18u / W' nrs='0.18u / W' sa=0 sb=0 sd=0
VAUD77 b0_b audit_d77 0
XM38 audit_d77 b0 dvss dvss nfet_03v3 L=0.5u W=1u nf=1 ad='int((nf+1)/2) * W/nf * 0.18u' as='int((nf+2)/2) * W/nf * 0.18u' pd='2*int((nf+1)/2) * (W/nf + 0.18u)' ps='2*int((nf+2)/2) * (W/nf + 0.18u)' nrd='0.18u / W' nrs='0.18u / W' sa=0 sb=0 sd=0
VAUD78 b0_b audit_d78 0
XM39 audit_d78 b0 dvdd dvdd pfet_03v3 L=0.5u W=3u nf=1 ad='int((nf+1)/2) * W/nf * 0.18u' as='int((nf+2)/2) * W/nf * 0.18u' pd='2*int((nf+1)/2) * (W/nf + 0.18u)' ps='2*int((nf+2)/2) * (W/nf + 0.18u)' nrd='0.18u / W' nrs='0.18u / W' sa=0 sb=0 sd=0
VAUD79 b1_b audit_d79 0
XM40 audit_d79 b1 dvss dvss nfet_03v3 L=0.5u W=1u nf=1 ad='int((nf+1)/2) * W/nf * 0.18u' as='int((nf+2)/2) * W/nf * 0.18u' pd='2*int((nf+1)/2) * (W/nf + 0.18u)' ps='2*int((nf+2)/2) * (W/nf + 0.18u)' nrd='0.18u / W' nrs='0.18u / W' sa=0 sb=0 sd=0
VAUD80 b1_b audit_d80 0
XM41 audit_d80 b1 dvdd dvdd pfet_03v3 L=0.5u W=3u nf=1 ad='int((nf+1)/2) * W/nf * 0.18u' as='int((nf+2)/2) * W/nf * 0.18u' pd='2*int((nf+1)/2) * (W/nf + 0.18u)' ps='2*int((nf+2)/2) * (W/nf + 0.18u)' nrd='0.18u / W' nrs='0.18u / W' sa=0 sb=0 sd=0
VAUD81 b2_b audit_d81 0
XM42 audit_d81 b2 dvss dvss nfet_03v3 L=0.5u W=1u nf=1 ad='int((nf+1)/2) * W/nf * 0.18u' as='int((nf+2)/2) * W/nf * 0.18u' pd='2*int((nf+1)/2) * (W/nf + 0.18u)' ps='2*int((nf+2)/2) * (W/nf + 0.18u)' nrd='0.18u / W' nrs='0.18u / W' sa=0 sb=0 sd=0
VAUD82 b2_b audit_d82 0
XM43 audit_d82 b2 dvdd dvdd pfet_03v3 L=0.5u W=3u nf=1 ad='int((nf+1)/2) * W/nf * 0.18u' as='int((nf+2)/2) * W/nf * 0.18u' pd='2*int((nf+1)/2) * (W/nf + 0.18u)' ps='2*int((nf+2)/2) * (W/nf + 0.18u)' nrd='0.18u / W' nrs='0.18u / W' sa=0 sb=0 sd=0
VAUD83 b3_b audit_d83 0
XM44 audit_d83 b3 dvss dvss nfet_03v3 L=0.5u W=1u nf=1 ad='int((nf+1)/2) * W/nf * 0.18u' as='int((nf+2)/2) * W/nf * 0.18u' pd='2*int((nf+1)/2) * (W/nf + 0.18u)' ps='2*int((nf+2)/2) * (W/nf + 0.18u)' nrd='0.18u / W' nrs='0.18u / W' sa=0 sb=0 sd=0
VAUD84 b3_b audit_d84 0
XM45 audit_d84 b3 dvdd dvdd pfet_03v3 L=0.5u W=3u nf=1 ad='int((nf+1)/2) * W/nf * 0.18u' as='int((nf+2)/2) * W/nf * 0.18u' pd='2*int((nf+1)/2) * (W/nf + 0.18u)' ps='2*int((nf+2)/2) * (W/nf + 0.18u)' nrd='0.18u / W' nrs='0.18u / W' sa=0 sb=0 sd=0
VAUD85 b4_b audit_d85 0
XM46 audit_d85 b4 dvss dvss nfet_03v3 L=0.5u W=1u nf=1 ad='int((nf+1)/2) * W/nf * 0.18u' as='int((nf+2)/2) * W/nf * 0.18u' pd='2*int((nf+1)/2) * (W/nf + 0.18u)' ps='2*int((nf+2)/2) * (W/nf + 0.18u)' nrd='0.18u / W' nrs='0.18u / W' sa=0 sb=0 sd=0
VAUD86 b4_b audit_d86 0
XM47 audit_d86 b4 dvdd dvdd pfet_03v3 L=0.5u W=3u nf=1 ad='int((nf+1)/2) * W/nf * 0.18u' as='int((nf+2)/2) * W/nf * 0.18u' pd='2*int((nf+1)/2) * (W/nf + 0.18u)' ps='2*int((nf+2)/2) * (W/nf + 0.18u)' nrd='0.18u / W' nrs='0.18u / W' sa=0 sb=0 sd=0
VAUD87 b5_b audit_d87 0
XM48 audit_d87 b5 dvss dvss nfet_03v3 L=0.5u W=1u nf=1 ad='int((nf+1)/2) * W/nf * 0.18u' as='int((nf+2)/2) * W/nf * 0.18u' pd='2*int((nf+1)/2) * (W/nf + 0.18u)' ps='2*int((nf+2)/2) * (W/nf + 0.18u)' nrd='0.18u / W' nrs='0.18u / W' sa=0 sb=0 sd=0
VAUD88 b5_b audit_d88 0
XM49 audit_d88 b5 dvdd dvdd pfet_03v3 L=0.5u W=3u nf=1 ad='int((nf+1)/2) * W/nf * 0.18u' as='int((nf+2)/2) * W/nf * 0.18u' pd='2*int((nf+1)/2) * (W/nf + 0.18u)' ps='2*int((nf+2)/2) * (W/nf + 0.18u)' nrd='0.18u / W' nrs='0.18u / W' sa=0 sb=0 sd=0
VAUD89 b6_b audit_d89 0
XM50 audit_d89 b6 dvss dvss nfet_03v3 L=0.5u W=1u nf=1 ad='int((nf+1)/2) * W/nf * 0.18u' as='int((nf+2)/2) * W/nf * 0.18u' pd='2*int((nf+1)/2) * (W/nf + 0.18u)' ps='2*int((nf+2)/2) * (W/nf + 0.18u)' nrd='0.18u / W' nrs='0.18u / W' sa=0 sb=0 sd=0
VAUD90 b6_b audit_d90 0
XM51 audit_d90 b6 dvdd dvdd pfet_03v3 L=0.5u W=3u nf=1 ad='int((nf+1)/2) * W/nf * 0.18u' as='int((nf+2)/2) * W/nf * 0.18u' pd='2*int((nf+1)/2) * (W/nf + 0.18u)' ps='2*int((nf+2)/2) * (W/nf + 0.18u)' nrd='0.18u / W' nrs='0.18u / W' sa=0 sb=0 sd=0
VAUD91 avdd audit_d91 0
XDUM_M1 audit_d91 avdd avdd avdd pfet_05v0 W=16.75u L=2u m=22
VAUD92 avdd audit_d92 0
XDUM_M11 audit_d92 avdd avdd avdd pfet_05v0 W=16.42u L=4u m=34
VAUD93 avdd audit_d93 0
XDUM_MINP audit_d93 avdd avdd avdd pfet_05v0 W=54.89u L=4u m=29
VAUD94 avdd audit_d94 0
XDUM_PCAS1 audit_d94 avdd avdd avdd pfet_05v0 W=22.21u L=8u m=20
VAUD95 avdd audit_d95 0
XDUM_PLOAD1 audit_d95 avdd avdd avdd pfet_05v0 W=20.76u L=4u m=20
VAUD96 avdd audit_d96 0
XDUM_PREF audit_d96 avdd avdd avdd pfet_05v0 W=18.75u L=8u m=29
VAUD97 avdd audit_d97 0
XDUM_MPSINK audit_d97 avdd avdd avdd pfet_05v0 W=18.95u L=8u m=23
VAUD98 avdd audit_d98 0
XDUM_MPFOLD audit_d98 avdd avdd avdd pfet_05v0 W=18.99u L=8u m=20
VAUD99 avss audit_d99 0
XDUM_MSINK1 audit_d99 avss avss avss nfet_05v0 W=16.34u L=8u m=20
VAUD100 avss audit_d100 0
XDUM_M3 audit_d100 avss avss avss nfet_05v0 W=14.6u L=4u m=14
VAUD101 avss audit_d101 0
XDUM_MFOLD1 audit_d101 avss avss avss nfet_05v0 W=18.49u L=6u m=10
VAUD102 avss audit_d102 0
XDUM_M16 audit_d102 avss avss avss nfet_05v0 W=7.55u L=4u m=10
VAUD103 avss audit_d103 0
XDUM_VBNSINK audit_d103 avss avss avss nfet_05v0 W=12.31u L=8u m=10
.ends Bandgap_Core_Res
