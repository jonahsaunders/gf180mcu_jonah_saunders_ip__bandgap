* Diagnostic DC mirror currents; ideal series drain probes only.

.include /foss/pdks/gf180mcuD/libs.tech/ngspice/design.ngspice
.lib /foss/pdks/gf180mcuD/libs.tech/ngspice/sm141064.ngspice typical
.lib /foss/pdks/gf180mcuD/libs.tech/ngspice/sm141064.ngspice bjt_typical
.lib /foss/pdks/gf180mcuD/libs.tech/ngspice/sm141064.ngspice res_typical
* GF180 2p0fF MIM fit, charge-form ngspice compatibility implementation.
* Derived from GlobalFoundries PDK Authors (2022), Apache-2.0:
* https://github.com/google/globalfoundries-pdk-libs-gf180mcu_fd_pr
* Same geometry, voltage/temperature coefficients, leakage and corner factors.
* Differential C(V)=C0*(1+a*V+b*V^2) is implemented as
* Q(V)=C0*(V+a*V^2/2+b*V^3/3), so dQ/dV exactly equals C(V).
* This avoids ngspice's poorly scaled unity-capacitor C-expression expansion.
* Do not also include mimcap_typical: it would redefine cap_mim_2f0fF.
.param mim_corner_2p0fF=1 mc_c_cox_2p0fF=0
.subckt cap_mim_2f0fF  1 2  c_length=l  c_width=w dtemp=0 par=1
.param gleak='9.51e-10/5*10000'
.param c_cox='1.99e-3*mim_corner_2p0fF'
.param c_capsw='2.383e-10*mim_corner_2p0fF'
.param c_vcr1='0+(c_width>5u||c_length>5u)*8.742e-6+(c_width<=5u||c_length<=5u)*(-81e-6)'
.param c_vcr2='0+(c_width>5u||c_length>5u)*9.188e-6+(c_width<=5u||c_length<=5u)*(16.7e-6)'

.param c_tnom=25
.param c_tc1=1.46e-5
.param c_tc2=-5.55e-8
.param c_AREA='c_length*c_width'
.param c_PERI='2*(c_length+c_width)'

.param c_c0='(c_cox*c_AREA+c_capsw*c_PERI)*(1+c_tc1*(temper +dtemp -c_tnom)+c_tc2*(temper+dtemp-c_tnom)*(temper+dtemp-c_tnom))'
*
c_cap 1 2 Q='c_c0*(v(1,2)+c_vcr1*v(1,2)*v(1,2)/2+c_vcr2*v(1,2)*v(1,2)*v(1,2)/3)*(1+mc_c_cox_2p0fF)'
r_leak 1 2 r='1/(gleak*c_AREA)' tc1=c_tc1 tc2=c_tc2 dtemp=dtemp
.ends cap_mim_2f0fF
* Bootstrap nominal process; runner selects each corner independently. Mismatch disabled. MIM compatibility model above is intentional.
.options tnom=25 numdgt=15 method=gear maxord=2 reltol=1e-5 vntol=1e-7 abstol=1e-13 itl4=200
.param sw_stat_global=0 sw_stat_mismatch=0 fnoicor=0
.param VDD_RUN=5
.temp 25

.options klu num_threads=1
.include diagnostic.spice
XDUT avdd 0 vref b0 b1 b2 b3 b4 b5 b6 0 dvdd Bandgap_Core_Res
VDD avdd 0 5.0
VDVDD dvdd 0 3.3
VB0 b0 0 0
VB1 b1 0 0
VB2 b2 0 0
VB3 b3 0 3.3
VB4 b4 0 0
VB5 b5 0 0
VB6 b6 0 3.3
.control
set noaskquit
set numdgt=15
op
print v(vref) i(vdd)
echo DEVICE 0
let aid=i(v.xdut.vaud0)
let avd=v(xdut.audit_d0)
let avg=v(xdut.b0.t2)
let avs=v(xdut.rbit1top.t8)
let avb=0
print aid avd avg avs avb
echo DEVICE 1
let aid=i(v.xdut.vaud1)
let avd=v(xdut.audit_d1)
let avg=v(xdut.avdd.t742)
let avs=v(xdut.avdd.t744)
let avb=v(xdut.avdd.t743)
print aid avd avg avs avb
echo DEVICE 2
let aid=i(v.xdut.vaud2)
let avd=v(xdut.audit_d2)
let avg=0
let avs=0
let avb=0
print aid avd avg avs avb
echo DEVICE 3
let aid=i(v.xdut.vaud3)
let avd=v(xdut.audit_d3)
let avg=0
let avs=0
let avb=0
print aid avd avg avs avb
echo DEVICE 4
let aid=i(v.xdut.vaud4)
let avd=v(xdut.audit_d4)
let avg=v(xdut.avdd.t391)
let avs=v(xdut.avdd.t393)
let avb=v(xdut.avdd.t392)
print aid avd avg avs avb
echo DEVICE 5
let aid=i(v.xdut.vaud5)
let avd=v(xdut.audit_d5)
let avg=v(xdut.vbp_i.t32)
let avs=v(xdut.avdd.t61)
let avb=v(xdut.avdd.t60)
print aid avd avg avs avb
echo DEVICE 6
let aid=i(v.xdut.vaud6)
let avd=v(xdut.audit_d6)
let avg=v(xdut.vbp_i.t24)
let avs=v(xdut.avdd.t69)
let avb=v(xdut.avdd.t68)
print aid avd avg avs avb
echo DEVICE 7
let aid=i(v.xdut.vaud7)
let avd=v(xdut.audit_d7)
let avg=v(xdut.avdd.t447)
let avs=v(xdut.avdd.t449)
let avb=v(xdut.avdd.t448)
print aid avd avg avs avb
echo DEVICE 8
let aid=i(v.xdut.vaud8)
let avd=v(xdut.audit_d8)
let avg=v(xdut.avdd.t471)
let avs=v(xdut.avdd.t473)
let avb=v(xdut.avdd.t472)
print aid avd avg avs avb
echo DEVICE 9
let aid=i(v.xdut.vaud9)
let avd=v(xdut.audit_d9)
let avg=v(xdut.vbp_i.t33)
let avs=v(xdut.avdd.t63)
let avb=v(xdut.avdd.t62)
print aid avd avg avs avb
echo DEVICE 10
let aid=i(v.xdut.vaud10)
let avd=v(xdut.audit_d10)
let avg=v(xdut.avdd.t275)
let avs=v(xdut.avdd.t277)
let avb=v(xdut.avdd.t276)
print aid avd avg avs avb
echo DEVICE 11
let aid=i(v.xdut.vaud11)
let avd=v(xdut.audit_d11)
let avg=v(xdut.vbp_i.t47)
let avs=v(xdut.avdd.t892)
let avb=v(xdut.avdd.t891)
print aid avd avg avs avb
echo DEVICE 12
let aid=i(v.xdut.vaud12)
let avd=v(xdut.audit_d12)
let avg=v(xdut.b3.t0)
let avs=v(xdut.dvdd.t27)
let avb=v(xdut.dvdd.t26)
print aid avd avg avs avb
echo DEVICE 13
let aid=i(v.xdut.vaud13)
let avd=v(xdut.audit_d13)
let avg=v(xdut.psrg_m3_feed.t13)
let avs=v(xdut.avdd.t1048)
let avb=v(xdut.avdd.t1047)
print aid avd avg avs avb
echo DEVICE 14
let aid=i(v.xdut.vaud14)
let avd=v(xdut.audit_d14)
let avg=v(xdut.b2_b.t3)
let avs=v(xdut.rbit2top.t4)
let avb=v(xdut.dvdd.t23)
print aid avd avg avs avb
echo DEVICE 15
let aid=i(v.xdut.vaud15)
let avd=v(xdut.audit_d15)
let avg=v(xdut.y1.t13)
let avs=v(xdut.avdd.t948)
let avb=v(xdut.avdd.t947)
print aid avd avg avs avb
echo DEVICE 16
let aid=i(v.xdut.vaud16)
let avd=v(xdut.audit_d16)
let avg=v(xdut.vbn.t0)
let avs=0
let avb=0
print aid avd avg avs avb
echo DEVICE 17
let aid=i(v.xdut.vaud17)
let avd=v(xdut.audit_d17)
let avg=v(xdut.avdd.t207)
let avs=v(xdut.avdd.t209)
let avb=v(xdut.avdd.t208)
print aid avd avg avs avb
echo DEVICE 18
let aid=i(v.xdut.vaud18)
let avd=v(xdut.audit_d18)
let avg=v(xdut.avdd.t295)
let avs=v(xdut.avdd.t297)
let avb=v(xdut.avdd.t296)
print aid avd avg avs avb
echo DEVICE 19
let aid=i(v.xdut.vaud19)
let avd=v(xdut.audit_d19)
let avg=v(xdut.vbn_fold.t14)
let avs=v(xdut.xf2.t0)
let avb=0
print aid avd avg avs avb
echo DEVICE 20
let aid=i(v.xdut.vaud20)
let avd=v(xdut.audit_d20)
let avg=v(xdut.vbn_i.t11)
let avs=0
let avb=0
print aid avd avg avs avb
echo DEVICE 21
let aid=i(v.xdut.vaud21)
let avd=v(xdut.audit_d21)
let avg=v(xdut.vbp_i.t52)
let avs=v(xdut.avdd.t894)
let avb=v(xdut.avdd.t893)
print aid avd avg avs avb
echo DEVICE 22
let aid=i(v.xdut.vaud22)
let avd=v(xdut.audit_d22)
let avg=v(xdut.avdd.t439)
let avs=v(xdut.avdd.t441)
let avb=v(xdut.avdd.t440)
print aid avd avg avs avb
echo DEVICE 23
let aid=i(v.xdut.vaud23)
let avd=v(xdut.audit_d23)
let avg=v(xdut.vbp_cas.t32)
let avs=v(xdut.pm2.t2)
let avb=v(xdut.avdd.t966)
print aid avd avg avs avb
echo DEVICE 24
let aid=i(v.xdut.vaud24)
let avd=v(xdut.audit_d24)
let avg=v(xdut.avdd.t623)
let avs=v(xdut.avdd.t625)
let avb=v(xdut.avdd.t624)
print aid avd avg avs avb
echo DEVICE 25
let aid=i(v.xdut.vaud25)
let avd=v(xdut.audit_d25)
let avg=v(xdut.avdd.t858)
let avs=v(xdut.avdd.t860)
let avb=v(xdut.avdd.t859)
print aid avd avg avs avb
echo DEVICE 26
let aid=i(v.xdut.vaud26)
let avd=v(xdut.audit_d26)
let avg=v(xdut.avdd.t635)
let avs=v(xdut.avdd.t637)
let avb=v(xdut.avdd.t636)
print aid avd avg avs avb
echo DEVICE 27
let aid=i(v.xdut.vaud27)
let avd=v(xdut.audit_d27)
let avg=v(xdut.avdd.t203)
let avs=v(xdut.avdd.t205)
let avb=v(xdut.avdd.t204)
print aid avd avg avs avb
echo DEVICE 28
let aid=i(v.xdut.vaud28)
let avd=v(xdut.audit_d28)
let avg=v(xdut.avdd.t291)
let avs=v(xdut.avdd.t293)
let avb=v(xdut.avdd.t292)
print aid avd avg avs avb
echo DEVICE 29
let aid=i(v.xdut.vaud29)
let avd=v(xdut.audit_d29)
let avg=v(xdut.avdd.t511)
let avs=v(xdut.avdd.t513)
let avb=v(xdut.avdd.t512)
print aid avd avg avs avb
echo DEVICE 30
let aid=i(v.xdut.vaud30)
let avd=v(xdut.audit_d30)
let avg=v(xdut.vbn_fold.t12)
let avs=v(xdut.vnx_bias)
let avb=0
print aid avd avg avs avb
echo DEVICE 31
let aid=i(v.xdut.vaud31)
let avd=v(xdut.audit_d31)
let avg=v(xdut.vbn_sink.t23)
let avs=0
let avb=0
print aid avd avg avs avb
echo DEVICE 32
let aid=i(v.xdut.vaud32)
let avd=v(xdut.audit_d32)
let avg=v(xdut.aux_gate)
let avs=v(xdut.psrg_m3_feed.t7)
let avb=v(xdut.avdd.t1013)
print aid avd avg avs avb
echo DEVICE 33
let aid=i(v.xdut.vaud33)
let avd=v(xdut.audit_d33)
let avg=v(xdut.b5_b.t2)
let avs=v(xdut.rbit5top.t2)
let avb=v(xdut.dvdd.t5)
print aid avd avg avs avb
echo DEVICE 34
let aid=i(v.xdut.vaud34)
let avd=v(xdut.audit_d34)
let avg=v(xdut.avdd.t754)
let avs=v(xdut.avdd.t756)
let avb=v(xdut.avdd.t755)
print aid avd avg avs avb
echo DEVICE 35
let aid=i(v.xdut.vaud35)
let avd=v(xdut.audit_d35)
let avg=v(xdut.avdd.t103)
let avs=v(xdut.avdd.t105)
let avb=v(xdut.avdd.t104)
print aid avd avg avs avb
echo DEVICE 36
let aid=i(v.xdut.vaud36)
let avd=v(xdut.audit_d36)
let avg=0
let avs=0
let avb=0
print aid avd avg avs avb
echo DEVICE 37
let aid=i(v.xdut.vaud37)
let avd=v(xdut.audit_d37)
let avg=v(xdut.psrg_m3_feed.t26)
let avs=v(xdut.avdd.t896)
let avb=v(xdut.avdd.t895)
print aid avd avg avs avb
echo DEVICE 38
let aid=i(v.xdut.vaud38)
let avd=v(xdut.audit_d38)
let avg=v(xdut.avdd.t818)
let avs=v(xdut.avdd.t820)
let avb=v(xdut.avdd.t819)
print aid avd avg avs avb
echo DEVICE 39
let aid=i(v.xdut.vaud39)
let avd=v(xdut.audit_d39)
let avg=v(xdut.avdd.t547)
let avs=v(xdut.avdd.t549)
let avb=v(xdut.avdd.t548)
print aid avd avg avs avb
echo DEVICE 40
let aid=i(v.xdut.vaud40)
let avd=v(xdut.audit_d40)
let avg=v(xdut.avdd.t99)
let avs=v(xdut.avdd.t101)
let avb=v(xdut.avdd.t100)
print aid avd avg avs avb
echo DEVICE 41
let aid=i(v.xdut.vaud41)
let avd=v(xdut.audit_d41)
let avg=v(xdut.avdd.t451)
let avs=v(xdut.avdd.t453)
let avb=v(xdut.avdd.t452)
print aid avd avg avs avb
echo DEVICE 42
let aid=i(v.xdut.vaud42)
let avd=v(xdut.audit_d42)
let avg=v(xdut.psrg_m3_feed.t28)
let avs=v(xdut.avdd.t900)
let avb=v(xdut.avdd.t899)
print aid avd avg avs avb
echo DEVICE 43
let aid=i(v.xdut.vaud43)
let avd=v(xdut.audit_d43)
let avg=v(xdut.aux_gate)
let avs=v(xdut.avdd.t1012)
let avb=v(xdut.avdd.t1011)
print aid avd avg avs avb
echo DEVICE 44
let aid=i(v.xdut.vaud44)
let avd=v(xdut.audit_d44)
let avg=v(xdut.avdd.t706)
let avs=v(xdut.avdd.t708)
let avb=v(xdut.avdd.t707)
print aid avd avg avs avb
echo DEVICE 45
let aid=i(v.xdut.vaud45)
let avd=v(xdut.audit_d45)
let avg=v(xdut.avdd.t503)
let avs=v(xdut.avdd.t505)
let avb=v(xdut.avdd.t504)
print aid avd avg avs avb
echo DEVICE 46
let aid=i(v.xdut.vaud46)
let avd=v(xdut.audit_d46)
let avg=v(xdut.avdd.t215)
let avs=v(xdut.avdd.t217)
let avb=v(xdut.avdd.t216)
print aid avd avg avs avb
echo DEVICE 47
let aid=i(v.xdut.vaud47)
let avd=v(xdut.audit_d47)
let avg=v(xdut.avdd.t850)
let avs=v(xdut.avdd.t852)
let avb=v(xdut.avdd.t851)
print aid avd avg avs avb
echo DEVICE 48
let aid=i(v.xdut.vaud48)
let avd=v(xdut.audit_d48)
let avg=v(xdut.vcasp)
let avs=v(xdut.vx3.t5)
let avb=v(xdut.avdd.t995)
print aid avd avg avs avb
echo DEVICE 49
let aid=i(v.xdut.vaud49)
let avd=v(xdut.audit_d49)
let avg=v(xdut.avdd.t403)
let avs=v(xdut.avdd.t405)
let avb=v(xdut.avdd.t404)
print aid avd avg avs avb
echo DEVICE 50
let aid=i(v.xdut.vaud50)
let avd=v(xdut.audit_d50)
let avg=v(xdut.psrg_vnc.t7)
let avs=v(xdut.rb_mid)
let avb=0
print aid avd avg avs avb
echo DEVICE 51
let aid=i(v.xdut.vaud51)
let avd=v(xdut.audit_d51)
let avg=v(xdut.avdd.t710)
let avs=v(xdut.avdd.t712)
let avb=v(xdut.avdd.t711)
print aid avd avg avs avb
echo DEVICE 52
let aid=i(v.xdut.vaud52)
let avd=v(xdut.audit_d52)
let avg=v(xdut.psrg_m3_feed.t18)
let avs=v(xdut.avdd.t3)
let avb=v(xdut.avdd.t2)
print aid avd avg avs avb
echo DEVICE 53
let aid=i(v.xdut.vaud53)
let avd=v(xdut.audit_d53)
let avg=v(xdut.avdd.t111)
let avs=v(xdut.avdd.t113)
let avb=v(xdut.avdd.t112)
print aid avd avg avs avb
echo DEVICE 54
let aid=i(v.xdut.vaud54)
let avd=v(xdut.audit_d54)
let avg=v(xdut.avdd.t687)
let avs=v(xdut.avdd.t689)
let avb=v(xdut.avdd.t688)
print aid avd avg avs avb
echo DEVICE 55
let aid=i(v.xdut.vaud55)
let avd=v(xdut.audit_d55)
let avg=v(xdut.y1.t9)
let avs=v(xdut.avdd.t928)
let avb=v(xdut.avdd.t927)
print aid avd avg avs avb
echo DEVICE 56
let aid=i(v.xdut.vaud56)
let avd=v(xdut.audit_d56)
let avg=v(xdut.avdd.t591)
let avs=v(xdut.avdd.t593)
let avb=v(xdut.avdd.t592)
print aid avd avg avs avb
echo DEVICE 57
let aid=i(v.xdut.vaud57)
let avd=v(xdut.audit_d57)
let avg=v(xdut.avdd.t271)
let avs=v(xdut.avdd.t273)
let avb=v(xdut.avdd.t272)
print aid avd avg avs avb
echo DEVICE 58
let aid=i(v.xdut.vaud58)
let avd=v(xdut.audit_d58)
let avg=v(xdut.avdd.t319)
let avs=v(xdut.avdd.t321)
let avb=v(xdut.avdd.t320)
print aid avd avg avs avb
echo DEVICE 59
let aid=i(v.xdut.vaud59)
let avd=v(xdut.audit_d59)
let avg=v(xdut.avdd.t355)
let avs=v(xdut.avdd.t357)
let avb=v(xdut.avdd.t356)
print aid avd avg avs avb
echo DEVICE 60
let aid=i(v.xdut.vaud60)
let avd=v(xdut.audit_d60)
let avg=v(xdut.avdd.t607)
let avs=v(xdut.avdd.t609)
let avb=v(xdut.avdd.t608)
print aid avd avg avs avb
echo DEVICE 61
let aid=i(v.xdut.vaud61)
let avd=v(xdut.audit_d61)
let avg=v(xdut.vcasp)
let avs=v(xdut.vx2.t6)
let avb=v(xdut.avdd.t992)
print aid avd avg avs avb
echo DEVICE 62
let aid=i(v.xdut.vaud62)
let avd=v(xdut.audit_d62)
let avg=v(xdut.y1.t12)
let avs=v(xdut.avdd.t946)
let avb=v(xdut.avdd.t945)
print aid avd avg avs avb
echo DEVICE 63
let aid=i(v.xdut.vaud63)
let avd=v(xdut.audit_d63)
let avg=v(xdut.psrg_m3_feed.t25)
let avs=v(xdut.avdd.t888)
let avb=v(xdut.avdd.t887)
print aid avd avg avs avb
echo DEVICE 64
let aid=i(v.xdut.vaud64)
let avd=v(xdut.audit_d64)
let avg=v(xdut.avdd.t535)
let avs=v(xdut.avdd.t537)
let avb=v(xdut.avdd.t536)
print aid avd avg avs avb
echo DEVICE 65
let aid=i(v.xdut.vaud65)
let avd=v(xdut.audit_d65)
let avg=v(xdut.avdd.t267)
let avs=v(xdut.avdd.t269)
let avb=v(xdut.avdd.t268)
print aid avd avg avs avb
echo DEVICE 66
let aid=i(v.xdut.vaud66)
let avd=v(xdut.audit_d66)
let avg=v(xdut.avdd.t315)
let avs=v(xdut.avdd.t317)
let avb=v(xdut.avdd.t316)
print aid avd avg avs avb
echo DEVICE 67
let aid=i(v.xdut.vaud67)
let avd=v(xdut.audit_d67)
let avg=v(xdut.avdd.t351)
let avs=v(xdut.avdd.t353)
let avb=v(xdut.avdd.t352)
print aid avd avg avs avb
echo DEVICE 68
let aid=i(v.xdut.vaud68)
let avd=v(xdut.audit_d68)
let avg=v(xdut.b2.t0)
let avs=v(xdut.dvdd.t9)
let avb=v(xdut.dvdd.t8)
print aid avd avg avs avb
echo DEVICE 69
let aid=i(v.xdut.vaud69)
let avd=v(xdut.audit_d69)
let avg=v(xdut.avdd.t627)
let avs=v(xdut.avdd.t629)
let avb=v(xdut.avdd.t628)
print aid avd avg avs avb
echo DEVICE 70
let aid=i(v.xdut.vaud70)
let avd=v(xdut.audit_d70)
let avg=v(xdut.avdd.t667)
let avs=v(xdut.avdd.t669)
let avb=v(xdut.avdd.t668)
print aid avd avg avs avb
echo DEVICE 71
let aid=i(v.xdut.vaud71)
let avd=v(xdut.audit_d71)
let avg=v(xdut.vbp_cas.t26)
let avs=v(xdut.pm1.t0)
let avb=v(xdut.avdd.t953)
print aid avd avg avs avb
echo DEVICE 72
let aid=i(v.xdut.vaud72)
let avd=v(xdut.audit_d72)
let avg=v(xdut.avdd.t830)
let avs=v(xdut.avdd.t832)
let avb=v(xdut.avdd.t831)
print aid avd avg avs avb
echo DEVICE 73
let aid=i(v.xdut.vaud73)
let avd=v(xdut.audit_d73)
let avg=0
let avs=0
let avb=0
print aid avd avg avs avb
echo DEVICE 74
let aid=i(v.xdut.vaud74)
let avd=v(xdut.audit_d74)
let avg=v(xdut.b5.t0)
let avs=v(xdut.dvdd.t1)
let avb=v(xdut.dvdd.t0)
print aid avd avg avs avb
echo DEVICE 75
let aid=i(v.xdut.vaud75)
let avd=v(xdut.audit_d75)
let avg=0
let avs=0
let avb=0
print aid avd avg avs avb
echo DEVICE 76
let aid=i(v.xdut.vaud76)
let avd=v(xdut.audit_d76)
let avg=v(xdut.avdd.t491)
let avs=v(xdut.avdd.t493)
let avb=v(xdut.avdd.t492)
print aid avd avg avs avb
echo DEVICE 77
let aid=i(v.xdut.vaud77)
let avd=v(xdut.audit_d77)
let avg=v(xdut.vbp_i.t9)
let avs=v(xdut.avdd.t1033)
let avb=v(xdut.avdd.t1032)
print aid avd avg avs avb
echo DEVICE 78
let aid=i(v.xdut.vaud78)
let avd=v(xdut.audit_d78)
let avg=v(xdut.vbp_bias.t10)
let avs=v(xdut.avdd.t9)
let avb=v(xdut.avdd.t8)
print aid avd avg avs avb
echo DEVICE 79
let aid=i(v.xdut.vaud79)
let avd=v(xdut.audit_d79)
let avg=v(xdut.avdd.t199)
let avs=v(xdut.avdd.t201)
let avb=v(xdut.avdd.t200)
print aid avd avg avs avb
echo DEVICE 80
let aid=i(v.xdut.vaud80)
let avd=v(xdut.audit_d80)
let avg=v(xdut.avdd.t774)
let avs=v(xdut.avdd.t776)
let avb=v(xdut.avdd.t775)
print aid avd avg avs avb
echo DEVICE 81
let aid=i(v.xdut.vaud81)
let avd=v(xdut.audit_d81)
let avg=v(xdut.vbp_bias.t26)
let avs=v(xdut.avdd.t912)
let avb=v(xdut.avdd.t911)
print aid avd avg avs avb
echo DEVICE 82
let aid=i(v.xdut.vaud82)
let avd=v(xdut.audit_d82)
let avg=v(xdut.vbn_sink.t24)
let avs=0
let avb=0
print aid avd avg avs avb
echo DEVICE 83
let aid=i(v.xdut.vaud83)
let avd=v(xdut.audit_d83)
let avg=v(xdut.vbp_i.t28)
let avs=v(xdut.avdd.t19)
let avb=v(xdut.avdd.t18)
print aid avd avg avs avb
echo DEVICE 84
let aid=i(v.xdut.vaud84)
let avd=v(xdut.audit_d84)
let avg=v(xdut.vbp_i.t41)
let avs=v(xdut.avdd.t13)
let avb=v(xdut.avdd.t12)
print aid avd avg avs avb
echo DEVICE 85
let aid=i(v.xdut.vaud85)
let avd=v(xdut.audit_d85)
let avg=v(xdut.b0_b.t3)
let avs=v(xdut.rbit0top.t2)
let avb=v(xdut.dvdd.t15)
print aid avd avg avs avb
echo DEVICE 86
let aid=i(v.xdut.vaud86)
let avd=v(xdut.audit_d86)
let avg=v(xdut.avdd.t862)
let avs=v(xdut.avdd.t864)
let avb=v(xdut.avdd.t863)
print aid avd avg avs avb
echo DEVICE 87
let aid=i(v.xdut.vaud87)
let avd=v(xdut.audit_d87)
let avg=v(xdut.iref_gate.t3)
let avs=v(xdut.avdd.t932)
let avb=v(xdut.avdd.t931)
print aid avd avg avs avb
echo DEVICE 88
let aid=i(v.xdut.vaud88)
let avd=v(xdut.audit_d88)
let avg=v(xdut.avdd.t307)
let avs=v(xdut.avdd.t309)
let avb=v(xdut.avdd.t308)
print aid avd avg avs avb
echo DEVICE 89
let aid=i(v.xdut.vaud89)
let avd=v(xdut.audit_d89)
let avg=v(xdut.avdd.t343)
let avs=v(xdut.avdd.t345)
let avb=v(xdut.avdd.t344)
print aid avd avg avs avb
echo DEVICE 90
let aid=i(v.xdut.vaud90)
let avd=v(xdut.audit_d90)
let avg=v(xdut.avdd.t95)
let avs=v(xdut.avdd.t97)
let avb=v(xdut.avdd.t96)
print aid avd avg avs avb
echo DEVICE 91
let aid=i(v.xdut.vaud91)
let avd=v(xdut.audit_d91)
let avg=v(xdut.vbp_i.t21)
let avs=v(xdut.vsu1)
let avb=0
print aid avd avg avs avb
echo DEVICE 92
let aid=i(v.xdut.vaud92)
let avd=v(xdut.audit_d92)
let avg=v(xdut.vbp_cas.t29)
let avs=v(xdut.pm2.t1)
let avb=v(xdut.avdd.t956)
print aid avd avg avs avb
echo DEVICE 93
let aid=i(v.xdut.vaud93)
let avd=v(xdut.audit_d93)
let avg=v(xdut.vbp_i.t51)
let avs=v(xdut.avdd.t59)
let avb=v(xdut.avdd.t58)
print aid avd avg avs avb
echo DEVICE 94
let aid=i(v.xdut.vaud94)
let avd=v(xdut.audit_d94)
let avg=v(xdut.vbp_tail.t12)
let avs=v(xdut.avdd.t916)
let avb=v(xdut.avdd.t915)
print aid avd avg avs avb
echo DEVICE 95
let aid=i(v.xdut.vaud95)
let avd=v(xdut.audit_d95)
let avg=v(xdut.avdd.t603)
let avs=v(xdut.avdd.t605)
let avb=v(xdut.avdd.t604)
print aid avd avg avs avb
echo DEVICE 96
let aid=i(v.xdut.vaud96)
let avd=v(xdut.audit_d96)
let avg=v(xdut.b3_b.t2)
let avs=v(xdut.rbit3top.t1)
let avb=v(xdut.dvdd.t2)
print aid avd avg avs avb
echo DEVICE 97
let aid=i(v.xdut.vaud97)
let avd=v(xdut.audit_d97)
let avg=v(xdut.avdd.t435)
let avs=v(xdut.avdd.t437)
let avb=v(xdut.avdd.t436)
print aid avd avg avs avb
echo DEVICE 98
let aid=i(v.xdut.vaud98)
let avd=v(xdut.audit_d98)
let avg=v(xdut.vsu)
let avs=v(xdut.avdd.t88)
let avb=v(xdut.avdd.t87)
print aid avd avg avs avb
echo DEVICE 99
let aid=i(v.xdut.vaud99)
let avd=v(xdut.audit_d99)
let avg=v(xdut.vbn_sink.t27)
let avs=0
let avb=0
print aid avd avg avs avb
echo DEVICE 100
let aid=i(v.xdut.vaud100)
let avd=v(xdut.audit_d100)
let avg=v(xdut.avdd.t191)
let avs=v(xdut.avdd.t193)
let avb=v(xdut.avdd.t192)
print aid avd avg avs avb
echo DEVICE 101
let aid=i(v.xdut.vaud101)
let avd=v(xdut.audit_d101)
let avg=v(xdut.b4_b.t2)
let avs=v(xdut.rbit4top.t0)
let avb=v(xdut.dvdd.t4)
print aid avd avg avs avb
echo DEVICE 102
let aid=i(v.xdut.vaud102)
let avd=v(xdut.audit_d102)
let avg=v(xdut.avdd.t379)
let avs=v(xdut.avdd.t381)
let avb=v(xdut.avdd.t380)
print aid avd avg avs avb
echo DEVICE 103
let aid=i(v.xdut.vaud103)
let avd=v(xdut.audit_d103)
let avg=v(xdut.vbp_i.t54)
let avs=v(xdut.avdd.t77)
let avb=v(xdut.avdd.t76)
print aid avd avg avs avb
echo DEVICE 104
let aid=i(v.xdut.vaud104)
let avd=v(xdut.audit_d104)
let avg=v(xdut.vbn_sink.t28)
let avs=0
let avb=0
print aid avd avg avs avb
echo DEVICE 105
let aid=i(v.xdut.vaud105)
let avd=v(xdut.audit_d105)
let avg=v(xdut.avdd.t878)
let avs=v(xdut.avdd.t880)
let avb=v(xdut.avdd.t879)
print aid avd avg avs avb
echo DEVICE 106
let aid=i(v.xdut.vaud106)
let avd=v(xdut.audit_d106)
let avg=v(xdut.avdd.t615)
let avs=v(xdut.avdd.t617)
let avb=v(xdut.avdd.t616)
print aid avd avg avs avb
echo DEVICE 107
let aid=i(v.xdut.vaud107)
let avd=v(xdut.audit_d107)
let avg=v(xdut.v1.t3)
let avs=v(xdut.vsp.t11)
let avb=v(xdut.avdd.t1028)
print aid avd avg avs avb
echo DEVICE 108
let aid=i(v.xdut.vaud108)
let avd=v(xdut.audit_d108)
let avg=v(xdut.b1_b.t4)
let avs=v(xdut.rbit1top.t12)
let avb=v(xdut.dvdd.t12)
print aid avd avg avs avb
echo DEVICE 109
let aid=i(v.xdut.vaud109)
let avd=v(xdut.audit_d109)
let avg=v(xdut.psrg_vnc.t10)
let avs=v(xdut.psrg_m3_protected.t2)
let avb=0
print aid avd avg avs avb
echo DEVICE 110
let aid=i(v.xdut.vaud110)
let avd=v(xdut.audit_d110)
let avg=v(xdut.avdd.t375)
let avs=v(xdut.avdd.t377)
let avb=v(xdut.avdd.t376)
print aid avd avg avs avb
echo DEVICE 111
let aid=i(v.xdut.vaud111)
let avd=v(xdut.audit_d111)
let avg=v(xdut.b4.t2)
let avs=v(xdut.rbit5top.t3)
let avb=0
print aid avd avg avs avb
echo DEVICE 112
let aid=i(v.xdut.vaud112)
let avd=v(xdut.audit_d112)
let avg=v(xdut.avdd.t167)
let avs=v(xdut.avdd.t169)
let avb=v(xdut.avdd.t168)
print aid avd avg avs avb
echo DEVICE 113
let aid=i(v.xdut.vaud113)
let avd=v(xdut.audit_d113)
let avg=v(xdut.vbn_sink.t17)
let avs=0
let avb=0
print aid avd avg avs avb
echo DEVICE 114
let aid=i(v.xdut.vaud114)
let avd=v(xdut.audit_d114)
let avg=v(xdut.avdd.t519)
let avs=v(xdut.avdd.t521)
let avb=v(xdut.avdd.t520)
print aid avd avg avs avb
echo DEVICE 115
let aid=i(v.xdut.vaud115)
let avd=v(xdut.audit_d115)
let avg=v(xdut.avdd.t423)
let avs=v(xdut.avdd.t425)
let avb=v(xdut.avdd.t424)
print aid avd avg avs avb
echo DEVICE 116
let aid=i(v.xdut.vaud116)
let avd=v(xdut.audit_d116)
let avg=v(xdut.vbp_tail.t2)
let avs=v(xdut.avdd.t920)
let avb=v(xdut.avdd.t919)
print aid avd avg avs avb
echo DEVICE 117
let aid=i(v.xdut.vaud117)
let avd=v(xdut.audit_d117)
let avg=v(xdut.avdd.t539)
let avs=v(xdut.avdd.t541)
let avb=v(xdut.avdd.t540)
print aid avd avg avs avb
echo DEVICE 118
let aid=i(v.xdut.vaud118)
let avd=v(xdut.audit_d118)
let avg=v(xdut.avdd.t714)
let avs=v(xdut.avdd.t716)
let avb=v(xdut.avdd.t715)
print aid avd avg avs avb
echo DEVICE 119
let aid=i(v.xdut.vaud119)
let avd=v(xdut.audit_d119)
let avg=v(xdut.vbp_cas.t16)
let avs=v(xdut.vbp_bias.t4)
let avb=v(xdut.avdd.t974)
print aid avd avg avs avb
echo DEVICE 120
let aid=i(v.xdut.vaud120)
let avd=v(xdut.audit_d120)
let avg=v(xdut.y1.t18)
let avs=v(xdut.avdd.t963)
let avb=v(xdut.avdd.t962)
print aid avd avg avs avb
echo DEVICE 121
let aid=i(v.xdut.vaud121)
let avd=v(xdut.audit_d121)
let avg=v(xdut.avdd.t455)
let avs=v(xdut.avdd.t457)
let avb=v(xdut.avdd.t456)
print aid avd avg avs avb
echo DEVICE 122
let aid=i(v.xdut.vaud122)
let avd=v(xdut.audit_d122)
let avg=v(xdut.v2.t5)
let avs=v(xdut.vsp.t1)
let avb=v(xdut.avdd.t65)
print aid avd avg avs avb
echo DEVICE 123
let aid=i(v.xdut.vaud123)
let avd=v(xdut.audit_d123)
let avg=v(xdut.psrg_m3_feed.t27)
let avs=v(xdut.avdd.t898)
let avb=v(xdut.avdd.t897)
print aid avd avg avs avb
echo DEVICE 124
let aid=i(v.xdut.vaud124)
let avd=v(xdut.audit_d124)
let avg=v(xdut.avdd.t822)
let avs=v(xdut.avdd.t824)
let avb=v(xdut.avdd.t823)
print aid avd avg avs avb
echo DEVICE 125
let aid=i(v.xdut.vaud125)
let avd=v(xdut.audit_d125)
let avg=v(xdut.vbp_tail.t13)
let avs=v(xdut.avdd.t92)
let avb=v(xdut.avdd.t91)
print aid avd avg avs avb
echo DEVICE 126
let aid=i(v.xdut.vaud126)
let avd=v(xdut.audit_d126)
let avg=v(xdut.avdd.t703)
let avs=v(xdut.avdd.t705)
let avb=v(xdut.avdd.t704)
print aid avd avg avs avb
echo DEVICE 127
let aid=i(v.xdut.vaud127)
let avd=v(xdut.audit_d127)
let avg=v(xdut.avdd.t387)
let avs=v(xdut.avdd.t389)
let avb=v(xdut.avdd.t388)
print aid avd avg avs avb
echo DEVICE 128
let aid=i(v.xdut.vaud128)
let avd=v(xdut.audit_d128)
let avg=v(xdut.avdd.t870)
let avs=v(xdut.avdd.t872)
let avb=v(xdut.avdd.t871)
print aid avd avg avs avb
echo DEVICE 129
let aid=i(v.xdut.vaud129)
let avd=v(xdut.audit_d129)
let avg=v(xdut.avdd.t347)
let avs=v(xdut.avdd.t349)
let avb=v(xdut.avdd.t348)
print aid avd avg avs avb
echo DEVICE 130
let aid=i(v.xdut.vaud130)
let avd=v(xdut.audit_d130)
let avg=v(xdut.y1.t11)
let avs=v(xdut.avdd.t976)
let avb=v(xdut.avdd.t975)
print aid avd avg avs avb
echo DEVICE 131
let aid=i(v.xdut.vaud131)
let avd=v(xdut.audit_d131)
let avg=v(xdut.avdd.t551)
let avs=v(xdut.avdd.t553)
let avb=v(xdut.avdd.t552)
print aid avd avg avs avb
echo DEVICE 132
let aid=i(v.xdut.vaud132)
let avd=v(xdut.audit_d132)
let avg=v(xdut.avdd.t599)
let avs=v(xdut.avdd.t601)
let avb=v(xdut.avdd.t600)
print aid avd avg avs avb
echo DEVICE 133
let aid=i(v.xdut.vaud133)
let avd=v(xdut.audit_d133)
let avg=v(xdut.vbp_i.t18)
let avs=v(xdut.avdd.t15)
let avb=v(xdut.avdd.t14)
print aid avd avg avs avb
echo DEVICE 134
let aid=i(v.xdut.vaud134)
let avd=v(xdut.audit_d134)
let avg=v(xdut.avdd.t243)
let avs=v(xdut.avdd.t245)
let avb=v(xdut.avdd.t244)
print aid avd avg avs avb
echo DEVICE 135
let aid=i(v.xdut.vaud135)
let avd=v(xdut.audit_d135)
let avg=v(xdut.avdd.t367)
let avs=v(xdut.avdd.t369)
let avb=v(xdut.avdd.t368)
print aid avd avg avs avb
echo DEVICE 136
let aid=i(v.xdut.vaud136)
let avd=v(xdut.audit_d136)
let avg=v(xdut.vbn_sink.t31)
let avs=0
let avb=0
print aid avd avg avs avb
echo DEVICE 137
let aid=i(v.xdut.vaud137)
let avd=v(xdut.audit_d137)
let avg=v(xdut.vbp_i.t23)
let avs=v(xdut.avdd.t49)
let avb=v(xdut.avdd.t48)
print aid avd avg avs avb
echo DEVICE 138
let aid=i(v.xdut.vaud138)
let avd=v(xdut.audit_d138)
let avg=v(xdut.vcasp)
let avs=v(xdut.avdd.t1010)
let avb=v(xdut.avdd.t1009)
print aid avd avg avs avb
echo DEVICE 139
let aid=i(v.xdut.vaud139)
let avd=v(xdut.audit_d139)
let avg=v(xdut.avdd.t195)
let avs=v(xdut.avdd.t197)
let avb=v(xdut.avdd.t196)
print aid avd avg avs avb
echo DEVICE 140
let aid=i(v.xdut.vaud140)
let avd=v(xdut.audit_d140)
let avg=v(xdut.psrg_m3_feed.t17)
let avs=v(xdut.avdd.t1)
let avb=v(xdut.avdd.t0)
print aid avd avg avs avb
echo DEVICE 141
let aid=i(v.xdut.vaud141)
let avd=v(xdut.audit_d141)
let avg=v(xdut.vbp_bias.t12)
let avs=v(xdut.avdd.t1022)
let avb=v(xdut.avdd.t1021)
print aid avd avg avs avb
echo DEVICE 142
let aid=i(v.xdut.vaud142)
let avd=v(xdut.audit_d142)
let avg=v(xdut.avdd.t611)
let avs=v(xdut.avdd.t613)
let avb=v(xdut.avdd.t612)
print aid avd avg avs avb
echo DEVICE 143
let aid=i(v.xdut.vaud143)
let avd=v(xdut.audit_d143)
let avg=v(xdut.avdd.t575)
let avs=v(xdut.avdd.t577)
let avb=v(xdut.avdd.t576)
print aid avd avg avs avb
echo DEVICE 144
let aid=i(v.xdut.vaud144)
let avd=v(xdut.audit_d144)
let avg=v(xdut.avdd.t415)
let avs=v(xdut.avdd.t417)
let avb=v(xdut.avdd.t416)
print aid avd avg avs avb
echo DEVICE 145
let aid=i(v.xdut.vaud145)
let avd=v(xdut.audit_d145)
let avg=v(xdut.vbp_i.t46)
let avs=v(xdut.avdd.t890)
let avb=v(xdut.avdd.t889)
print aid avd avg avs avb
echo DEVICE 146
let aid=i(v.xdut.vaud146)
let avd=v(xdut.audit_d146)
let avg=v(xdut.y1.t14)
let avs=v(xdut.avdd.t950)
let avb=v(xdut.avdd.t949)
print aid avd avg avs avb
echo DEVICE 147
let aid=i(v.xdut.vaud147)
let avd=v(xdut.audit_d147)
let avg=v(xdut.vcasp)
let avs=v(xdut.vx3.t6)
let avb=v(xdut.avdd.t997)
print aid avd avg avs avb
echo DEVICE 148
let aid=i(v.xdut.vaud148)
let avd=v(xdut.audit_d148)
let avg=v(xdut.avdd.t139)
let avs=v(xdut.avdd.t141)
let avb=v(xdut.avdd.t140)
print aid avd avg avs avb
echo DEVICE 149
let aid=i(v.xdut.vaud149)
let avd=v(xdut.audit_d149)
let avg=v(xdut.vbp_cas.t23)
let avs=v(xdut.pm1.t11)
let avb=v(xdut.avdd.t978)
print aid avd avg avs avb
echo DEVICE 150
let aid=i(v.xdut.vaud150)
let avd=v(xdut.audit_d150)
let avg=v(xdut.avdd.t303)
let avs=v(xdut.avdd.t305)
let avb=v(xdut.avdd.t304)
print aid avd avg avs avb
echo DEVICE 151
let aid=i(v.xdut.vaud151)
let avd=v(xdut.audit_d151)
let avg=v(xdut.vbp_i.t20)
let avs=0
let avb=0
print aid avd avg avs avb
echo DEVICE 152
let aid=i(v.xdut.vaud152)
let avd=v(xdut.audit_d152)
let avg=v(xdut.vbp_i.t35)
let avs=v(xdut.avdd.t938)
let avb=v(xdut.avdd.t937)
print aid avd avg avs avb
echo DEVICE 153
let aid=i(v.xdut.vaud153)
let avd=v(xdut.audit_d153)
let avg=v(xdut.avdd.t810)
let avs=v(xdut.avdd.t812)
let avb=v(xdut.avdd.t811)
print aid avd avg avs avb
echo DEVICE 154
let aid=i(v.xdut.vaud154)
let avd=v(xdut.audit_d154)
let avg=v(xdut.avdd.t842)
let avs=v(xdut.avdd.t844)
let avb=v(xdut.avdd.t843)
print aid avd avg avs avb
echo DEVICE 155
let aid=i(v.xdut.vaud155)
let avd=v(xdut.audit_d155)
let avg=v(xdut.psrg_m3_feed.t24)
let avs=v(xdut.avdd.t886)
let avb=v(xdut.avdd.t885)
print aid avd avg avs avb
echo DEVICE 156
let aid=i(v.xdut.vaud156)
let avd=v(xdut.audit_d156)
let avg=v(xdut.avdd.t507)
let avs=v(xdut.avdd.t509)
let avb=v(xdut.avdd.t508)
print aid avd avg avs avb
echo DEVICE 157
let aid=i(v.xdut.vaud157)
let avd=v(xdut.audit_d157)
let avg=v(xdut.avdd.t299)
let avs=v(xdut.avdd.t301)
let avb=v(xdut.avdd.t300)
print aid avd avg avs avb
echo DEVICE 158
let aid=i(v.xdut.vaud158)
let avd=v(xdut.audit_d158)
let avg=v(xdut.vbp_tail.t9)
let avs=v(xdut.avdd.t988)
let avb=v(xdut.avdd.t987)
print aid avd avg avs avb
echo DEVICE 159
let aid=i(v.xdut.vaud159)
let avd=v(xdut.audit_d159)
let avg=v(xdut.avdd.t790)
let avs=v(xdut.avdd.t792)
let avb=v(xdut.avdd.t791)
print aid avd avg avs avb
echo DEVICE 160
let aid=i(v.xdut.vaud160)
let avd=v(xdut.audit_d160)
let avg=v(xdut.vbp_i.t25)
let avs=v(xdut.avdd.t71)
let avb=v(xdut.avdd.t70)
print aid avd avg avs avb
echo DEVICE 161
let aid=i(v.xdut.vaud161)
let avd=v(xdut.audit_d161)
let avg=v(xdut.v1.t5)
let avs=v(xdut.vsp.t9)
let avb=v(xdut.avdd.t1026)
print aid avd avg avs avb
echo DEVICE 162
let aid=i(v.xdut.vaud162)
let avd=v(xdut.audit_d162)
let avg=v(xdut.avdd.t834)
let avs=v(xdut.avdd.t836)
let avb=v(xdut.avdd.t835)
print aid avd avg avs avb
echo DEVICE 163
let aid=i(v.xdut.vaud163)
let avd=v(xdut.audit_d163)
let avg=v(xdut.avdd.t183)
let avs=v(xdut.avdd.t185)
let avb=v(xdut.avdd.t184)
print aid avd avg avs avb
echo DEVICE 164
let aid=i(v.xdut.vaud164)
let avd=v(xdut.audit_d164)
let avg=v(xdut.avdd.t499)
let avs=v(xdut.avdd.t501)
let avb=v(xdut.avdd.t500)
print aid avd avg avs avb
echo DEVICE 165
let aid=i(v.xdut.vaud165)
let avd=v(xdut.audit_d165)
let avg=v(xdut.vbp_i.t48)
let avs=v(xdut.avdd.t75)
let avb=v(xdut.avdd.t74)
print aid avd avg avs avb
echo DEVICE 166
let aid=i(v.xdut.vaud166)
let avd=v(xdut.audit_d166)
let avg=v(xdut.vbp_cas.t12)
let avs=v(xdut.vbp_bias.t9)
let avb=v(xdut.avdd.t968)
print aid avd avg avs avb
echo DEVICE 167
let aid=i(v.xdut.vaud167)
let avd=v(xdut.audit_d167)
let avg=v(xdut.vbp_i.t5)
let avs=v(xdut.avdd.t934)
let avb=v(xdut.avdd.t933)
print aid avd avg avs avb
echo DEVICE 168
let aid=i(v.xdut.vaud168)
let avd=v(xdut.audit_d168)
let avg=v(xdut.vbn_sink.t15)
let avs=0
let avb=0
print aid avd avg avs avb
echo DEVICE 169
let aid=i(v.xdut.vaud169)
let avd=v(xdut.audit_d169)
let avg=v(xdut.vbp_i.t45)
let avs=v(xdut.avdd.t86)
let avb=v(xdut.avdd.t85)
print aid avd avg avs avb
echo DEVICE 170
let aid=i(v.xdut.vaud170)
let avd=v(xdut.audit_d170)
let avg=v(xdut.vcasp)
let avs=v(xdut.vx2.t9)
let avb=v(xdut.avdd.t1001)
print aid avd avg avs avb
echo DEVICE 171
let aid=i(v.xdut.vaud171)
let avd=v(xdut.audit_d171)
let avg=v(xdut.vcasp)
let avs=v(xdut.vx2.t7)
let avb=v(xdut.avdd.t994)
print aid avd avg avs avb
echo DEVICE 172
let aid=i(v.xdut.vaud172)
let avd=v(xdut.audit_d172)
let avg=v(xdut.vbp_i.t15)
let avs=v(xdut.avdd.t45)
let avb=v(xdut.avdd.t44)
print aid avd avg avs avb
echo DEVICE 173
let aid=i(v.xdut.vaud173)
let avd=v(xdut.audit_d173)
let avg=v(xdut.vbp_tail.t11)
let avs=v(xdut.avdd.t914)
let avb=v(xdut.avdd.t913)
print aid avd avg avs avb
echo DEVICE 174
let aid=i(v.xdut.vaud174)
let avd=v(xdut.audit_d174)
let avg=v(xdut.avdd.t251)
let avs=v(xdut.avdd.t253)
let avb=v(xdut.avdd.t252)
print aid avd avg avs avb
echo DEVICE 175
let aid=i(v.xdut.vaud175)
let avd=v(xdut.audit_d175)
let avg=v(xdut.avdd.t595)
let avs=v(xdut.avdd.t597)
let avb=v(xdut.avdd.t596)
print aid avd avg avs avb
echo DEVICE 176
let aid=i(v.xdut.vaud176)
let avd=v(xdut.audit_d176)
let avg=v(xdut.vbp_tail.t0)
let avs=v(xdut.avdd.t1037)
let avb=v(xdut.avdd.t1036)
print aid avd avg avs avb
echo DEVICE 177
let aid=i(v.xdut.vaud177)
let avd=v(xdut.audit_d177)
let avg=v(xdut.vbp_bias.t16)
let avs=v(xdut.avdd.t82)
let avb=v(xdut.avdd.t81)
print aid avd avg avs avb
echo DEVICE 178
let aid=i(v.xdut.vaud178)
let avd=v(xdut.audit_d178)
let avg=v(xdut.avdd.t718)
let avs=v(xdut.avdd.t720)
let avb=v(xdut.avdd.t719)
print aid avd avg avs avb
echo DEVICE 179
let aid=i(v.xdut.vaud179)
let avd=v(xdut.audit_d179)
let avg=v(xdut.vbp_cas.t10)
let avs=v(xdut.vbp_bias.t8)
let avb=v(xdut.avdd.t967)
print aid avd avg avs avb
echo DEVICE 180
let aid=i(v.xdut.vaud180)
let avd=v(xdut.audit_d180)
let avg=v(xdut.vcasp)
let avs=v(xdut.vx2.t10)
let avb=v(xdut.avdd.t1004)
print aid avd avg avs avb
echo DEVICE 181
let aid=i(v.xdut.vaud181)
let avd=v(xdut.audit_d181)
let avg=v(xdut.avdd.t655)
let avs=v(xdut.avdd.t657)
let avb=v(xdut.avdd.t656)
print aid avd avg avs avb
echo DEVICE 182
let aid=i(v.xdut.vaud182)
let avd=v(xdut.audit_d182)
let avg=v(xdut.vbp_cas.t14)
let avs=v(xdut.vbp_bias.t7)
let avb=v(xdut.avdd.t973)
print aid avd avg avs avb
echo DEVICE 183
let aid=i(v.xdut.vaud183)
let avd=v(xdut.audit_d183)
let avg=v(xdut.vbp_cas.t4)
let avs=v(xdut.vbp_bias.t0)
let avb=v(xdut.avdd.t972)
print aid avd avg avs avb
echo DEVICE 184
let aid=i(v.xdut.vaud184)
let avd=v(xdut.audit_d184)
let avg=v(xdut.avdd.t239)
let avs=v(xdut.avdd.t241)
let avb=v(xdut.avdd.t240)
print aid avd avg avs avb
echo DEVICE 185
let aid=i(v.xdut.vaud185)
let avd=v(xdut.audit_d185)
let avg=v(xdut.avdd.t363)
let avs=v(xdut.avdd.t365)
let avb=v(xdut.avdd.t364)
print aid avd avg avs avb
echo DEVICE 186
let aid=i(v.xdut.vaud186)
let avd=v(xdut.audit_d186)
let avg=v(xdut.vbn_sink.t32)
let avs=0
let avb=0
print aid avd avg avs avb
echo DEVICE 187
let aid=i(v.xdut.vaud187)
let avd=v(xdut.audit_d187)
let avg=v(xdut.avdd.t515)
let avs=v(xdut.avdd.t517)
let avb=v(xdut.avdd.t516)
print aid avd avg avs avb
echo DEVICE 188
let aid=i(v.xdut.vaud188)
let avd=v(xdut.audit_d188)
let avg=v(xdut.avdd.t419)
let avs=v(xdut.avdd.t421)
let avb=v(xdut.avdd.t420)
print aid avd avg avs avb
echo DEVICE 189
let aid=i(v.xdut.vaud189)
let avd=v(xdut.audit_d189)
let avg=v(xdut.avdd.t874)
let avs=v(xdut.avdd.t876)
let avb=v(xdut.avdd.t875)
print aid avd avg avs avb
echo DEVICE 190
let aid=i(v.xdut.vaud190)
let avd=v(xdut.audit_d190)
let avg=v(xdut.vbn_i.t1)
let avs=0
let avb=0
print aid avd avg avs avb
echo DEVICE 191
let aid=i(v.xdut.vaud191)
let avd=v(xdut.audit_d191)
let avg=v(xdut.vcasp)
let avs=v(xdut.vx2.t8)
let avb=v(xdut.avdd.t999)
print aid avd avg avs avb
echo DEVICE 192
let aid=i(v.xdut.vaud192)
let avd=v(xdut.audit_d192)
let avg=v(xdut.psrg_vnc.t9)
let avs=v(xdut.psrg_mf1_protected.t1)
let avb=0
print aid avd avg avs avb
echo DEVICE 193
let aid=i(v.xdut.vaud193)
let avd=v(xdut.audit_d193)
let avg=v(xdut.avdd.t555)
let avs=v(xdut.avdd.t557)
let avb=v(xdut.avdd.t556)
print aid avd avg avs avb
echo DEVICE 194
let aid=i(v.xdut.vaud194)
let avd=v(xdut.audit_d194)
let avg=v(xdut.avdd.t778)
let avs=v(xdut.avdd.t780)
let avb=v(xdut.avdd.t779)
print aid avd avg avs avb
echo DEVICE 195
let aid=i(v.xdut.vaud195)
let avd=v(xdut.audit_d195)
let avg=v(xdut.y1.t10)
let avs=v(xdut.avdd.t926)
let avb=v(xdut.avdd.t925)
print aid avd avg avs avb
echo DEVICE 196
let aid=i(v.xdut.vaud196)
let avd=v(xdut.audit_d196)
let avg=v(xdut.avdd.t802)
let avs=v(xdut.avdd.t804)
let avb=v(xdut.avdd.t803)
print aid avd avg avs avb
echo DEVICE 197
let aid=i(v.xdut.vaud197)
let avd=v(xdut.audit_d197)
let avg=v(xdut.avdd.t359)
let avs=v(xdut.avdd.t361)
let avb=v(xdut.avdd.t360)
print aid avd avg avs avb
echo DEVICE 198
let aid=i(v.xdut.vaud198)
let avd=v(xdut.audit_d198)
let avg=v(xdut.v2.t3)
let avs=v(xdut.vsp.t0)
let avb=v(xdut.avdd.t64)
print aid avd avg avs avb
echo DEVICE 199
let aid=i(v.xdut.vaud199)
let avd=v(xdut.audit_d199)
let avg=v(xdut.vbn_i.t10)
let avs=v(xdut.net4.t0)
let avb=0
print aid avd avg avs avb
echo DEVICE 200
let aid=i(v.xdut.vaud200)
let avd=v(xdut.audit_d200)
let avg=v(xdut.vbp_i.t17)
let avs=v(xdut.avdd.t942)
let avb=v(xdut.avdd.t941)
print aid avd avg avs avb
echo DEVICE 201
let aid=i(v.xdut.vaud201)
let avd=v(xdut.audit_d201)
let avg=v(xdut.avdd.t151)
let avs=v(xdut.avdd.t153)
let avb=v(xdut.avdd.t152)
print aid avd avg avs avb
echo DEVICE 202
let aid=i(v.xdut.vaud202)
let avd=v(xdut.audit_d202)
let avg=v(xdut.avdd.t135)
let avs=v(xdut.avdd.t137)
let avb=v(xdut.avdd.t136)
print aid avd avg avs avb
echo DEVICE 203
let aid=i(v.xdut.vaud203)
let avd=v(xdut.audit_d203)
let avg=v(xdut.b3.t2)
let avs=v(xdut.rbit4top.t5)
let avb=0
print aid avd avg avs avb
echo DEVICE 204
let aid=i(v.xdut.vaud204)
let avd=v(xdut.audit_d204)
let avg=v(xdut.avdd.t734)
let avs=v(xdut.avdd.t736)
let avb=v(xdut.avdd.t735)
print aid avd avg avs avb
echo DEVICE 205
let aid=i(v.xdut.vaud205)
let avd=v(xdut.audit_d205)
let avg=v(xdut.avdd.t487)
let avs=v(xdut.avdd.t489)
let avb=v(xdut.avdd.t488)
print aid avd avg avs avb
echo DEVICE 206
let aid=i(v.xdut.vaud206)
let avd=v(xdut.audit_d206)
let avg=v(xdut.avdd.t187)
let avs=v(xdut.avdd.t189)
let avb=v(xdut.avdd.t188)
print aid avd avg avs avb
echo DEVICE 207
let aid=i(v.xdut.vaud207)
let avd=v(xdut.audit_d207)
let avg=v(xdut.avdd.t147)
let avs=v(xdut.avdd.t149)
let avb=v(xdut.avdd.t148)
print aid avd avg avs avb
echo DEVICE 208
let aid=i(v.xdut.vaud208)
let avd=v(xdut.audit_d208)
let avg=v(xdut.avdd.t459)
let avs=v(xdut.avdd.t461)
let avb=v(xdut.avdd.t460)
print aid avd avg avs avb
echo DEVICE 209
let aid=i(v.xdut.vaud209)
let avd=v(xdut.audit_d209)
let avg=v(xdut.avdd.t579)
let avs=v(xdut.avdd.t581)
let avb=v(xdut.avdd.t580)
print aid avd avg avs avb
echo DEVICE 210
let aid=i(v.xdut.vaud210)
let avd=v(xdut.audit_d210)
let avg=v(xdut.vbn_i.t9)
let avs=0
let avb=0
print aid avd avg avs avb
echo DEVICE 211
let aid=i(v.xdut.vaud211)
let avd=v(xdut.audit_d211)
let avg=v(xdut.vbp_bias.t14)
let avs=v(xdut.avdd.t1024)
let avb=v(xdut.avdd.t1023)
print aid avd avg avs avb
echo DEVICE 212
let aid=i(v.xdut.vaud212)
let avd=v(xdut.audit_d212)
let avg=v(xdut.avdd.t722)
let avs=v(xdut.avdd.t724)
let avb=v(xdut.avdd.t723)
print aid avd avg avs avb
echo DEVICE 213
let aid=i(v.xdut.vaud213)
let avd=v(xdut.audit_d213)
let avg=v(xdut.avdd.t770)
let avs=v(xdut.avdd.t772)
let avb=v(xdut.avdd.t771)
print aid avd avg avs avb
echo DEVICE 214
let aid=i(v.xdut.vaud214)
let avd=v(xdut.audit_d214)
let avg=v(xdut.vsua)
let avs=v(xdut.auxsu1)
let avb=0
print aid avd avg avs avb
echo DEVICE 215
let aid=i(v.xdut.vaud215)
let avd=v(xdut.audit_d215)
let avg=v(xdut.avdd.t846)
let avs=v(xdut.avdd.t848)
let avb=v(xdut.avdd.t847)
print aid avd avg avs avb
echo DEVICE 216
let aid=i(v.xdut.vaud216)
let avd=v(xdut.audit_d216)
let avg=v(xdut.vbp_i.t26)
let avs=v(xdut.avdd.t55)
let avb=v(xdut.avdd.t54)
print aid avd avg avs avb
echo DEVICE 217
let aid=i(v.xdut.vaud217)
let avd=v(xdut.audit_d217)
let avg=v(xdut.avdd.t255)
let avs=v(xdut.avdd.t257)
let avb=v(xdut.avdd.t256)
print aid avd avg avs avb
echo DEVICE 218
let aid=i(v.xdut.vaud218)
let avd=v(xdut.audit_d218)
let avg=v(xdut.b0_b.t7)
let avs=v(xdut.rbit0top.t5)
let avb=v(xdut.dvdd.t19)
print aid avd avg avs avb
echo DEVICE 219
let aid=i(v.xdut.vaud219)
let avd=v(xdut.audit_d219)
let avg=v(xdut.b0_b.t4)
let avs=v(xdut.rbit0top.t6)
let avb=v(xdut.dvdd.t18)
print aid avd avg avs avb
echo DEVICE 220
let aid=i(v.xdut.vaud220)
let avd=v(xdut.audit_d220)
let avg=v(xdut.b3.t1)
let avs=0
let avb=0
print aid avd avg avs avb
echo DEVICE 221
let aid=i(v.xdut.vaud221)
let avd=v(xdut.audit_d221)
let avg=v(xdut.avdd.t227)
let avs=v(xdut.avdd.t229)
let avb=v(xdut.avdd.t228)
print aid avd avg avs avb
echo DEVICE 222
let aid=i(v.xdut.vaud222)
let avd=v(xdut.audit_d222)
let avg=v(xdut.vbp_i.t27)
let avs=v(xdut.avdd.t57)
let avb=v(xdut.avdd.t56)
print aid avd avg avs avb
echo DEVICE 223
let aid=i(v.xdut.vaud223)
let avd=v(xdut.audit_d223)
let avg=v(xdut.vbp_i.t40)
let avs=v(xdut.avdd.t11)
let avb=v(xdut.avdd.t10)
print aid avd avg avs avb
echo DEVICE 224
let aid=i(v.xdut.vaud224)
let avd=v(xdut.audit_d224)
let avg=v(xdut.vbp_i.t49)
let avs=v(xdut.avdd.t67)
let avb=v(xdut.avdd.t66)
print aid avd avg avs avb
echo DEVICE 225
let aid=i(v.xdut.vaud225)
let avd=v(xdut.audit_d225)
let avg=v(xdut.psrg_m3_feed.t10)
let avs=v(xdut.avdd.t94)
let avb=v(xdut.avdd.t93)
print aid avd avg avs avb
echo DEVICE 226
let aid=i(v.xdut.vaud226)
let avd=v(xdut.audit_d226)
let avg=v(xdut.b5.t2)
let avs=0
let avb=0
print aid avd avg avs avb
echo DEVICE 227
let aid=i(v.xdut.vaud227)
let avd=v(xdut.audit_d227)
let avg=v(xdut.vbp_i.t50)
let avs=v(xdut.avdd.t80)
let avb=v(xdut.avdd.t79)
print aid avd avg avs avb
echo DEVICE 228
let aid=i(v.xdut.vaud228)
let avd=v(xdut.audit_d228)
let avg=v(xdut.avdd.t123)
let avs=v(xdut.avdd.t125)
let avb=v(xdut.avdd.t124)
print aid avd avg avs avb
echo DEVICE 229
let aid=i(v.xdut.vaud229)
let avd=v(xdut.audit_d229)
let avg=v(xdut.vbp_i.t30)
let avs=v(xdut.avdd.t23)
let avb=v(xdut.avdd.t22)
print aid avd avg avs avb
echo DEVICE 230
let aid=i(v.xdut.vaud230)
let avd=v(xdut.audit_d230)
let avg=v(xdut.avdd.t798)
let avs=v(xdut.avdd.t800)
let avb=v(xdut.avdd.t799)
print aid avd avg avs avb
echo DEVICE 231
let aid=i(v.xdut.vaud231)
let avd=v(xdut.audit_d231)
let avg=v(xdut.vbp_i.t7)
let avs=v(xdut.avdd.t908)
let avb=v(xdut.avdd.t907)
print aid avd avg avs avb
echo DEVICE 232
let aid=i(v.xdut.vaud232)
let avd=v(xdut.audit_d232)
let avg=v(xdut.vbp_i.t39)
let avs=v(xdut.avdd.t35)
let avb=v(xdut.avdd.t34)
print aid avd avg avs avb
echo DEVICE 233
let aid=i(v.xdut.vaud233)
let avd=v(xdut.audit_d233)
let avg=v(xdut.avdd.t786)
let avs=v(xdut.avdd.t788)
let avb=v(xdut.avdd.t787)
print aid avd avg avs avb
echo DEVICE 234
let aid=i(v.xdut.vaud234)
let avd=v(xdut.audit_d234)
let avg=v(xdut.v2.t4)
let avs=v(xdut.vsp.t2)
let avb=v(xdut.avdd.t882)
print aid avd avg avs avb
echo DEVICE 235
let aid=i(v.xdut.vaud235)
let avd=v(xdut.audit_d235)
let avg=v(xdut.avdd.t647)
let avs=v(xdut.avdd.t649)
let avb=v(xdut.avdd.t648)
print aid avd avg avs avb
echo DEVICE 236
let aid=i(v.xdut.vaud236)
let avd=v(xdut.audit_d236)
let avg=v(xdut.b6.t0)
let avs=v(xdut.dvdd.t29)
let avb=v(xdut.dvdd.t28)
print aid avd avg avs avb
echo DEVICE 237
let aid=i(v.xdut.vaud237)
let avd=v(xdut.audit_d237)
let avg=v(xdut.vbn_fold.t15)
let avs=v(xdut.xf1.t0)
let avb=0
print aid avd avg avs avb
echo DEVICE 238
let aid=i(v.xdut.vaud238)
let avd=v(xdut.audit_d238)
let avg=v(xdut.y1.t8)
let avs=v(xdut.avdd.t922)
let avb=v(xdut.avdd.t921)
print aid avd avg avs avb
echo DEVICE 239
let aid=i(v.xdut.vaud239)
let avd=v(xdut.audit_d239)
let avg=v(xdut.bgsu1)
let avs=v(xdut.bgsu2)
let avb=0
print aid avd avg avs avb
echo DEVICE 240
let aid=i(v.xdut.vaud240)
let avd=v(xdut.audit_d240)
let avg=v(xdut.psrg_vnc.t11)
let avs=v(xdut.psrg_m3_protected.t3)
let avb=0
print aid avd avg avs avb
echo DEVICE 241
let aid=i(v.xdut.vaud241)
let avd=v(xdut.audit_d241)
let avg=v(xdut.psrg_m3_feed.t23)
let avs=v(xdut.avdd.t884)
let avb=v(xdut.avdd.t883)
print aid avd avg avs avb
echo DEVICE 242
let aid=i(v.xdut.vaud242)
let avd=v(xdut.audit_d242)
let avg=v(xdut.vcasp)
let avs=v(xdut.vx1.t9)
let avb=v(xdut.avdd.t1002)
print aid avd avg avs avb
echo DEVICE 243
let aid=i(v.xdut.vaud243)
let avd=v(xdut.audit_d243)
let avg=v(xdut.avdd.t814)
let avs=v(xdut.avdd.t816)
let avb=v(xdut.avdd.t815)
print aid avd avg avs avb
echo DEVICE 244
let aid=i(v.xdut.vaud244)
let avd=v(xdut.audit_d244)
let avg=v(xdut.vbp_bias.t18)
let avs=v(xdut.avdd.t904)
let avb=v(xdut.avdd.t903)
print aid avd avg avs avb
echo DEVICE 245
let aid=i(v.xdut.vaud245)
let avd=v(xdut.audit_d245)
let avg=v(xdut.avdd.t399)
let avs=v(xdut.avdd.t401)
let avb=v(xdut.avdd.t400)
print aid avd avg avs avb
echo DEVICE 246
let aid=i(v.xdut.vaud246)
let avd=v(xdut.audit_d246)
let avg=v(xdut.avdd.t323)
let avs=v(xdut.avdd.t325)
let avb=v(xdut.avdd.t324)
print aid avd avg avs avb
echo DEVICE 247
let aid=i(v.xdut.vaud247)
let avd=v(xdut.audit_d247)
let avg=v(xdut.vbp_i.t14)
let avs=v(xdut.avdd.t43)
let avb=v(xdut.avdd.t42)
print aid avd avg avs avb
echo DEVICE 248
let aid=i(v.xdut.vaud248)
let avd=v(xdut.audit_d248)
let avg=v(xdut.avdd.t175)
let avs=v(xdut.avdd.t177)
let avb=v(xdut.avdd.t176)
print aid avd avg avs avb
echo DEVICE 249
let aid=i(v.xdut.vaud249)
let avd=v(xdut.audit_d249)
let avg=v(xdut.vbp_i.t42)
let avs=v(xdut.avdd.t39)
let avb=v(xdut.avdd.t38)
print aid avd avg avs avb
echo DEVICE 250
let aid=i(v.xdut.vaud250)
let avd=v(xdut.audit_d250)
let avg=v(xdut.avdd.t563)
let avs=v(xdut.avdd.t565)
let avb=v(xdut.avdd.t564)
print aid avd avg avs avb
echo DEVICE 251
let aid=i(v.xdut.vaud251)
let avd=v(xdut.audit_d251)
let avg=v(xdut.b1.t2)
let avs=v(xdut.dvdd.t25)
let avb=v(xdut.dvdd.t24)
print aid avd avg avs avb
echo DEVICE 252
let aid=i(v.xdut.vaud252)
let avd=v(xdut.audit_d252)
let avg=v(xdut.vbp_i.t12)
let avs=v(xdut.avdd.t27)
let avb=v(xdut.avdd.t26)
print aid avd avg avs avb
echo DEVICE 253
let aid=i(v.xdut.vaud253)
let avd=v(xdut.audit_d253)
let avg=v(xdut.vbp_cas.t0)
let avs=v(xdut.vbp_bias.t6)
let avb=v(xdut.avdd.t1043)
print aid avd avg avs avb
echo DEVICE 254
let aid=i(v.xdut.vaud254)
let avd=v(xdut.audit_d254)
let avg=v(xdut.vgn1.t2)
let avs=v(xdut.v1.t0)
let avb=0
print aid avd avg avs avb
echo DEVICE 255
let aid=i(v.xdut.vaud255)
let avd=v(xdut.audit_d255)
let avg=v(xdut.avdd.t171)
let avs=v(xdut.avdd.t173)
let avb=v(xdut.avdd.t172)
print aid avd avg avs avb
echo DEVICE 256
let aid=i(v.xdut.vaud256)
let avd=v(xdut.audit_d256)
let avg=v(xdut.avdd.t663)
let avs=v(xdut.avdd.t665)
let avb=v(xdut.avdd.t664)
print aid avd avg avs avb
echo DEVICE 257
let aid=i(v.xdut.vaud257)
let avd=v(xdut.audit_d257)
let avg=v(xdut.b6_b.t2)
let avs=v(xdut.rbit6top.t4)
let avb=v(xdut.dvdd.t17)
print aid avd avg avs avb
echo DEVICE 258
let aid=i(v.xdut.vaud258)
let avd=v(xdut.audit_d258)
let avg=v(xdut.avdd.t583)
let avs=v(xdut.avdd.t585)
let avb=v(xdut.avdd.t584)
print aid avd avg avs avb
echo DEVICE 259
let aid=i(v.xdut.vaud259)
let avd=v(xdut.audit_d259)
let avg=v(xdut.vbp_cas.t18)
let avs=v(xdut.vbp_bias.t5)
let avb=v(xdut.avdd.t970)
print aid avd avg avs avb
echo DEVICE 260
let aid=i(v.xdut.vaud260)
let avd=v(xdut.audit_d260)
let avg=v(xdut.avdd.t383)
let avs=v(xdut.avdd.t385)
let avb=v(xdut.avdd.t384)
print aid avd avg avs avb
echo DEVICE 261
let aid=i(v.xdut.vaud261)
let avd=v(xdut.audit_d261)
let avg=v(xdut.b2_b.t4)
let avs=v(xdut.rbit2top.t3)
let avb=v(xdut.dvdd.t20)
print aid avd avg avs avb
echo DEVICE 262
let aid=i(v.xdut.vaud262)
let avd=v(xdut.audit_d262)
let avg=v(xdut.avdd.t587)
let avs=v(xdut.avdd.t589)
let avb=v(xdut.avdd.t588)
print aid avd avg avs avb
echo DEVICE 263
let aid=i(v.xdut.vaud263)
let avd=v(xdut.audit_d263)
let avg=v(xdut.vcasp)
let avs=v(xdut.vx3.t7)
let avb=v(xdut.avdd.t1000)
print aid avd avg avs avb
echo DEVICE 264
let aid=i(v.xdut.vaud264)
let avd=v(xdut.audit_d264)
let avg=v(xdut.vbp_cas.t2)
let avs=v(xdut.vbp_bias.t3)
let avb=v(xdut.avdd.t957)
print aid avd avg avs avb
echo DEVICE 265
let aid=i(v.xdut.vaud265)
let avd=v(xdut.audit_d265)
let avg=v(xdut.vbp_i.t16)
let avs=v(xdut.avdd.t940)
let avb=v(xdut.avdd.t939)
print aid avd avg avs avb
echo DEVICE 266
let aid=i(v.xdut.vaud266)
let avd=v(xdut.audit_d266)
let avg=v(xdut.vgn2.t8)
let avs=v(xdut.v2.t2)
let avb=0
print aid avd avg avs avb
echo DEVICE 267
let aid=i(v.xdut.vaud267)
let avd=v(xdut.audit_d267)
let avg=v(xdut.psrg_m3_feed.t11)
let avs=v(xdut.avdd.t31)
let avb=v(xdut.avdd.t30)
print aid avd avg avs avb
echo DEVICE 268
let aid=i(v.xdut.vaud268)
let avd=v(xdut.audit_d268)
let avg=v(xdut.vbn_sink.t29)
let avs=0
let avb=0
print aid avd avg avs avb
echo DEVICE 269
let aid=i(v.xdut.vaud269)
let avd=v(xdut.audit_d269)
let avg=v(xdut.psrg_m3_feed.t16)
let avs=v(xdut.avdd.t1019)
let avb=v(xdut.avdd.t1018)
print aid avd avg avs avb
echo DEVICE 270
let aid=i(v.xdut.vaud270)
let avd=v(xdut.audit_d270)
let avg=v(xdut.avdd.t738)
let avs=v(xdut.avdd.t740)
let avb=v(xdut.avdd.t739)
print aid avd avg avs avb
echo DEVICE 271
let aid=i(v.xdut.vaud271)
let avd=v(xdut.audit_d271)
let avg=v(xdut.avdd.t479)
let avs=v(xdut.avdd.t481)
let avb=v(xdut.avdd.t480)
print aid avd avg avs avb
echo DEVICE 272
let aid=i(v.xdut.vaud272)
let avd=v(xdut.audit_d272)
let avg=v(xdut.vgn2.t9)
let avs=v(xdut.v2.t1)
let avb=0
print aid avd avg avs avb
echo DEVICE 273
let aid=i(v.xdut.vaud273)
let avd=v(xdut.audit_d273)
let avg=v(xdut.vcasp)
let avs=v(xdut.vx1.t6)
let avb=v(xdut.avdd.t991)
print aid avd avg avs avb
echo DEVICE 274
let aid=i(v.xdut.vaud274)
let avd=v(xdut.audit_d274)
let avg=v(xdut.avdd.t163)
let avs=v(xdut.avdd.t165)
let avb=v(xdut.avdd.t164)
print aid avd avg avs avb
echo DEVICE 275
let aid=i(v.xdut.vaud275)
let avd=v(xdut.audit_d275)
let avg=v(xdut.avdd.t643)
let avs=v(xdut.avdd.t645)
let avb=v(xdut.avdd.t644)
print aid avd avg avs avb
echo DEVICE 276
let aid=i(v.xdut.vaud276)
let avd=v(xdut.audit_d276)
let avg=v(xdut.vcasp)
let avs=v(xdut.vx1.t10)
let avb=v(xdut.avdd.t1003)
print aid avd avg avs avb
echo DEVICE 277
let aid=i(v.xdut.vaud277)
let avd=v(xdut.audit_d277)
let avg=v(xdut.avdd.t531)
let avs=v(xdut.avdd.t533)
let avb=v(xdut.avdd.t532)
print aid avd avg avs avb
echo DEVICE 278
let aid=i(v.xdut.vaud278)
let avd=v(xdut.audit_d278)
let avg=v(xdut.avdd.t726)
let avs=v(xdut.avdd.t728)
let avb=v(xdut.avdd.t727)
print aid avd avg avs avb
echo DEVICE 279
let aid=i(v.xdut.vaud279)
let avd=v(xdut.audit_d279)
let avg=v(xdut.b2.t2)
let avs=v(xdut.rbit3top.t0)
let avb=0
print aid avd avg avs avb
echo DEVICE 280
let aid=i(v.xdut.vaud280)
let avd=v(xdut.audit_d280)
let avg=v(xdut.v1.t2)
let avs=v(xdut.vsp.t12)
let avb=v(xdut.avdd.t1029)
print aid avd avg avs avb
echo DEVICE 281
let aid=i(v.xdut.vaud281)
let avd=v(xdut.audit_d281)
let avg=v(xdut.avdd.t223)
let avs=v(xdut.avdd.t225)
let avb=v(xdut.avdd.t224)
print aid avd avg avs avb
echo DEVICE 282
let aid=i(v.xdut.vaud282)
let avd=v(xdut.audit_d282)
let avg=v(xdut.avdd.t331)
let avs=v(xdut.avdd.t333)
let avb=v(xdut.avdd.t332)
print aid avd avg avs avb
echo DEVICE 283
let aid=i(v.xdut.vaud283)
let avd=v(xdut.audit_d283)
let avg=v(xdut.psrg_m3_feed.t9)
let avs=v(xdut.avdd.t1031)
let avb=v(xdut.avdd.t1030)
print aid avd avg avs avb
echo DEVICE 284
let aid=i(v.xdut.vaud284)
let avd=v(xdut.audit_d284)
let avg=v(xdut.psrg_m3_feed.t8)
let avs=v(xdut.avdd.t902)
let avb=v(xdut.avdd.t901)
print aid avd avg avs avb
echo DEVICE 285
let aid=i(v.xdut.vaud285)
let avd=v(xdut.audit_d285)
let avg=v(xdut.avdd.t219)
let avs=v(xdut.avdd.t221)
let avb=v(xdut.avdd.t220)
print aid avd avg avs avb
echo DEVICE 286
let aid=i(v.xdut.vaud286)
let avd=v(xdut.audit_d286)
let avg=v(xdut.avdd.t327)
let avs=v(xdut.avdd.t329)
let avb=v(xdut.avdd.t328)
print aid avd avg avs avb
echo DEVICE 287
let aid=i(v.xdut.vaud287)
let avd=v(xdut.audit_d287)
let avg=v(xdut.b5.t1)
let avs=v(xdut.rbit6top.t1)
let avb=0
print aid avd avg avs avb
echo DEVICE 288
let aid=i(v.xdut.vaud288)
let avd=v(xdut.audit_d288)
let avg=v(xdut.avdd.t699)
let avs=v(xdut.avdd.t701)
let avb=v(xdut.avdd.t700)
print aid avd avg avs avb
echo DEVICE 289
let aid=i(v.xdut.vaud289)
let avd=v(xdut.audit_d289)
let avg=v(xdut.v2.t6)
let avs=v(xdut.vsp.t14)
let avb=v(xdut.avdd.t1040)
print aid avd avg avs avb
echo DEVICE 290
let aid=i(v.xdut.vaud290)
let avd=v(xdut.audit_d290)
let avg=v(xdut.avdd.t119)
let avs=v(xdut.avdd.t121)
let avb=v(xdut.avdd.t120)
print aid avd avg avs avb
echo DEVICE 291
let aid=i(v.xdut.vaud291)
let avd=v(xdut.audit_d291)
let avg=v(xdut.avdd.t651)
let avs=v(xdut.avdd.t653)
let avb=v(xdut.avdd.t652)
print aid avd avg avs avb
echo DEVICE 292
let aid=i(v.xdut.vaud292)
let avd=v(xdut.audit_d292)
let avg=v(xdut.vbp_bias.t22)
let avs=v(xdut.avdd.t7)
let avb=v(xdut.avdd.t6)
print aid avd avg avs avb
echo DEVICE 293
let aid=i(v.xdut.vaud293)
let avd=v(xdut.audit_d293)
let avg=v(xdut.vcasp)
let avs=v(xdut.vx1.t7)
let avb=v(xdut.avdd.t996)
print aid avd avg avs avb
echo DEVICE 294
let aid=i(v.xdut.vaud294)
let avd=v(xdut.audit_d294)
let avg=v(xdut.vbp_i.t53)
let avs=v(xdut.avdd.t1046)
let avb=v(xdut.avdd.t1045)
print aid avd avg avs avb
echo DEVICE 295
let aid=i(v.xdut.vaud295)
let avd=v(xdut.audit_d295)
let avg=v(xdut.avdd.t115)
let avs=v(xdut.avdd.t117)
let avb=v(xdut.avdd.t116)
print aid avd avg avs avb
echo DEVICE 296
let aid=i(v.xdut.vaud296)
let avd=v(xdut.audit_d296)
let avg=v(xdut.avdd.t495)
let avs=v(xdut.avdd.t497)
let avb=v(xdut.avdd.t496)
print aid avd avg avs avb
echo DEVICE 297
let aid=i(v.xdut.vaud297)
let avd=v(xdut.audit_d297)
let avg=v(xdut.vbp_i.t55)
let avs=v(xdut.avdd.t37)
let avb=v(xdut.avdd.t36)
print aid avd avg avs avb
echo DEVICE 298
let aid=i(v.xdut.vaud298)
let avd=v(xdut.audit_d298)
let avg=v(xdut.avdd.t279)
let avs=v(xdut.avdd.t281)
let avb=v(xdut.avdd.t280)
print aid avd avg avs avb
echo DEVICE 299
let aid=i(v.xdut.vaud299)
let avd=v(xdut.audit_d299)
let avg=v(xdut.avdd.t567)
let avs=v(xdut.avdd.t569)
let avb=v(xdut.avdd.t568)
print aid avd avg avs avb
echo DEVICE 300
let aid=i(v.xdut.vaud300)
let avd=v(xdut.audit_d300)
let avg=v(xdut.b4.t0)
let avs=v(xdut.dvdd.t7)
let avb=v(xdut.dvdd.t6)
print aid avd avg avs avb
echo DEVICE 301
let aid=i(v.xdut.vaud301)
let avd=v(xdut.audit_d301)
let avg=v(xdut.vnx_bias)
let avs=0
let avb=0
print aid avd avg avs avb
echo DEVICE 302
let aid=i(v.xdut.vaud302)
let avd=v(xdut.audit_d302)
let avg=v(xdut.vcasp)
let avs=v(xdut.vaux.t2)
let avb=v(xdut.avdd.t1006)
print aid avd avg avs avb
echo DEVICE 303
let aid=i(v.xdut.vaud303)
let avd=v(xdut.audit_d303)
let avg=v(xdut.psrg_m3_feed.t15)
let avs=v(xdut.avdd.t1017)
let avb=v(xdut.avdd.t1016)
print aid avd avg avs avb
echo DEVICE 304
let aid=i(v.xdut.vaud304)
let avd=v(xdut.audit_d304)
let avg=v(xdut.b1_b.t2)
let avs=v(xdut.rbit1top.t11)
let avb=v(xdut.dvdd.t14)
print aid avd avg avs avb
echo DEVICE 305
let aid=i(v.xdut.vaud305)
let avd=v(xdut.audit_d305)
let avg=v(xdut.vbp_i.t43)
let avs=v(xdut.avdd.t41)
let avb=v(xdut.avdd.t40)
print aid avd avg avs avb
echo DEVICE 306
let aid=i(v.xdut.vaud306)
let avd=v(xdut.audit_d306)
let avg=v(xdut.y1.t7)
let avs=v(xdut.avdd.t924)
let avb=v(xdut.avdd.t923)
print aid avd avg avs avb
echo DEVICE 307
let aid=i(v.xdut.vaud307)
let avd=v(xdut.audit_d307)
let avg=v(xdut.avdd.t427)
let avs=v(xdut.avdd.t429)
let avb=v(xdut.avdd.t428)
print aid avd avg avs avb
echo DEVICE 308
let aid=i(v.xdut.vaud308)
let avd=v(xdut.audit_d308)
let avg=v(xdut.vbp_i.t36)
let avs=v(xdut.avdd.t51)
let avb=v(xdut.avdd.t50)
print aid avd avg avs avb
echo DEVICE 309
let aid=i(v.xdut.vaud309)
let avd=v(xdut.audit_d309)
let avg=v(xdut.vbp_i.t44)
let avs=v(xdut.avdd.t84)
let avb=v(xdut.avdd.t83)
print aid avd avg avs avb
echo DEVICE 310
let aid=i(v.xdut.vaud310)
let avd=v(xdut.audit_d310)
let avg=v(xdut.b1.t1)
let avs=0
let avb=0
print aid avd avg avs avb
echo DEVICE 311
let aid=i(v.xdut.vaud311)
let avd=v(xdut.audit_d311)
let avg=v(xdut.vbp_bias.t20)
let avs=v(xdut.avdd.t906)
let avb=v(xdut.avdd.t905)
print aid avd avg avs avb
echo DEVICE 312
let aid=i(v.xdut.vaud312)
let avd=v(xdut.audit_d312)
let avg=v(xdut.vbn_sink.t21)
let avs=0
let avb=0
print aid avd avg avs avb
echo DEVICE 313
let aid=i(v.xdut.vaud313)
let avd=v(xdut.audit_d313)
let avg=v(xdut.b1.t0)
let avs=v(xdut.rbit2top.t6)
let avb=0
print aid avd avg avs avb
echo DEVICE 314
let aid=i(v.xdut.vaud314)
let avd=v(xdut.audit_d314)
let avg=v(xdut.y1.t16)
let avs=v(xdut.avdd.t959)
let avb=v(xdut.avdd.t958)
print aid avd avg avs avb
echo DEVICE 315
let aid=i(v.xdut.vaud315)
let avd=v(xdut.audit_d315)
let avg=v(xdut.vsu)
let avs=v(xdut.bgsu1)
let avb=0
print aid avd avg avs avb
echo DEVICE 316
let aid=i(v.xdut.vaud316)
let avd=v(xdut.audit_d316)
let avg=v(xdut.vbp_cas.t25)
let avs=v(xdut.pm2.t11)
let avb=v(xdut.avdd.t980)
print aid avd avg avs avb
echo DEVICE 317
let aid=i(v.xdut.vaud317)
let avd=v(xdut.audit_d317)
let avg=v(xdut.avdd.t826)
let avs=v(xdut.avdd.t828)
let avb=v(xdut.avdd.t827)
print aid avd avg avs avb
echo DEVICE 318
let aid=i(v.xdut.vaud318)
let avd=v(xdut.audit_d318)
let avg=v(xdut.vbn_sink.t22)
let avs=0
let avb=0
print aid avd avg avs avb
echo DEVICE 319
let aid=i(v.xdut.vaud319)
let avd=v(xdut.audit_d319)
let avg=v(xdut.b4.t1)
let avs=0
let avb=0
print aid avd avg avs avb
echo DEVICE 320
let aid=i(v.xdut.vaud320)
let avd=v(xdut.audit_d320)
let avg=v(xdut.vbp_i.t34)
let avs=v(xdut.avdd.t936)
let avb=v(xdut.avdd.t935)
print aid avd avg avs avb
echo DEVICE 321
let aid=i(v.xdut.vaud321)
let avd=v(xdut.audit_d321)
let avg=v(xdut.vbp_cas.t6)
let avs=v(xdut.vbp_bias.t2)
let avb=v(xdut.avdd.t969)
print aid avd avg avs avb
echo DEVICE 322
let aid=i(v.xdut.vaud322)
let avd=v(xdut.audit_d322)
let avg=v(xdut.avdd.t247)
let avs=v(xdut.avdd.t249)
let avb=v(xdut.avdd.t248)
print aid avd avg avs avb
echo DEVICE 323
let aid=i(v.xdut.vaud323)
let avd=v(xdut.audit_d323)
let avg=v(xdut.vbn_sink.t30)
let avs=0
let avb=0
print aid avd avg avs avb
echo DEVICE 324
let aid=i(v.xdut.vaud324)
let avd=v(xdut.audit_d324)
let avg=v(xdut.avdd.t758)
let avs=v(xdut.avdd.t760)
let avb=v(xdut.avdd.t759)
print aid avd avg avs avb
echo DEVICE 325
let aid=i(v.xdut.vaud325)
let avd=v(xdut.audit_d325)
let avg=v(xdut.vbp_tail.t7)
let avs=v(xdut.avdd.t1035)
let avb=v(xdut.avdd.t1034)
print aid avd avg avs avb
echo DEVICE 326
let aid=i(v.xdut.vaud326)
let avd=v(xdut.audit_d326)
let avg=v(xdut.avdd.t335)
let avs=v(xdut.avdd.t337)
let avb=v(xdut.avdd.t336)
print aid avd avg avs avb
echo DEVICE 327
let aid=i(v.xdut.vaud327)
let avd=v(xdut.audit_d327)
let avg=v(xdut.vbp_cas.t8)
let avs=v(xdut.vbp_bias.t1)
let avb=v(xdut.avdd.t1044)
print aid avd avg avs avb
echo DEVICE 328
let aid=i(v.xdut.vaud328)
let avd=v(xdut.audit_d328)
let avg=v(xdut.vbn_i.t8)
let avs=0
let avb=0
print aid avd avg avs avb
echo DEVICE 329
let aid=i(v.xdut.vaud329)
let avd=v(xdut.audit_d329)
let avg=v(xdut.avdd.t159)
let avs=v(xdut.avdd.t161)
let avb=v(xdut.avdd.t160)
print aid avd avg avs avb
echo DEVICE 330
let aid=i(v.xdut.vaud330)
let avd=v(xdut.audit_d330)
let avg=v(xdut.avdd.t143)
let avs=v(xdut.avdd.t145)
let avb=v(xdut.avdd.t144)
print aid avd avg avs avb
echo DEVICE 331
let aid=i(v.xdut.vaud331)
let avd=v(xdut.audit_d331)
let avg=v(xdut.avdd.t559)
let avs=v(xdut.avdd.t561)
let avb=v(xdut.avdd.t560)
print aid avd avg avs avb
echo DEVICE 332
let aid=i(v.xdut.vaud332)
let avd=v(xdut.audit_d332)
let avg=v(xdut.avdd.t463)
let avs=v(xdut.avdd.t465)
let avb=v(xdut.avdd.t464)
print aid avd avg avs avb
echo DEVICE 333
let aid=i(v.xdut.vaud333)
let avd=v(xdut.audit_d333)
let avg=v(xdut.avdd.t483)
let avs=v(xdut.avdd.t485)
let avb=v(xdut.avdd.t484)
print aid avd avg avs avb
echo DEVICE 334
let aid=i(v.xdut.vaud334)
let avd=v(xdut.audit_d334)
let avg=v(xdut.avdd.t155)
let avs=v(xdut.avdd.t157)
let avb=v(xdut.avdd.t156)
print aid avd avg avs avb
echo DEVICE 335
let aid=i(v.xdut.vaud335)
let avd=v(xdut.audit_d335)
let avg=v(xdut.vgn1.t0)
let avs=v(xdut.v1.t1)
let avb=0
print aid avd avg avs avb
echo DEVICE 336
let aid=i(v.xdut.vaud336)
let avd=v(xdut.audit_d336)
let avg=v(xdut.rb_mid)
let avs=0
let avb=0
print aid avd avg avs avb
echo DEVICE 337
let aid=i(v.xdut.vaud337)
let avd=v(xdut.audit_d337)
let avg=v(xdut.avdd.t766)
let avs=v(xdut.avdd.t768)
let avb=v(xdut.avdd.t767)
print aid avd avg avs avb
echo DEVICE 338
let aid=i(v.xdut.vaud338)
let avd=v(xdut.audit_d338)
let avg=v(xdut.avdd.t730)
let avs=v(xdut.avdd.t732)
let avb=v(xdut.avdd.t731)
print aid avd avg avs avb
echo DEVICE 339
let aid=i(v.xdut.vaud339)
let avd=v(xdut.audit_d339)
let avg=v(xdut.avdd.t695)
let avs=v(xdut.avdd.t697)
let avb=v(xdut.avdd.t696)
print aid avd avg avs avb
echo DEVICE 340
let aid=i(v.xdut.vaud340)
let avd=v(xdut.audit_d340)
let avg=v(xdut.b0_b.t5)
let avs=v(xdut.rbit0top.t4)
let avb=v(xdut.dvdd.t3)
print aid avd avg avs avb
echo DEVICE 341
let aid=i(v.xdut.vaud341)
let avd=v(xdut.audit_d341)
let avg=v(xdut.vcasp)
let avs=v(xdut.vx3.t8)
let avb=v(xdut.avdd.t1005)
print aid avd avg avs avb
echo DEVICE 342
let aid=i(v.xdut.vaud342)
let avd=v(xdut.audit_d342)
let avg=v(xdut.vbn_sink.t25)
let avs=0
let avb=0
print aid avd avg avs avb
echo DEVICE 343
let aid=i(v.xdut.vaud343)
let avd=v(xdut.audit_d343)
let avg=v(xdut.avdd.t475)
let avs=v(xdut.avdd.t477)
let avb=v(xdut.avdd.t476)
print aid avd avg avs avb
echo DEVICE 344
let aid=i(v.xdut.vaud344)
let avd=v(xdut.audit_d344)
let avg=v(xdut.avdd.t235)
let avs=v(xdut.avdd.t237)
let avb=v(xdut.avdd.t236)
print aid avd avg avs avb
echo DEVICE 345
let aid=i(v.xdut.vaud345)
let avd=v(xdut.audit_d345)
let avg=v(xdut.avdd.t691)
let avs=v(xdut.avdd.t693)
let avb=v(xdut.avdd.t692)
print aid avd avg avs avb
echo DEVICE 346
let aid=i(v.xdut.vaud346)
let avd=v(xdut.audit_d346)
let avg=v(xdut.b0.t0)
let avs=0
let avb=0
print aid avd avg avs avb
echo DEVICE 347
let aid=i(v.xdut.vaud347)
let avd=v(xdut.audit_d347)
let avg=v(xdut.vbp_cas.t22)
let avs=v(xdut.pm1.t10)
let avb=v(xdut.avdd.t977)
print aid avd avg avs avb
echo DEVICE 348
let aid=i(v.xdut.vaud348)
let avd=v(xdut.audit_d348)
let avg=v(xdut.vbp_tail.t4)
let avs=v(xdut.avdd.t918)
let avb=v(xdut.avdd.t917)
print aid avd avg avs avb
echo DEVICE 349
let aid=i(v.xdut.vaud349)
let avd=v(xdut.audit_d349)
let avg=v(xdut.b6.t1)
let avs=v(xdut.vq3.t2)
let avb=0
print aid avd avg avs avb
echo DEVICE 350
let aid=i(v.xdut.vaud350)
let avd=v(xdut.audit_d350)
let avg=v(xdut.v2.t7)
let avs=v(xdut.vsp.t7)
let avb=v(xdut.avdd.t1020)
print aid avd avg avs avb
echo DEVICE 351
let aid=i(v.xdut.vaud351)
let avd=v(xdut.audit_d351)
let avg=v(xdut.vbp_i.t1)
let avs=v(xdut.avdd.t47)
let avb=v(xdut.avdd.t46)
print aid avd avg avs avb
echo DEVICE 352
let aid=i(v.xdut.vaud352)
let avd=v(xdut.audit_d352)
let avg=v(xdut.avdd.t746)
let avs=v(xdut.avdd.t748)
let avb=v(xdut.avdd.t747)
print aid avd avg avs avb
echo DEVICE 353
let aid=i(v.xdut.vaud353)
let avd=v(xdut.audit_d353)
let avg=v(xdut.vbp_bias.t24)
let avs=v(xdut.avdd.t910)
let avb=v(xdut.avdd.t909)
print aid avd avg avs avb
echo DEVICE 354
let aid=i(v.xdut.vaud354)
let avd=v(xdut.audit_d354)
let avg=v(xdut.vbp_i.t56)
let avs=v(xdut.avdd.t73)
let avb=v(xdut.avdd.t72)
print aid avd avg avs avb
echo DEVICE 355
let aid=i(v.xdut.vaud355)
let avd=v(xdut.audit_d355)
let avg=v(xdut.avdd.t131)
let avs=v(xdut.avdd.t133)
let avb=v(xdut.avdd.t132)
print aid avd avg avs avb
echo DEVICE 356
let aid=i(v.xdut.vaud356)
let avd=v(xdut.audit_d356)
let avg=v(xdut.avdd.t339)
let avs=v(xdut.avdd.t341)
let avb=v(xdut.avdd.t340)
print aid avd avg avs avb
echo DEVICE 357
let aid=i(v.xdut.vaud357)
let avd=v(xdut.audit_d357)
let avg=v(xdut.vbp_i.t37)
let avs=v(xdut.avdd.t53)
let avb=v(xdut.avdd.t52)
print aid avd avg avs avb
echo DEVICE 358
let aid=i(v.xdut.vaud358)
let avd=v(xdut.audit_d358)
let avg=v(xdut.psrg_m3_feed.t12)
let avs=v(xdut.avdd.t1039)
let avb=v(xdut.avdd.t1038)
print aid avd avg avs avb
echo DEVICE 359
let aid=i(v.xdut.vaud359)
let avd=v(xdut.audit_d359)
let avg=v(xdut.psrg_m3_feed.t22)
let avs=v(xdut.avdd.t986)
let avb=v(xdut.avdd.t985)
print aid avd avg avs avb
echo DEVICE 360
let aid=i(v.xdut.vaud360)
let avd=v(xdut.audit_d360)
let avg=v(xdut.avdd.t443)
let avs=v(xdut.avdd.t445)
let avb=v(xdut.avdd.t444)
print aid avd avg avs avb
echo DEVICE 361
let aid=i(v.xdut.vaud361)
let avd=v(xdut.audit_d361)
let avg=v(xdut.avdd.t782)
let avs=v(xdut.avdd.t784)
let avb=v(xdut.avdd.t783)
print aid avd avg avs avb
echo DEVICE 362
let aid=i(v.xdut.vaud362)
let avd=v(xdut.audit_d362)
let avg=v(xdut.vbp_i.t11)
let avs=v(xdut.avdd.t930)
let avb=v(xdut.avdd.t929)
print aid avd avg avs avb
echo DEVICE 363
let aid=i(v.xdut.vaud363)
let avd=v(xdut.audit_d363)
let avg=v(xdut.avdd.t467)
let avs=v(xdut.avdd.t469)
let avb=v(xdut.avdd.t468)
print aid avd avg avs avb
echo DEVICE 364
let aid=i(v.xdut.vaud364)
let avd=v(xdut.audit_d364)
let avg=v(xdut.vcasp)
let avs=v(xdut.avdd.t1008)
let avb=v(xdut.avdd.t1007)
print aid avd avg avs avb
echo DEVICE 365
let aid=i(v.xdut.vaud365)
let avd=v(xdut.audit_d365)
let avg=v(xdut.avdd.t395)
let avs=v(xdut.avdd.t397)
let avb=v(xdut.avdd.t396)
print aid avd avg avs avb
echo DEVICE 366
let aid=i(v.xdut.vaud366)
let avd=v(xdut.audit_d366)
let avg=v(xdut.vbp_i.t29)
let avs=v(xdut.avdd.t21)
let avb=v(xdut.avdd.t20)
print aid avd avg avs avb
echo DEVICE 367
let aid=i(v.xdut.vaud367)
let avd=v(xdut.audit_d367)
let avg=v(xdut.vbp_i.t38)
let avs=v(xdut.avdd.t33)
let avb=v(xdut.avdd.t32)
print aid avd avg avs avb
echo DEVICE 368
let aid=i(v.xdut.vaud368)
let avd=v(xdut.audit_d368)
let avg=v(xdut.vbp_i.t13)
let avs=v(xdut.avdd.t29)
let avb=v(xdut.avdd.t28)
print aid avd avg avs avb
echo DEVICE 369
let aid=i(v.xdut.vaud369)
let avd=v(xdut.audit_d369)
let avg=v(xdut.b6.t2)
let avs=0
let avb=0
print aid avd avg avs avb
echo DEVICE 370
let aid=i(v.xdut.vaud370)
let avd=v(xdut.audit_d370)
let avg=v(xdut.avdd.t683)
let avs=v(xdut.avdd.t685)
let avb=v(xdut.avdd.t684)
print aid avd avg avs avb
echo DEVICE 371
let aid=i(v.xdut.vaud371)
let avd=v(xdut.audit_d371)
let avg=v(xdut.vbp_i.t22)
let avs=v(xdut.vsu2)
let avb=0
print aid avd avg avs avb
echo DEVICE 372
let aid=i(v.xdut.vaud372)
let avd=v(xdut.audit_d372)
let avg=v(xdut.avdd.t639)
let avs=v(xdut.avdd.t641)
let avb=v(xdut.avdd.t640)
print aid avd avg avs avb
echo DEVICE 373
let aid=i(v.xdut.vaud373)
let avd=v(xdut.audit_d373)
let avg=v(xdut.vbp_i.t3)
let avs=v(xdut.avdd.t90)
let avb=v(xdut.avdd.t89)
print aid avd avg avs avb
echo DEVICE 374
let aid=i(v.xdut.vaud374)
let avd=v(xdut.audit_d374)
let avg=v(xdut.avdd.t679)
let avs=v(xdut.avdd.t681)
let avb=v(xdut.avdd.t680)
print aid avd avg avs avb
echo DEVICE 375
let aid=i(v.xdut.vaud375)
let avd=v(xdut.audit_d375)
let avg=v(xdut.bgsu2)
let avs=0
let avb=0
print aid avd avg avs avb
echo DEVICE 376
let aid=i(v.xdut.vaud376)
let avd=v(xdut.audit_d376)
let avg=v(xdut.vbp_cas.t27)
let avs=v(xdut.pm1.t1)
let avb=v(xdut.avdd.t954)
print aid avd avg avs avb
echo DEVICE 377
let aid=i(v.xdut.vaud377)
let avd=v(xdut.audit_d377)
let avg=v(xdut.v1.t4)
let avs=v(xdut.vsp.t10)
let avb=v(xdut.avdd.t1027)
print aid avd avg avs avb
echo DEVICE 378
let aid=i(v.xdut.vaud378)
let avd=v(xdut.audit_d378)
let avg=v(xdut.vbn.t4)
let avs=0
let avb=0
print aid avd avg avs avb
echo DEVICE 379
let aid=i(v.xdut.vaud379)
let avd=v(xdut.audit_d379)
let avg=v(xdut.b2.t1)
let avs=0
let avb=0
print aid avd avg avs avb
echo DEVICE 380
let aid=i(v.xdut.vaud380)
let avd=v(xdut.audit_d380)
let avg=v(xdut.avdd.t311)
let avs=v(xdut.avdd.t313)
let avb=v(xdut.avdd.t312)
print aid avd avg avs avb
echo DEVICE 381
let aid=i(v.xdut.vaud381)
let avd=v(xdut.audit_d381)
let avg=v(xdut.avdd.t263)
let avs=v(xdut.avdd.t265)
let avb=v(xdut.avdd.t264)
print aid avd avg avs avb
echo DEVICE 382
let aid=i(v.xdut.vaud382)
let avd=v(xdut.audit_d382)
let avg=v(xdut.psrg_m3_feed.t20)
let avs=v(xdut.avdd.t982)
let avb=v(xdut.avdd.t981)
print aid avd avg avs avb
echo DEVICE 383
let aid=i(v.xdut.vaud383)
let avd=v(xdut.audit_d383)
let avg=v(xdut.vgn2.t10)
let avs=0
let avb=0
print aid avd avg avs avb
echo DEVICE 384
let aid=i(v.xdut.vaud384)
let avd=v(xdut.audit_d384)
let avg=v(xdut.vbp_cas.t28)
let avs=v(xdut.pm2.t0)
let avb=v(xdut.avdd.t955)
print aid avd avg avs avb
echo DEVICE 385
let aid=i(v.xdut.vaud385)
let avd=v(xdut.audit_d385)
let avg=v(xdut.avdd.t571)
let avs=v(xdut.avdd.t573)
let avb=v(xdut.avdd.t572)
print aid avd avg avs avb
echo DEVICE 386
let aid=i(v.xdut.vaud386)
let avd=v(xdut.audit_d386)
let avg=v(xdut.vcasp)
let avs=v(xdut.vx3.t4)
let avb=v(xdut.avdd.t993)
print aid avd avg avs avb
echo DEVICE 387
let aid=i(v.xdut.vaud387)
let avd=v(xdut.audit_d387)
let avg=v(xdut.b2_b.t2)
let avs=v(xdut.rbit2top.t2)
let avb=v(xdut.dvdd.t16)
print aid avd avg avs avb
echo DEVICE 388
let aid=i(v.xdut.vaud388)
let avd=v(xdut.audit_d388)
let avg=v(xdut.avdd.t806)
let avs=v(xdut.avdd.t808)
let avb=v(xdut.avdd.t807)
print aid avd avg avs avb
echo DEVICE 389
let aid=i(v.xdut.vaud389)
let avd=v(xdut.audit_d389)
let avg=v(xdut.auxsu1)
let avs=v(xdut.auxsu2)
let avb=0
print aid avd avg avs avb
echo DEVICE 390
let aid=i(v.xdut.vaud390)
let avd=v(xdut.audit_d390)
let avg=v(xdut.vcasp)
let avs=v(xdut.vx1.t8)
let avb=v(xdut.avdd.t998)
print aid avd avg avs avb
echo DEVICE 391
let aid=i(v.xdut.vaud391)
let avd=v(xdut.audit_d391)
let avg=v(xdut.vbp_tail.t8)
let avs=v(xdut.avdd.t944)
let avb=v(xdut.avdd.t943)
print aid avd avg avs avb
echo DEVICE 392
let aid=i(v.xdut.vaud392)
let avd=v(xdut.audit_d392)
let avg=v(xdut.avdd.t259)
let avs=v(xdut.avdd.t261)
let avb=v(xdut.avdd.t260)
print aid avd avg avs avb
echo DEVICE 393
let aid=i(v.xdut.vaud393)
let avd=v(xdut.audit_d393)
let avg=v(xdut.vbp_i.t31)
let avs=v(xdut.avdd.t25)
let avb=v(xdut.avdd.t24)
print aid avd avg avs avb
echo DEVICE 394
let aid=i(v.xdut.vaud394)
let avd=v(xdut.audit_d394)
let avg=v(xdut.b0.t1)
let avs=v(xdut.dvdd.t11)
let avb=v(xdut.dvdd.t10)
print aid avd avg avs avb
echo DEVICE 395
let aid=i(v.xdut.vaud395)
let avd=v(xdut.audit_d395)
let avg=v(xdut.avdd.t619)
let avs=v(xdut.avdd.t621)
let avb=v(xdut.avdd.t620)
print aid avd avg avs avb
echo DEVICE 396
let aid=i(v.xdut.vaud396)
let avd=v(xdut.audit_d396)
let avg=v(xdut.avdd.t543)
let avs=v(xdut.avdd.t545)
let avb=v(xdut.avdd.t544)
print aid avd avg avs avb
echo DEVICE 397
let aid=i(v.xdut.vaud397)
let avd=v(xdut.audit_d397)
let avg=v(xdut.vcasp)
let avs=v(xdut.avdd.t990)
let avb=v(xdut.avdd.t989)
print aid avd avg avs avb
echo DEVICE 398
let aid=i(v.xdut.vaud398)
let avd=v(xdut.audit_d398)
let avg=v(xdut.psrg_m3_feed.t21)
let avs=v(xdut.avdd.t984)
let avb=v(xdut.avdd.t983)
print aid avd avg avs avb
echo DEVICE 399
let aid=i(v.xdut.vaud399)
let avd=v(xdut.audit_d399)
let avg=v(xdut.avdd.t411)
let avs=v(xdut.avdd.t413)
let avb=v(xdut.avdd.t412)
print aid avd avg avs avb
echo DEVICE 400
let aid=i(v.xdut.vaud400)
let avd=v(xdut.audit_d400)
let avg=v(xdut.avdd.t866)
let avs=v(xdut.avdd.t868)
let avb=v(xdut.avdd.t867)
print aid avd avg avs avb
echo DEVICE 401
let aid=i(v.xdut.vaud401)
let avd=v(xdut.audit_d401)
let avg=v(xdut.avdd.t527)
let avs=v(xdut.avdd.t529)
let avb=v(xdut.avdd.t528)
print aid avd avg avs avb
echo DEVICE 402
let aid=i(v.xdut.vaud402)
let avd=v(xdut.audit_d402)
let avg=v(xdut.vbn_sink.t26)
let avs=0
let avb=0
print aid avd avg avs avb
echo DEVICE 403
let aid=i(v.xdut.vaud403)
let avd=v(xdut.audit_d403)
let avg=v(xdut.vbp_cas.t24)
let avs=v(xdut.pm2.t10)
let avb=v(xdut.avdd.t979)
print aid avd avg avs avb
echo DEVICE 404
let aid=i(v.xdut.vaud404)
let avd=v(xdut.audit_d404)
let avg=v(xdut.avdd.t838)
let avs=v(xdut.avdd.t840)
let avb=v(xdut.avdd.t839)
print aid avd avg avs avb
echo DEVICE 405
let aid=i(v.xdut.vaud405)
let avd=v(xdut.audit_d405)
let avg=v(xdut.avdd.t231)
let avs=v(xdut.avdd.t233)
let avb=v(xdut.avdd.t232)
print aid avd avg avs avb
echo DEVICE 406
let aid=i(v.xdut.vaud406)
let avd=v(xdut.audit_d406)
let avg=v(xdut.avdd.t854)
let avs=v(xdut.avdd.t856)
let avb=v(xdut.avdd.t855)
print aid avd avg avs avb
echo DEVICE 407
let aid=i(v.xdut.vaud407)
let avd=v(xdut.audit_d407)
let avg=v(xdut.b0_b.t2)
let avs=v(xdut.rbit0top.t7)
let avb=v(xdut.dvdd.t21)
print aid avd avg avs avb
echo DEVICE 408
let aid=i(v.xdut.vaud408)
let avd=v(xdut.audit_d408)
let avg=v(xdut.vbp_cas.t30)
let avs=v(xdut.pm1.t2)
let avb=v(xdut.avdd.t964)
print aid avd avg avs avb
echo DEVICE 409
let aid=i(v.xdut.vaud409)
let avd=v(xdut.audit_d409)
let avg=v(xdut.vbp_tail.t10)
let avs=v(xdut.avdd.t1042)
let avb=v(xdut.avdd.t1041)
print aid avd avg avs avb
echo DEVICE 410
let aid=i(v.xdut.vaud410)
let avd=v(xdut.audit_d410)
let avg=v(xdut.avdd.t211)
let avs=v(xdut.avdd.t213)
let avb=v(xdut.avdd.t212)
print aid avd avg avs avb
echo DEVICE 411
let aid=i(v.xdut.vaud411)
let avd=v(xdut.audit_d411)
let avg=v(xdut.psrg_m3_feed.t14)
let avs=v(xdut.avdd.t1015)
let avb=v(xdut.avdd.t1014)
print aid avd avg avs avb
echo DEVICE 412
let aid=i(v.xdut.vaud412)
let avd=v(xdut.audit_d412)
let avg=v(xdut.vbp_cas.t31)
let avs=v(xdut.pm1.t3)
let avb=v(xdut.avdd.t965)
print aid avd avg avs avb
echo DEVICE 413
let aid=i(v.xdut.vaud413)
let avd=v(xdut.audit_d413)
let avg=v(xdut.avdd.t179)
let avs=v(xdut.avdd.t181)
let avb=v(xdut.avdd.t180)
print aid avd avg avs avb
echo DEVICE 414
let aid=i(v.xdut.vaud414)
let avd=v(xdut.audit_d414)
let avg=v(xdut.avdd.t762)
let avs=v(xdut.avdd.t764)
let avb=v(xdut.avdd.t763)
print aid avd avg avs avb
echo DEVICE 415
let aid=i(v.xdut.vaud415)
let avd=v(xdut.audit_d415)
let avg=v(xdut.v1.t6)
let avs=v(xdut.vsp.t8)
let avb=v(xdut.avdd.t1025)
print aid avd avg avs avb
echo DEVICE 416
let aid=i(v.xdut.vaud416)
let avd=v(xdut.audit_d416)
let avg=v(xdut.psrg_m3_feed.t19)
let avs=v(xdut.avdd.t5)
let avb=v(xdut.avdd.t4)
print aid avd avg avs avb
echo DEVICE 417
let aid=i(v.xdut.vaud417)
let avd=v(xdut.audit_d417)
let avg=v(xdut.avdd.t127)
let avs=v(xdut.avdd.t129)
let avb=v(xdut.avdd.t128)
print aid avd avg avs avb
echo DEVICE 418
let aid=i(v.xdut.vaud418)
let avd=v(xdut.audit_d418)
let avg=v(xdut.avdd.t407)
let avs=v(xdut.avdd.t409)
let avb=v(xdut.avdd.t408)
print aid avd avg avs avb
echo DEVICE 419
let aid=i(v.xdut.vaud419)
let avd=v(xdut.audit_d419)
let avg=v(xdut.avdd.t631)
let avs=v(xdut.avdd.t633)
let avb=v(xdut.avdd.t632)
print aid avd avg avs avb
echo DEVICE 420
let aid=i(v.xdut.vaud420)
let avd=v(xdut.audit_d420)
let avg=v(xdut.avdd.t431)
let avs=v(xdut.avdd.t433)
let avb=v(xdut.avdd.t432)
print aid avd avg avs avb
echo DEVICE 421
let aid=i(v.xdut.vaud421)
let avd=v(xdut.audit_d421)
let avg=v(xdut.auxsu2)
let avs=0
let avb=0
print aid avd avg avs avb
echo DEVICE 422
let aid=i(v.xdut.vaud422)
let avd=v(xdut.audit_d422)
let avg=v(xdut.avdd.t107)
let avs=v(xdut.avdd.t109)
let avb=v(xdut.avdd.t108)
print aid avd avg avs avb
echo DEVICE 423
let aid=i(v.xdut.vaud423)
let avd=v(xdut.audit_d423)
let avg=v(xdut.b0_b.t6)
let avs=v(xdut.rbit0top.t3)
let avb=v(xdut.dvdd.t22)
print aid avd avg avs avb
echo DEVICE 424
let aid=i(v.xdut.vaud424)
let avd=v(xdut.audit_d424)
let avg=v(xdut.avdd.t750)
let avs=v(xdut.avdd.t752)
let avb=v(xdut.avdd.t751)
print aid avd avg avs avb
echo DEVICE 425
let aid=i(v.xdut.vaud425)
let avd=v(xdut.audit_d425)
let avg=v(xdut.avdd.t287)
let avs=v(xdut.avdd.t289)
let avb=v(xdut.avdd.t288)
print aid avd avg avs avb
echo DEVICE 426
let aid=i(v.xdut.vaud426)
let avd=v(xdut.audit_d426)
let avg=v(xdut.y1.t15)
let avs=v(xdut.avdd.t952)
let avb=v(xdut.avdd.t951)
print aid avd avg avs avb
echo DEVICE 427
let aid=i(v.xdut.vaud427)
let avd=v(xdut.audit_d427)
let avg=v(xdut.avdd.t371)
let avs=v(xdut.avdd.t373)
let avb=v(xdut.avdd.t372)
print aid avd avg avs avb
echo DEVICE 428
let aid=i(v.xdut.vaud428)
let avd=v(xdut.audit_d428)
let avg=v(xdut.avdd.t794)
let avs=v(xdut.avdd.t796)
let avb=v(xdut.avdd.t795)
print aid avd avg avs avb
echo DEVICE 429
let aid=i(v.xdut.vaud429)
let avd=v(xdut.audit_d429)
let avg=v(xdut.b1_b.t3)
let avs=v(xdut.rbit1top.t13)
let avb=v(xdut.dvdd.t13)
print aid avd avg avs avb
echo DEVICE 430
let aid=i(v.xdut.vaud430)
let avd=v(xdut.audit_d430)
let avg=v(xdut.avdd.t659)
let avs=v(xdut.avdd.t661)
let avb=v(xdut.avdd.t660)
print aid avd avg avs avb
echo DEVICE 431
let aid=i(v.xdut.vaud431)
let avd=v(xdut.audit_d431)
let avg=v(xdut.avdd.t283)
let avs=v(xdut.avdd.t285)
let avb=v(xdut.avdd.t284)
print aid avd avg avs avb
echo DEVICE 432
let aid=i(v.xdut.vaud432)
let avd=v(xdut.audit_d432)
let avg=v(xdut.avdd.t675)
let avs=v(xdut.avdd.t677)
let avb=v(xdut.avdd.t676)
print aid avd avg avs avb
echo DEVICE 433
let aid=i(v.xdut.vaud433)
let avd=v(xdut.audit_d433)
let avg=v(xdut.avdd.t523)
let avs=v(xdut.avdd.t525)
let avb=v(xdut.avdd.t524)
print aid avd avg avs avb
echo DEVICE 434
let aid=i(v.xdut.vaud434)
let avd=v(xdut.audit_d434)
let avg=v(xdut.vbp_cas.t21)
let avs=v(xdut.pm2.t9)
let avb=v(xdut.avdd.t971)
print aid avd avg avs avb
echo DEVICE 435
let aid=i(v.xdut.vaud435)
let avd=v(xdut.audit_d435)
let avg=v(xdut.y1.t17)
let avs=v(xdut.avdd.t961)
let avb=v(xdut.avdd.t960)
print aid avd avg avs avb
echo DEVICE 436
let aid=i(v.xdut.vaud436)
let avd=v(xdut.audit_d436)
let avg=v(xdut.avdd.t671)
let avs=v(xdut.avdd.t673)
let avb=v(xdut.avdd.t672)
print aid avd avg avs avb
echo DEVICE 437
let aid=i(v.xdut.vaud437)
let avd=v(xdut.audit_d437)
let avg=v(xdut.vbp_i.t19)
let avs=v(xdut.avdd.t17)
let avb=v(xdut.avdd.t16)
print aid avd avg avs avb
echo DEVICE 438
let aid=i(v.xdut.vaud438)
let avd=v(xdut.audit_d438)
let avg=v(xdut.b0.t3)
let avs=v(xdut.rbit1top.t7)
let avb=0
print aid avd avg avs avb
quit
.endc
.end
