* Capacitance-conserving approximation; see conserve_pex_capacitance.py.
* Raw Magic exports remain available for independent review.
* NGSPICE file created from Bandgap_Core_Res.ext - technology: gf180mcuD
.subckt Bandgap_Core_Res avdd avss vref b0 b1 b2 b3 b4 b5 b6 dvss dvdd
Xpnp_05p00x05p00_0 avss avss vq3 pnp_05p00x05p00
Xpnp_05p00x05p00_1 avss avss vq2 pnp_05p00x05p00
Xpnp_05p00x05p00_2 avss avss vq2 pnp_05p00x05p00
Xpnp_05p00x05p00_4 avss avss vq2 pnp_05p00x05p00
Xpnp_05p00x05p00_3 avss avss vq2 pnp_05p00x05p00
Xpnp_05p00x05p00_5 avss avss v1 pnp_05p00x05p00
Xpnp_05p00x05p00_6 avss avss vq2 pnp_05p00x05p00
Xpnp_05p00x05p00_7 avss avss vq2 pnp_05p00x05p00
Xpnp_05p00x05p00_8 avss avss vq2 pnp_05p00x05p00
Xpnp_05p00x05p00_9 avss avss vq2 pnp_05p00x05p00
Xnwell_0 net3 net4 avss nwell r_length=20.19u r_width=2u
VAUD0 rbit0top.t8 audit_d0 0
X0 audit_d0 b0.t2 rbit1top.t9 dvss nfet_03v3 ad=17.6p pd=80.88u as=17.6p ps=80.88u w=40u l=0.28u
VAUD1 avdd.t462 audit_d1 0
X1 audit_d1 avdd.t461 avdd.t462 avdd pfet_05v0 ad=24.1516p pd=0.11066m as=0 ps=0 w=54.89u l=4u
VAUD2 avss.t114 audit_d2 0
X2 audit_d2 avss.t112 avss.t113 avss nfet_05v0 ad=3.322p pd=15.98u as=0 ps=0 w=7.55u l=4u
VAUD3 avss.t141 audit_d3 0
X3 audit_d3 avss.t139 avss.t140 avss nfet_05v0 ad=7.1896p pd=33.56u as=0 ps=0 w=16.34u l=8u
VAUD4 avdd.t225 audit_d4 0
X4 audit_d4 avdd.t223 avdd.t224 avdd pfet_05v0 ad=7.2248p pd=33.72u as=0 ps=0 w=16.42u l=4u
VAUD5 vbn_sink.t13 audit_d5 0
X5 audit_d5 vbp_i.t32 avdd.t590 avdd pfet_05v0 ad=8.338p pd=38.78u as=8.338p ps=38.78u w=18.95u l=8u
VAUD6 vbn_sink.t6 audit_d6 0
X6 audit_d6 vbp_i.t24 avdd.t576 avdd pfet_05v0 ad=8.338p pd=38.78u as=8.338p ps=38.78u w=18.95u l=8u
VAUD7 avdd.t267 audit_d7 0
X7 audit_d7 avdd.t265 avdd.t266 avdd pfet_05v0 ad=7.37p pd=34.38u as=0 ps=0 w=16.75u l=2u
VAUD8 avdd.t285 audit_d8 0
X8 audit_d8 avdd.t283 avdd.t284 avdd pfet_05v0 ad=7.37p pd=34.38u as=0 ps=0 w=16.75u l=2u
VAUD9 vbn_sink.t14 audit_d9 0
X9 audit_d9 vbp_i.t33 avdd.t591 avdd pfet_05v0 ad=8.338p pd=38.78u as=8.338p ps=38.78u w=18.95u l=8u
VAUD10 avdd.t138 audit_d10 0
X10 audit_d10 avdd.t136 avdd.t137 avdd pfet_05v0 ad=8.3556p pd=38.86u as=0 ps=0 w=18.99u l=8u
VAUD11 vbn_fold.t1 audit_d11 0
X11 audit_d11 vbp_i.t47 avdd.t564 avdd pfet_05v0 ad=8.3556p pd=38.86u as=8.3556p ps=38.86u w=18.99u l=8u
VAUD12 b3_b.t1 audit_d12 0
X12 audit_d12 b3.t0 dvdd.t0 dvdd pfet_03v3 ad=1.32p pd=6.88u as=1.32p ps=6.88u w=3u l=0.5u
VAUD13 vx1.t4 audit_d13 0
X13 audit_d13 psrg_m3_feed.t13 avdd.t605 avdd pfet_05v0 ad=7.37p pd=34.38u as=7.37p ps=34.38u w=16.75u l=2u
VAUD14 rbit3top.t5 audit_d14 0
X14 audit_d14 b2_b.t3 rbit2top.t1 dvdd pfet_03v3 ad=8.8p pd=40.88u as=8.8p ps=40.88u w=20u l=0.28u
VAUD15 pm1.t2 audit_d15 0
X15 audit_d15 y1.t13 avdd.t624 avdd pfet_05v0 ad=9.1344p pd=42.4u as=9.1344p ps=42.4u w=20.76u l=4u
VAUD16 vbn.t1 audit_d16 0
X16 audit_d16 vbn.t0 avss.t204 avss nfet_05v0 ad=3.322p pd=15.98u as=3.322p ps=15.98u w=7.55u l=4u
VAUD17 avdd.t87 audit_d17 0
X17 audit_d17 avdd.t85 avdd.t86 avdd pfet_05v0 ad=8.25p pd=38.38u as=0 ps=0 w=18.75u l=8u
VAUD18 avdd.t153 audit_d18 0
X18 audit_d18 avdd.t151 avdd.t152 avdd pfet_05v0 ad=8.338p pd=38.78u as=0 ps=0 w=18.95u l=8u
VAUD19 vgn2.t0 audit_d19 0
X19 audit_d19 vbn_fold.t14 xf2.t2 avss nfet_05v0 ad=8.1356p pd=37.86u as=8.1356p ps=37.86u w=18.49u l=6u
VAUD20 vbp_cas.t20 audit_d20 0
X20 audit_d20 vbn_i.t11 avss.t207 avss nfet_05v0 ad=0.286p pd=2.18u as=0.286p ps=2.18u w=0.65u l=8u
VAUD21 vbn_i.t4 audit_d21 0
X21 audit_d21 vbp_i.t52 avdd.t633 avdd pfet_05v0 ad=8.25p pd=38.38u as=8.25p ps=38.38u w=18.75u l=8u
VAUD22 avdd.t261 audit_d22 0
X22 audit_d22 avdd.t259 avdd.t260 avdd pfet_05v0 ad=7.2248p pd=33.72u as=0 ps=0 w=16.42u l=4u
VAUD23 avss.t165 audit_d23 0
X23 audit_d23 avss.t163 avss.t164 avss nfet_05v0 ad=7.1896p pd=33.56u as=0 ps=0 w=16.34u l=8u
VAUD24 vgn2.t1 audit_d24 0
X24 audit_d24 vbp_cas.t32 pm2.t7 avdd pfet_05v0 ad=9.7724p pd=45.3u as=9.7724p ps=45.3u w=22.21u l=8u
VAUD25 avdd.t386 audit_d25 0
X25 audit_d25 avdd.t384 avdd.t385 avdd pfet_05v0 ad=7.2248p pd=33.72u as=0 ps=0 w=16.42u l=4u
VAUD26 avdd.t547 audit_d26 0
X26 audit_d26 avdd.t545 avdd.t546 avdd pfet_05v0 ad=9.1344p pd=42.4u as=0 ps=0 w=20.76u l=4u
VAUD27 avdd.t395 audit_d27 0
X27 audit_d27 avdd.t393 avdd.t394 avdd pfet_05v0 ad=7.37p pd=34.38u as=0 ps=0 w=16.75u l=2u
VAUD28 avdd.t84 audit_d28 0
X28 audit_d28 avdd.t82 avdd.t83 avdd pfet_05v0 ad=8.25p pd=38.38u as=0 ps=0 w=18.75u l=8u
VAUD29 avdd.t150 audit_d29 0
X29 audit_d29 avdd.t148 avdd.t149 avdd pfet_05v0 ad=8.338p pd=38.78u as=0 ps=0 w=18.95u l=8u
VAUD30 avdd.t305 audit_d30 0
X30 audit_d30 avdd.t304 avdd.t305 avdd pfet_05v0 ad=24.1516p pd=0.11066m as=0 ps=0 w=54.89u l=4u
VAUD31 vbn_fold.t9 audit_d31 0
X31 audit_d31 vbn_fold.t8 vnx_bias avss nfet_05v0 ad=2.0328p pd=10.12u as=2.0328p ps=10.12u w=4.62u l=6u
VAUD32 xf1.t4 audit_d32 0
X32 audit_d32 vbn_sink.t23 avss.t202 avss nfet_05v0 ad=7.1896p pd=33.56u as=7.1896p ps=33.56u w=16.34u l=8u
VAUD33 vgn1.t9 audit_d33 0
X33 audit_d33 aux_gate psrg_m3_feed.t7 avdd pfet_05v0 ad=0.88p pd=4.88u as=0.88p ps=4.88u w=2u l=2u
VAUD34 rbit6top.t0 audit_d34 0
X34 audit_d34 b5_b.t2 rbit5top.t0 dvdd pfet_03v3 ad=3.3p pd=15.88u as=3.3p ps=15.88u w=7.5u l=0.28u
VAUD35 avdd.t469 audit_d35 0
X35 audit_d35 avdd.t467 avdd.t468 avdd pfet_05v0 ad=9.7724p pd=45.3u as=0 ps=0 w=22.21u l=8u
VAUD36 avdd.t9 audit_d36 0
X36 audit_d36 avdd.t7 avdd.t8 avdd pfet_05v0 ad=8.25p pd=38.38u as=0 ps=0 w=18.75u l=8u
X37 rbit4top.t1 rbit3top.t2 avss ppolyf_u_1k r_width=6.6u r_length=16u
VAUD37 avss.t69 audit_d37 0
X38 audit_d37 avss.t67 avss.t68 avss nfet_05v0 ad=6.424p pd=30.08u as=0 ps=0 w=14.6u l=4u
VAUD38 vx3.t4 audit_d38 0
X39 audit_d38 psrg_m3_feed.t26 avdd.t637 avdd pfet_05v0 ad=7.37p pd=34.38u as=7.37p ps=34.38u w=16.75u l=2u
VAUD39 avdd.t517 audit_d39 0
X40 audit_d39 avdd.t515 avdd.t516 avdd pfet_05v0 ad=9.7724p pd=45.3u as=0 ps=0 w=22.21u l=8u
VAUD40 avss.t9 audit_d40 0
X41 audit_d40 avss.t7 avss.t8 avss nfet_05v0 ad=7.1896p pd=33.56u as=0 ps=0 w=16.34u l=8u
VAUD41 avdd.t329 audit_d41 0
X42 audit_d41 avdd.t327 avdd.t328 avdd pfet_05v0 ad=7.37p pd=34.38u as=0 ps=0 w=16.75u l=2u
VAUD42 avdd.t6 audit_d42 0
X43 audit_d42 avdd.t4 avdd.t5 avdd pfet_05v0 ad=8.25p pd=38.38u as=0 ps=0 w=18.75u l=8u
VAUD43 avdd.t270 audit_d43 0
X44 audit_d43 avdd.t268 avdd.t269 avdd pfet_05v0 ad=7.37p pd=34.38u as=0 ps=0 w=16.75u l=2u
VAUD44 vaux.t2 audit_d44 0
X45 audit_d44 psrg_m3_feed.t28 avdd.t648 avdd pfet_05v0 ad=4.4p pd=20.88u as=4.4p ps=20.88u w=10u l=2u
VAUD45 vbn.t3 audit_d45 0
X46 audit_d45 aux_gate avdd.t662 avdd pfet_05v0 ad=0.22p pd=1.88u as=0.22p ps=1.88u w=0.5u l=8u
VAUD46 avdd.t444 audit_d46 0
X47 audit_d46 avdd.t443 avdd.t444 avdd pfet_05v0 ad=24.1516p pd=0.11066m as=0 ps=0 w=54.89u l=4u
VAUD47 avdd.t301 audit_d47 0
X48 audit_d47 avdd.t300 avdd.t301 avdd pfet_05v0 ad=24.1516p pd=0.11066m as=0 ps=0 w=54.89u l=4u
X49 rfix2 rfix1 avss ppolyf_u_1k r_width=6.6u r_length=0.128m
VAUD48 avss.t6 audit_d48 0
X50 audit_d48 avss.t4 avss.t5 avss nfet_05v0 ad=7.1896p pd=33.56u as=0 ps=0 w=16.34u l=8u
VAUD49 avdd.t93 audit_d49 0
X51 audit_d49 avdd.t91 avdd.t92 avdd pfet_05v0 ad=8.25p pd=38.38u as=0 ps=0 w=18.75u l=8u
VAUD50 avdd.t541 audit_d50 0
X52 audit_d50 avdd.t539 avdd.t540 avdd pfet_05v0 ad=9.1344p pd=42.4u as=0 ps=0 w=20.76u l=4u
VAUD51 vref.t4 audit_d51 0
X53 audit_d51 vcasp vx3.t6 avdd pfet_05v0 ad=7.2248p pd=33.72u as=7.2248p ps=33.72u w=16.42u l=4u
VAUD52 avdd.t234 audit_d52 0
X54 audit_d52 avdd.t232 avdd.t233 avdd pfet_05v0 ad=7.2248p pd=33.72u as=0 ps=0 w=16.42u l=4u
X55 rbit6top.t1 rbit5top.t1 avss ppolyf_u_1k r_width=6.6u r_length=64u
VAUD53 psrg_vnc.t1 audit_d53 0
X56 audit_d53 psrg_vnc.t0 rb_mid avss nfet_05v0 ad=0.3124p pd=2.3u as=0.3124p ps=2.3u w=0.71u l=20u
VAUD54 avss.t156 audit_d54 0
X57 audit_d54 avss.t154 avss.t155 avss nfet_05v0 ad=7.1896p pd=33.56u as=0 ps=0 w=16.34u l=8u
VAUD55 avdd.t446 audit_d55 0
X58 audit_d55 avdd.t445 avdd.t446 avdd pfet_05v0 ad=24.1516p pd=0.11066m as=0 ps=0 w=54.89u l=4u
VAUD56 vx2.t2 audit_d56 0
X59 audit_d56 psrg_m3_feed.t18 avdd.t651 avdd pfet_05v0 ad=7.37p pd=34.38u as=7.37p ps=34.38u w=16.75u l=2u
VAUD57 avdd.t15 audit_d57 0
X60 audit_d57 avdd.t13 avdd.t14 avdd pfet_05v0 ad=8.25p pd=38.38u as=0 ps=0 w=18.75u l=8u
VAUD58 avdd.t431 audit_d58 0
X61 audit_d58 avdd.t429 avdd.t430 avdd pfet_05v0 ad=9.7724p pd=45.3u as=0 ps=0 w=22.21u l=8u
VAUD59 pm1.t4 audit_d59 0
X62 audit_d59 y1.t9 avdd.t628 avdd pfet_05v0 ad=9.1344p pd=42.4u as=9.1344p ps=42.4u w=20.76u l=4u
VAUD60 avss.t90 audit_d60 0
X63 audit_d60 avss.t88 avss.t89 avss nfet_05v0 ad=6.424p pd=30.08u as=0 ps=0 w=14.6u l=4u
VAUD61 avdd.t362 audit_d61 0
X64 audit_d61 avdd.t360 avdd.t361 avdd pfet_05v0 ad=7.37p pd=34.38u as=0 ps=0 w=16.75u l=2u
VAUD62 avss.t117 audit_d62 0
X65 audit_d62 avss.t115 avss.t116 avss nfet_05v0 ad=3.322p pd=15.98u as=0 ps=0 w=7.55u l=4u
VAUD63 avdd.t135 audit_d63 0
X66 audit_d63 avdd.t133 avdd.t134 avdd pfet_05v0 ad=8.3556p pd=38.86u as=0 ps=0 w=18.99u l=8u
VAUD64 avdd.t171 audit_d64 0
X67 audit_d64 avdd.t169 avdd.t170 avdd pfet_05v0 ad=8.338p pd=38.78u as=0 ps=0 w=18.95u l=8u
VAUD65 avdd.t198 audit_d65 0
X68 audit_d65 avdd.t196 avdd.t197 avdd pfet_05v0 ad=8.338p pd=38.78u as=0 ps=0 w=18.95u l=8u
VAUD66 avdd.t374 audit_d66 0
X69 audit_d66 avdd.t372 avdd.t373 avdd pfet_05v0 ad=7.2248p pd=33.72u as=0 ps=0 w=16.42u l=4u
VAUD67 psrg_m3_feed.t2 audit_d67 0
X70 audit_d67 vcasp vx2.t6 avdd pfet_05v0 ad=7.2248p pd=33.72u as=7.2248p ps=33.72u w=16.42u l=4u
VAUD68 pm1.t3 audit_d68 0
X71 audit_d68 y1.t12 avdd.t641 avdd pfet_05v0 ad=9.1344p pd=42.4u as=9.1344p ps=42.4u w=20.76u l=4u
VAUD69 vx2.t0 audit_d69 0
X72 audit_d69 psrg_m3_feed.t25 avdd.t636 avdd pfet_05v0 ad=7.37p pd=34.38u as=7.37p ps=34.38u w=16.75u l=2u
VAUD70 avdd.t320 audit_d70 0
X73 audit_d70 avdd.t318 avdd.t319 avdd pfet_05v0 ad=7.2248p pd=33.72u as=0 ps=0 w=16.42u l=4u
VAUD71 avdd.t132 audit_d71 0
X74 audit_d71 avdd.t130 avdd.t131 avdd pfet_05v0 ad=8.3556p pd=38.86u as=0 ps=0 w=18.99u l=8u
VAUD72 avdd.t168 audit_d72 0
X75 audit_d72 avdd.t166 avdd.t167 avdd pfet_05v0 ad=8.338p pd=38.78u as=0 ps=0 w=18.95u l=8u
VAUD73 avdd.t195 audit_d73 0
X76 audit_d73 avdd.t193 avdd.t194 avdd pfet_05v0 ad=8.338p pd=38.78u as=0 ps=0 w=18.95u l=8u
VAUD74 b2_b.t1 audit_d74 0
X77 audit_d74 b2.t0 dvdd.t3 dvdd pfet_03v3 ad=1.32p pd=6.88u as=1.32p ps=6.88u w=3u l=0.5u
VAUD75 avdd.t389 audit_d75 0
X78 audit_d75 avdd.t387 avdd.t388 avdd pfet_05v0 ad=7.37p pd=34.38u as=0 ps=0 w=16.75u l=2u
VAUD76 avdd.t416 audit_d76 0
X79 audit_d76 avdd.t415 avdd.t416 avdd pfet_05v0 ad=24.1516p pd=0.11066m as=0 ps=0 w=54.89u l=4u
VAUD77 y1.t5 audit_d77 0
X80 audit_d77 vbp_cas.t26 pm1.t10 avdd pfet_05v0 ad=9.7724p pd=45.3u as=9.7724p ps=45.3u w=22.21u l=8u
VAUD78 avdd.t526 audit_d78 0
X81 audit_d78 avdd.t524 avdd.t525 avdd pfet_05v0 ad=9.7724p pd=45.3u as=0 ps=0 w=22.21u l=8u
VAUD79 avss.t135 audit_d79 0
X82 audit_d79 avss.t133 avss.t134 avss nfet_05v0 ad=5.4164p pd=25.5u as=0 ps=0 w=12.31u l=8u
VAUD80 b5_b.t1 audit_d80 0
X83 audit_d80 b5.t0 dvdd.t6 dvdd pfet_03v3 ad=1.32p pd=6.88u as=1.32p ps=6.88u w=3u l=0.5u
VAUD81 avss.t174 audit_d81 0
X84 audit_d81 avss.t172 avss.t173 avss nfet_05v0 ad=8.1356p pd=37.86u as=0 ps=0 w=18.49u l=6u
VAUD82 avdd.t295 audit_d82 0
X85 audit_d82 avdd.t294 avdd.t295 avdd pfet_05v0 ad=24.1516p pd=0.11066m as=0 ps=0 w=54.89u l=4u
VAUD83 vbp_i.t9 audit_d83 0
X86 audit_d83 vbp_i.t8 avdd.t569 avdd pfet_05v0 ad=8.25p pd=38.38u as=8.25p ps=38.38u w=18.75u l=8u
VAUD84 avss.t27 audit_d84 0
X87 audit_d84 avss.t25 avss.t26 avss nfet_05v0 ad=7.1896p pd=33.56u as=0 ps=0 w=16.34u l=8u
VAUD85 avss.t132 audit_d85 0
X88 audit_d85 avss.t130 avss.t131 avss nfet_05v0 ad=5.4164p pd=25.5u as=0 ps=0 w=12.31u l=8u
VAUD86 vbp_bias.t11 audit_d86 0
X89 audit_d86 vbp_bias.t10 avdd.t656 avdd pfet_03v3 ad=8.3864p pd=39u as=8.3864p ps=39u w=19.06u l=8u
VAUD87 avdd.t81 audit_d87 0
X90 audit_d87 avdd.t79 avdd.t80 avdd pfet_05v0 ad=8.25p pd=38.38u as=0 ps=0 w=18.75u l=8u
VAUD88 avdd.t484 audit_d88 0
X91 audit_d88 avdd.t482 avdd.t483 avdd pfet_05v0 ad=9.1344p pd=42.4u as=0 ps=0 w=20.76u l=4u
VAUD89 vbp_bias.t27 audit_d89 0
X92 audit_d89 vbp_bias.t26 avdd.t632 avdd pfet_03v3 ad=8.3864p pd=39u as=8.3864p ps=39u w=19.06u l=8u
VAUD90 xf2.t4 audit_d90 0
X93 audit_d90 vbn_sink.t24 avss.t203 avss nfet_05v0 ad=7.1896p pd=33.56u as=7.1896p ps=33.56u w=16.34u l=8u
X94 vref.t11 avss.t220 cap_mim_2f0fF c_width=70.7u c_length=70.7u
VAUD91 vbn_sink.t15 audit_d91 0
X95 audit_d91 vbp_i.t28 avdd.t601 avdd pfet_05v0 ad=8.338p pd=38.78u as=8.338p ps=38.78u w=18.95u l=8u
VAUD92 vbn_fold.t11 audit_d92 0
X96 audit_d92 vbp_i.t41 avdd.t646 avdd pfet_05v0 ad=8.3556p pd=38.86u as=8.3556p ps=38.86u w=18.99u l=8u
VAUD93 rbit1top.t4 audit_d93 0
X97 audit_d93 b0_b.t3 rbit0top.t0 dvdd pfet_03v3 ad=17.6p pd=80.88u as=17.6p ps=80.88u w=40u l=0.28u
VAUD94 avdd.t550 audit_d94 0
X98 audit_d94 avdd.t548 avdd.t549 avdd pfet_05v0 ad=9.1344p pd=42.4u as=0 ps=0 w=20.76u l=4u
VAUD95 vbn_i.t3 audit_d95 0
X99 audit_d95 iref_gate.t3 avdd.t643 avdd pfet_05v0 ad=0.22p pd=1.88u as=0.22p ps=1.88u w=0.5u l=8u
VAUD96 avss.t192 audit_d96 0
X100 audit_d96 avss.t190 avss.t191 avss nfet_05v0 ad=8.1356p pd=37.86u as=0 ps=0 w=18.49u l=6u
X101 vref.t6 avss.t230 cap_mim_2f0fF c_width=70.7u c_length=70.7u
VAUD97 avdd.t162 audit_d97 0
X102 audit_d97 avdd.t160 avdd.t161 avdd pfet_05v0 ad=8.338p pd=38.78u as=0 ps=0 w=18.95u l=8u
VAUD98 avdd.t189 audit_d98 0
X103 audit_d98 avdd.t187 avdd.t188 avdd pfet_05v0 ad=8.338p pd=38.78u as=0 ps=0 w=18.95u l=8u
VAUD99 avdd.t3 audit_d99 0
X104 audit_d99 avdd.t1 avdd.t2 avdd pfet_05v0 ad=8.25p pd=38.38u as=0 ps=0 w=18.75u l=8u
VAUD100 iref_gate.t0 audit_d100 0
X105 audit_d100 vbp_i.t21 vsu1 avss nfet_05v0 ad=0.22p pd=1.88u as=0.22p ps=1.88u w=0.5u l=50u
VAUD101 vgn2.t2 audit_d101 0
X106 audit_d101 vbp_cas.t29 pm2.t6 avdd pfet_05v0 ad=9.7724p pd=45.3u as=9.7724p ps=45.3u w=22.21u l=8u
VAUD102 vbn_fold.t5 audit_d102 0
X107 audit_d102 vbp_i.t51 avdd.t593 avdd pfet_05v0 ad=8.3556p pd=38.86u as=8.3556p ps=38.86u w=18.99u l=8u
X108 rbit0top.t6 rfix2 avss ppolyf_u_1k r_width=6.6u r_length=0.128m
VAUD103 avss.t183 audit_d103 0
X109 audit_d103 avss.t181 avss.t182 avss nfet_05v0 ad=8.1356p pd=37.86u as=0 ps=0 w=18.49u l=6u
VAUD104 vsp.t12 audit_d104 0
X110 audit_d104 vbp_tail.t12 avdd.t622 avdd pfet_03v3 ad=12.7204p pd=58.7u as=12.7204p ps=58.7u w=28.91u l=6u
VAUD105 avdd.t371 audit_d105 0
X111 audit_d105 avdd.t369 avdd.t370 avdd pfet_05v0 ad=7.2248p pd=33.72u as=0 ps=0 w=16.42u l=4u
VAUD106 rbit4top.t0 audit_d106 0
X112 audit_d106 b3_b.t2 rbit3top.t0 dvdd pfet_03v3 ad=13.2p pd=60.88u as=13.2p ps=60.88u w=30u l=0.28u
VAUD107 avdd.t258 audit_d107 0
X113 audit_d107 avdd.t256 avdd.t257 avdd pfet_05v0 ad=7.2248p pd=33.72u as=0 ps=0 w=16.42u l=4u
VAUD108 su_state.t2 audit_d108 0
X114 audit_d108 vsu avdd.t642 avdd pfet_05v0 ad=0.44p pd=2.88u as=0.44p ps=2.88u w=1u l=8u
VAUD109 xf1.t2 audit_d109 0
X115 audit_d109 vbn_sink.t27 avss.t198 avss nfet_05v0 ad=7.1896p pd=33.56u as=7.1896p ps=33.56u w=16.34u l=8u
VAUD110 avdd.t75 audit_d110 0
X116 audit_d110 avdd.t73 avdd.t74 avdd pfet_05v0 ad=8.3556p pd=38.86u as=0 ps=0 w=18.99u l=8u
VAUD111 rbit5top.t4 audit_d111 0
X117 audit_d111 b4_b.t2 rbit4top.t5 dvdd pfet_03v3 ad=6.6p pd=30.88u as=6.6p ps=30.88u w=15u l=0.28u
VAUD112 avss.t99 audit_d112 0
X118 audit_d112 avss.t97 avss.t98 avss nfet_05v0 ad=6.424p pd=30.08u as=0 ps=0 w=14.6u l=4u
VAUD113 avdd.t216 audit_d113 0
X119 audit_d113 avdd.t214 avdd.t215 avdd pfet_05v0 ad=8.338p pd=38.78u as=0 ps=0 w=18.95u l=8u
VAUD114 vbn_i.t1 audit_d114 0
X120 audit_d114 vbp_i.t54 avdd.t603 avdd pfet_05v0 ad=8.25p pd=38.38u as=8.25p ps=38.38u w=18.75u l=8u
VAUD115 xf2.t0 audit_d115 0
X121 audit_d115 vbn_sink.t28 avss.t1 avss nfet_05v0 ad=7.1896p pd=33.56u as=7.1896p ps=33.56u w=16.34u l=8u
VAUD116 avss.t18 audit_d116 0
X122 audit_d116 avss.t16 avss.t17 avss nfet_05v0 ad=7.1896p pd=33.56u as=0 ps=0 w=16.34u l=8u
VAUD117 avdd.t562 audit_d117 0
X123 audit_d117 avdd.t560 avdd.t561 avdd pfet_05v0 ad=9.1344p pd=42.4u as=0 ps=0 w=20.76u l=4u
VAUD118 avss.t153 audit_d118 0
X124 audit_d118 avss.t151 avss.t152 avss nfet_05v0 ad=7.1896p pd=33.56u as=0 ps=0 w=16.34u l=8u
VAUD119 avdd.t380 audit_d119 0
X125 audit_d119 avdd.t378 avdd.t379 avdd pfet_05v0 ad=7.2248p pd=33.72u as=0 ps=0 w=16.42u l=4u
VAUD120 xf1.t6 audit_d120 0
X126 audit_d120 v1.t3 vsp.t6 avdd pfet_05v0 ad=24.1516p pd=0.11066m as=24.1516p ps=0.11066m w=54.89u l=4u
VAUD121 avss.t51 audit_d121 0
X127 audit_d121 avss.t49 avss.t50 avss nfet_05v0 ad=5.4164p pd=25.5u as=0 ps=0 w=12.31u l=8u
VAUD122 rbit2top.t5 audit_d122 0
X128 audit_d122 b1_b.t4 rbit1top.t12 dvdd pfet_03v3 ad=17.6p pd=80.88u as=17.6p ps=80.88u w=40u l=0.28u
VAUD123 psrg_m3_feed.t1 audit_d123 0
X129 audit_d123 psrg_vnc.t10 psrg_m3_protected.t1 avss nfet_05v0 ad=6.424p pd=30.08u as=6.424p ps=30.08u w=14.6u l=4u
VAUD124 avdd.t213 audit_d124 0
X130 audit_d124 avdd.t211 avdd.t212 avdd pfet_05v0 ad=8.338p pd=38.78u as=0 ps=0 w=18.95u l=8u
VAUD125 rbit4top.t3 audit_d125 0
X131 audit_d125 b4.t2 rbit5top.t2 dvss nfet_03v3 ad=2.2p pd=10.88u as=2.2p ps=10.88u w=5u l=0.28u
VAUD126 avdd.t57 audit_d126 0
X132 audit_d126 avdd.t55 avdd.t56 avdd pfet_05v0 ad=8.3556p pd=38.86u as=0 ps=0 w=18.99u l=8u
VAUD127 vbn_sink.t20 audit_d127 0
X133 audit_d127 vbn_sink.t19 avss.t239 avss nfet_05v0 ad=5.4164p pd=25.5u as=5.4164p ps=25.5u w=12.31u l=8u
VAUD128 avdd.t309 audit_d128 0
X134 audit_d128 avdd.t308 avdd.t309 avdd pfet_05v0 ad=24.1516p pd=0.11066m as=0 ps=0 w=54.89u l=4u
VAUD129 avdd.t249 audit_d129 0
X135 audit_d129 avdd.t247 avdd.t248 avdd pfet_05v0 ad=7.2248p pd=33.72u as=0 ps=0 w=16.42u l=4u
VAUD130 vbp_tail.t4 audit_d130 0
X136 audit_d130 vbp_tail.t3 avdd.t655 avdd pfet_03v3 ad=6.05p pd=28.38u as=6.05p ps=28.38u w=13.75u l=6u
VAUD131 avdd.t323 audit_d131 0
X137 audit_d131 avdd.t321 avdd.t322 avdd pfet_05v0 ad=7.2248p pd=33.72u as=0 ps=0 w=16.42u l=4u
VAUD132 avdd.t448 audit_d132 0
X138 audit_d132 avdd.t447 avdd.t448 avdd pfet_05v0 ad=24.1516p pd=0.11066m as=0 ps=0 w=54.89u l=4u
VAUD133 avss.t102 audit_d133 0
X139 audit_d133 avss.t100 avss.t101 avss nfet_05v0 ad=6.424p pd=30.08u as=0 ps=0 w=14.6u l=4u
VAUD134 vbp_cas.t1 audit_d134 0
X140 audit_d134 vbp_cas.t0 vbp_bias.t4 avdd pfet_05v0 ad=8.3292p pd=38.74u as=8.3292p ps=38.74u w=18.93u l=8u
VAUD135 pm2.t0 audit_d135 0
X141 audit_d135 y1.t18 avdd.t661 avdd pfet_05v0 ad=9.1344p pd=42.4u as=9.1344p ps=42.4u w=20.76u l=4u
VAUD136 avdd.t273 audit_d136 0
X142 audit_d136 avdd.t271 avdd.t272 avdd pfet_05v0 ad=7.37p pd=34.38u as=0 ps=0 w=16.75u l=2u
VAUD137 xf2.t8 audit_d137 0
X143 audit_d137 v2.t5 vsp.t10 avdd pfet_05v0 ad=24.1516p pd=0.11066m as=24.1516p ps=0.11066m w=54.89u l=4u
VAUD138 vaux.t1 audit_d138 0
X144 audit_d138 psrg_m3_feed.t27 avdd.t647 avdd pfet_05v0 ad=4.4p pd=20.88u as=4.4p ps=20.88u w=10u l=2u
VAUD139 avdd.t520 audit_d139 0
X145 audit_d139 avdd.t518 avdd.t519 avdd pfet_05v0 ad=9.7724p pd=45.3u as=0 ps=0 w=22.21u l=8u
VAUD140 su_state.t1 audit_d140 0
X146 audit_d140 vbp_tail.t13 avdd.t623 avdd pfet_05v0 ad=0.44p pd=2.88u as=0.44p ps=2.88u w=1u l=8u
VAUD141 avdd.t442 audit_d141 0
X147 audit_d141 avdd.t441 avdd.t442 avdd pfet_05v0 ad=24.1516p pd=0.11066m as=0 ps=0 w=54.89u l=4u
VAUD142 avss.t93 audit_d142 0
X148 audit_d142 avss.t91 avss.t92 avss nfet_05v0 ad=6.424p pd=30.08u as=0 ps=0 w=14.6u l=4u
VAUD143 avdd.t222 audit_d143 0
X149 audit_d143 avdd.t220 avdd.t221 avdd pfet_05v0 ad=7.2248p pd=33.72u as=0 ps=0 w=16.42u l=4u
VAUD144 avdd.t556 audit_d144 0
X150 audit_d144 avdd.t554 avdd.t555 avdd pfet_05v0 ad=9.1344p pd=42.4u as=0 ps=0 w=20.76u l=4u
VAUD145 avdd.t192 audit_d145 0
X151 audit_d145 avdd.t190 avdd.t191 avdd pfet_05v0 ad=8.338p pd=38.78u as=0 ps=0 w=18.95u l=8u
VAUD146 pm2.t3 audit_d146 0
X152 audit_d146 y1.t11 avdd.t631 avdd pfet_05v0 ad=9.1344p pd=42.4u as=9.1344p ps=42.4u w=20.76u l=4u
VAUD147 avdd.t332 audit_d147 0
X153 audit_d147 avdd.t330 avdd.t331 avdd pfet_05v0 ad=7.2248p pd=33.72u as=0 ps=0 w=16.42u l=4u
VAUD148 avdd.t368 audit_d148 0
X154 audit_d148 avdd.t366 avdd.t367 avdd pfet_05v0 ad=7.2248p pd=33.72u as=0 ps=0 w=16.42u l=4u
VAUD149 psrg_vnc.t4 audit_d149 0
X155 audit_d149 vbp_i.t18 avdd.t610 avdd pfet_05v0 ad=7.8056p pd=36.36u as=7.8056p ps=36.36u w=17.74u l=4u
VAUD150 avdd.t114 audit_d150 0
X156 audit_d150 avdd.t112 avdd.t113 avdd pfet_05v0 ad=8.25p pd=38.38u as=0 ps=0 w=18.75u l=8u
VAUD151 avdd.t207 audit_d151 0
X157 audit_d151 avdd.t205 avdd.t206 avdd pfet_05v0 ad=8.338p pd=38.78u as=0 ps=0 w=18.95u l=8u
VAUD152 xf1.t11 audit_d152 0
X158 audit_d152 vbn_sink.t31 avss.t235 avss nfet_05v0 ad=7.1896p pd=33.56u as=7.1896p ps=33.56u w=16.34u l=8u
VAUD153 vbn_sink.t10 audit_d153 0
X159 audit_d153 vbp_i.t23 avdd.t585 avdd pfet_05v0 ad=8.338p pd=38.78u as=8.338p ps=38.78u w=18.95u l=8u
VAUD154 vcasp audit_d154 0
X160 audit_d154 vcasp avdd.t639 avdd pfet_05v0 ad=0.396p pd=2.68u as=0.396p ps=2.68u w=0.9u l=2u
VAUD155 avss.t129 audit_d155 0
X161 audit_d155 avss.t127 avss.t128 avss nfet_05v0 ad=5.4164p pd=25.5u as=0 ps=0 w=12.31u l=8u
VAUD156 avdd.t78 audit_d156 0
X162 audit_d156 avdd.t76 avdd.t77 avdd pfet_05v0 ad=8.3556p pd=38.86u as=0 ps=0 w=18.99u l=8u
VAUD157 vx2.t3 audit_d157 0
X163 audit_d157 psrg_m3_feed.t17 avdd.t617 avdd pfet_05v0 ad=7.37p pd=34.38u as=7.37p ps=34.38u w=16.75u l=2u
VAUD158 vbp_bias.t13 audit_d158 0
X164 audit_d158 vbp_bias.t12 avdd.t657 avdd pfet_03v3 ad=8.3864p pd=39u as=8.3864p ps=39u w=19.06u l=8u
VAUD159 avdd.t377 audit_d159 0
X165 audit_d159 avdd.t375 avdd.t376 avdd pfet_05v0 ad=7.2248p pd=33.72u as=0 ps=0 w=16.42u l=4u
X166 rfix0 vref.t5 avss ppolyf_u_1k r_width=6.6u r_length=0.128m
VAUD160 avss.t126 audit_d160 0
X167 audit_d160 avss.t124 avss.t125 avss nfet_05v0 ad=5.4164p pd=25.5u as=0 ps=0 w=12.31u l=8u
VAUD161 avdd.t350 audit_d161 0
X168 audit_d161 avdd.t348 avdd.t349 avdd pfet_05v0 ad=7.2248p pd=33.72u as=0 ps=0 w=16.42u l=4u
VAUD162 avdd.t243 audit_d162 0
X169 audit_d162 avdd.t241 avdd.t242 avdd pfet_05v0 ad=7.2248p pd=33.72u as=0 ps=0 w=16.42u l=4u
VAUD163 vbn_fold.t0 audit_d163 0
X170 audit_d163 vbp_i.t46 avdd.t563 avdd pfet_05v0 ad=8.3556p pd=38.86u as=8.3556p ps=38.86u w=18.99u l=8u
VAUD164 pm2.t2 audit_d164 0
X171 audit_d164 y1.t14 avdd.t625 avdd pfet_05v0 ad=9.1344p pd=42.4u as=9.1344p ps=42.4u w=20.76u l=4u
VAUD165 vref.t1 audit_d165 0
X172 audit_d165 vcasp vx3.t7 avdd pfet_05v0 ad=7.2248p pd=33.72u as=7.2248p ps=33.72u w=16.42u l=4u
VAUD166 avdd.t36 audit_d166 0
X173 audit_d166 avdd.t34 avdd.t35 avdd pfet_05v0 ad=8.25p pd=38.38u as=0 ps=0 w=18.75u l=8u
VAUD167 y1.t4 audit_d167 0
X174 audit_d167 vbp_cas.t23 pm1.t9 avdd pfet_05v0 ad=9.7724p pd=45.3u as=9.7724p ps=45.3u w=22.21u l=8u
VAUD168 avdd.t159 audit_d168 0
X175 audit_d168 avdd.t157 avdd.t158 avdd pfet_05v0 ad=8.338p pd=38.78u as=0 ps=0 w=18.95u l=8u
VAUD169 vsu2 audit_d169 0
X176 audit_d169 vbp_i.t20 avss.t0 avss nfet_05v0 ad=0.22p pd=1.88u as=0.22p ps=1.88u w=0.5u l=50u
VAUD170 vbn_sink.t5 audit_d170 0
X177 audit_d170 vbp_i.t35 avdd.t575 avdd pfet_05v0 ad=8.338p pd=38.78u as=8.338p ps=38.78u w=18.95u l=8u
VAUD171 avdd.t511 audit_d171 0
X178 audit_d171 avdd.t509 avdd.t510 avdd pfet_05v0 ad=9.7724p pd=45.3u as=0 ps=0 w=22.21u l=8u
VAUD172 avdd.t535 audit_d172 0
X179 audit_d172 avdd.t533 avdd.t534 avdd pfet_05v0 ad=9.1344p pd=42.4u as=0 ps=0 w=20.76u l=4u
VAUD173 vx1.t0 audit_d173 0
X180 audit_d173 psrg_m3_feed.t24 avdd.t635 avdd pfet_05v0 ad=7.37p pd=34.38u as=7.37p ps=34.38u w=16.75u l=2u
VAUD174 avdd.t303 audit_d174 0
X181 audit_d174 avdd.t302 avdd.t303 avdd pfet_05v0 ad=24.1516p pd=0.11066m as=0 ps=0 w=54.89u l=4u
VAUD175 avdd.t156 audit_d175 0
X182 audit_d175 avdd.t154 avdd.t155 avdd pfet_05v0 ad=8.338p pd=38.78u as=0 ps=0 w=18.95u l=8u
VAUD176 vsp.t0 audit_d176 0
X183 audit_d176 vbp_tail.t9 avdd.t607 avdd pfet_03v3 ad=12.7204p pd=58.7u as=12.7204p ps=58.7u w=28.91u l=6u
X184 rbit3top.t1 rbit2top.t0 avss ppolyf_u_1k r_width=6.6u r_length=8u
VAUD177 avdd.t496 audit_d177 0
X185 audit_d177 avdd.t494 avdd.t495 avdd pfet_05v0 ad=9.1344p pd=42.4u as=0 ps=0 w=20.76u l=4u
VAUD178 vbn_sink.t7 audit_d178 0
X186 audit_d178 vbp_i.t25 avdd.t577 avdd pfet_05v0 ad=8.338p pd=38.78u as=8.338p ps=38.78u w=18.95u l=8u
VAUD179 avss.t180 audit_d179 0
X187 audit_d179 avss.t178 avss.t179 avss nfet_05v0 ad=8.1356p pd=37.86u as=0 ps=0 w=18.49u l=6u
VAUD180 xf1.t9 audit_d180 0
X188 audit_d180 v1.t5 vsp.t4 avdd pfet_05v0 ad=24.1516p pd=0.11066m as=24.1516p ps=0.11066m w=54.89u l=4u
VAUD181 avdd.t529 audit_d181 0
X189 audit_d181 avdd.t527 avdd.t528 avdd pfet_05v0 ad=9.7724p pd=45.3u as=0 ps=0 w=22.21u l=8u
X190 vref.t13 avss.t216 cap_mim_2f0fF c_width=70.7u c_length=70.7u
VAUD182 avdd.t69 audit_d182 0
X191 audit_d182 avdd.t67 avdd.t68 avdd pfet_05v0 ad=8.25p pd=38.38u as=0 ps=0 w=18.75u l=8u
VAUD183 avss.t15 audit_d183 0
X192 audit_d183 avss.t13 avss.t14 avss nfet_05v0 ad=7.1896p pd=33.56u as=0 ps=0 w=16.34u l=8u
X193 vref.t8 avss.t226 cap_mim_2f0fF c_width=70.7u c_length=70.7u
VAUD184 avdd.t299 audit_d184 0
X194 audit_d184 avdd.t298 avdd.t299 avdd pfet_05v0 ad=24.1516p pd=0.11066m as=0 ps=0 w=54.89u l=4u
VAUD185 vbn_fold.t2 audit_d185 0
X195 audit_d185 vbp_i.t48 avdd.t579 avdd pfet_05v0 ad=8.3556p pd=38.86u as=8.3556p ps=38.86u w=18.99u l=8u
VAUD186 avss.t195 audit_d186 0
X196 audit_d186 avss.t193 avss.t194 avss nfet_05v0 ad=8.1356p pd=37.86u as=0 ps=0 w=18.49u l=6u
VAUD187 vbp_cas.t5 audit_d187 0
X197 audit_d187 vbp_cas.t4 vbp_bias.t9 avdd pfet_05v0 ad=8.3292p pd=38.74u as=8.3292p ps=38.74u w=18.93u l=8u
VAUD188 vbp_i.t5 audit_d188 0
X198 audit_d188 vbp_i.t4 avdd.t609 avdd pfet_05v0 ad=8.25p pd=38.38u as=8.25p ps=38.38u w=18.75u l=8u
VAUD189 vbn_sink.t18 audit_d189 0
X199 audit_d189 vbn_sink.t17 avss.t208 avss nfet_05v0 ad=5.4164p pd=25.5u as=5.4164p ps=25.5u w=12.31u l=8u
VAUD190 vbn_fold.t13 audit_d190 0
X200 audit_d190 vbp_i.t45 avdd.t659 avdd pfet_05v0 ad=8.3556p pd=38.86u as=8.3556p ps=38.86u w=18.99u l=8u
VAUD191 psrg_m3_feed.t4 audit_d191 0
X201 audit_d191 vcasp vx2.t9 avdd pfet_05v0 ad=7.2248p pd=33.72u as=7.2248p ps=33.72u w=16.42u l=4u
VAUD192 psrg_m3_feed.t6 audit_d192 0
X202 audit_d192 vcasp vx2.t7 avdd pfet_05v0 ad=7.2248p pd=33.72u as=7.2248p ps=33.72u w=16.42u l=4u
VAUD193 psrg_vnc.t7 audit_d193 0
X203 audit_d193 vbp_i.t15 avdd.t664 avdd pfet_05v0 ad=7.8056p pd=36.36u as=7.8056p ps=36.36u w=17.74u l=4u
VAUD194 avss.t42 audit_d194 0
X204 audit_d194 avss.t40 avss.t41 avss nfet_05v0 ad=5.4164p pd=25.5u as=0 ps=0 w=12.31u l=8u
VAUD195 vsp.t11 audit_d195 0
X205 audit_d195 vbp_tail.t11 avdd.t621 avdd pfet_03v3 ad=12.7204p pd=58.7u as=12.7204p ps=58.7u w=28.91u l=6u
VAUD196 avdd.t120 audit_d196 0
X206 audit_d196 avdd.t118 avdd.t119 avdd pfet_05v0 ad=8.3556p pd=38.86u as=0 ps=0 w=18.99u l=8u
VAUD197 avdd.t365 audit_d197 0
X207 audit_d197 avdd.t363 avdd.t364 avdd pfet_05v0 ad=7.37p pd=34.38u as=0 ps=0 w=16.75u l=2u
VAUD198 vbp_tail.t2 audit_d198 0
X208 audit_d198 vbp_tail.t1 avdd.t620 avdd pfet_03v3 ad=6.05p pd=28.38u as=6.05p ps=28.38u w=13.75u l=6u
VAUD199 vbp_bias.t17 audit_d199 0
X209 audit_d199 vbp_bias.t16 avdd.t618 avdd pfet_03v3 ad=8.3864p pd=39u as=8.3864p ps=39u w=19.06u l=8u
VAUD200 avdd.t450 audit_d200 0
X210 audit_d200 avdd.t449 avdd.t450 avdd pfet_05v0 ad=24.1516p pd=0.11066m as=0 ps=0 w=54.89u l=4u
VAUD201 vbp_cas.t3 audit_d201 0
X211 audit_d201 vbp_cas.t2 vbp_bias.t8 avdd pfet_05v0 ad=8.3292p pd=38.74u as=8.3292p ps=38.74u w=18.93u l=8u
VAUD202 psrg_m3_feed.t5 audit_d202 0
X212 audit_d202 vcasp vx2.t10 avdd pfet_05v0 ad=7.2248p pd=33.72u as=7.2248p ps=33.72u w=16.42u l=4u
VAUD203 avdd.t410 audit_d203 0
X213 audit_d203 avdd.t408 avdd.t409 avdd pfet_05v0 ad=7.37p pd=34.38u as=0 ps=0 w=16.75u l=2u
X214 rfix1 rfix0 avss ppolyf_u_1k r_width=6.6u r_length=0.128m
VAUD204 avss.t96 audit_d204 0
X215 audit_d204 avss.t94 avss.t95 avss nfet_05v0 ad=6.424p pd=30.08u as=0 ps=0 w=14.6u l=4u
VAUD205 vbp_cas.t9 audit_d205 0
X216 audit_d205 vbp_cas.t8 vbp_bias.t7 avdd pfet_05v0 ad=8.3292p pd=38.74u as=8.3292p ps=38.74u w=18.93u l=8u
VAUD206 vbp_cas.t17 audit_d206 0
X217 audit_d206 vbp_cas.t16 vbp_bias.t0 avdd pfet_05v0 ad=8.3292p pd=38.74u as=8.3292p ps=38.74u w=18.93u l=8u
VAUD207 avdd.t111 audit_d207 0
X218 audit_d207 avdd.t109 avdd.t110 avdd pfet_05v0 ad=8.25p pd=38.38u as=0 ps=0 w=18.75u l=8u
VAUD208 avdd.t204 audit_d208 0
X219 audit_d208 avdd.t202 avdd.t203 avdd pfet_05v0 ad=8.338p pd=38.78u as=0 ps=0 w=18.95u l=8u
VAUD209 xf2.t10 audit_d209 0
X220 audit_d209 vbn_sink.t32 avss.t236 avss nfet_05v0 ad=7.1896p pd=33.56u as=7.1896p ps=33.56u w=16.34u l=8u
VAUD210 avdd.t307 audit_d210 0
X221 audit_d210 avdd.t306 avdd.t307 avdd pfet_05v0 ad=24.1516p pd=0.11066m as=0 ps=0 w=54.89u l=4u
VAUD211 avdd.t246 audit_d211 0
X222 audit_d211 avdd.t244 avdd.t245 avdd pfet_05v0 ad=7.2248p pd=33.72u as=0 ps=0 w=16.42u l=4u
VAUD212 avdd.t559 audit_d212 0
X223 audit_d212 avdd.t557 avdd.t558 avdd pfet_05v0 ad=9.1344p pd=42.4u as=0 ps=0 w=20.76u l=4u
X224 avss.t205 net3.t0 avdd pplus_u r_width=1u r_length=0.23253m
VAUD213 vbn_i.t7 audit_d213 0
X225 audit_d213 vbn_i.t6 avss.t232 avss nfet_05v0 ad=3.4232p pd=16.44u as=3.4232p ps=16.44u w=7.78u l=8u
VAUD214 psrg_m3_feed.t3 audit_d214 0
X226 audit_d214 vcasp vx2.t8 avdd pfet_05v0 ad=7.2248p pd=33.72u as=7.2248p ps=33.72u w=16.42u l=4u
VAUD215 y1.t0 audit_d215 0
X227 audit_d215 psrg_vnc.t9 psrg_mf1_protected.t0 avss nfet_05v0 ad=8.1356p pd=37.86u as=8.1356p ps=37.86u w=18.49u l=6u
VAUD216 avdd.t335 audit_d216 0
X228 audit_d216 avdd.t333 avdd.t334 avdd pfet_05v0 ad=7.2248p pd=33.72u as=0 ps=0 w=16.42u l=4u
VAUD217 avdd.t487 audit_d217 0
X229 audit_d217 avdd.t485 avdd.t486 avdd pfet_05v0 ad=9.1344p pd=42.4u as=0 ps=0 w=20.76u l=4u
VAUD218 pm2.t4 audit_d218 0
X230 audit_d218 y1.t10 avdd.t630 avdd pfet_05v0 ad=9.1344p pd=42.4u as=9.1344p ps=42.4u w=20.76u l=4u
VAUD219 avdd.t505 audit_d219 0
X231 audit_d219 avdd.t503 avdd.t504 avdd pfet_05v0 ad=9.1344p pd=42.4u as=0 ps=0 w=20.76u l=4u
X232 vq2.t0 v2.t2 avss ppolyf_u_1k r_width=4u r_length=42.1u
VAUD220 avdd.t201 audit_d220 0
X233 audit_d220 avdd.t199 avdd.t200 avdd pfet_05v0 ad=8.338p pd=38.78u as=0 ps=0 w=18.95u l=8u
VAUD221 xf2.t7 audit_d221 0
X234 audit_d221 v2.t3 vsp.t9 avdd pfet_05v0 ad=24.1516p pd=0.11066m as=24.1516p ps=0.11066m w=54.89u l=4u
VAUD222 vbp_i.t10 audit_d222 0
X235 audit_d222 vbn_i.t10 net4.t0 avss nfet_05v0 ad=4.0172p pd=19.14u as=4.0172p ps=19.14u w=9.13u l=8u
VAUD223 avss.t45 audit_d223 0
X236 audit_d223 avss.t43 avss.t44 avss nfet_05v0 ad=7.1896p pd=33.56u as=0 ps=0 w=16.34u l=8u
VAUD224 psrg_vnc.t3 audit_d224 0
X237 audit_d224 vbp_i.t17 avdd.t595 avdd pfet_05v0 ad=7.8056p pd=36.36u as=7.8056p ps=36.36u w=17.74u l=4u
VAUD225 avdd.t45 audit_d225 0
X238 audit_d225 avdd.t43 avdd.t44 avdd pfet_05v0 ad=8.3556p pd=38.86u as=0 ps=0 w=18.99u l=8u
VAUD226 avdd.t33 audit_d226 0
X239 audit_d226 avdd.t31 avdd.t32 avdd pfet_05v0 ad=8.25p pd=38.38u as=0 ps=0 w=18.75u l=8u
VAUD227 rbit3top.t3 audit_d227 0
X240 audit_d227 b3.t2 rbit4top.t2 dvss nfet_03v3 ad=4.4p pd=20.88u as=4.4p ps=20.88u w=10u l=0.28u
VAUD228 avdd.t458 audit_d228 0
X241 audit_d228 avdd.t457 avdd.t458 avdd pfet_05v0 ad=24.1516p pd=0.11066m as=0 ps=0 w=54.89u l=4u
VAUD229 avdd.t293 audit_d229 0
X242 audit_d229 avdd.t292 avdd.t293 avdd pfet_05v0 ad=24.1516p pd=0.11066m as=0 ps=0 w=54.89u l=4u
VAUD230 avdd.t72 audit_d230 0
X243 audit_d230 avdd.t70 avdd.t71 avdd pfet_05v0 ad=8.25p pd=38.38u as=0 ps=0 w=18.75u l=8u
VAUD231 avss.t72 audit_d231 0
X244 audit_d231 avss.t70 avss.t71 avss nfet_05v0 ad=6.424p pd=30.08u as=0 ps=0 w=14.6u l=4u
VAUD232 avdd.t42 audit_d232 0
X245 audit_d232 avdd.t40 avdd.t41 avdd pfet_05v0 ad=8.3556p pd=38.86u as=0 ps=0 w=18.99u l=8u
VAUD233 avdd.t276 audit_d233 0
X246 audit_d233 avdd.t274 avdd.t275 avdd pfet_05v0 ad=7.37p pd=34.38u as=0 ps=0 w=16.75u l=2u
VAUD234 avdd.t353 audit_d234 0
X247 audit_d234 avdd.t351 avdd.t352 avdd pfet_05v0 ad=7.2248p pd=33.72u as=0 ps=0 w=16.42u l=4u
VAUD235 vbp_tail.t0 audit_d235 0
X248 audit_d235 vbn_i.t9 avss.t206 avss nfet_05v0 ad=6.138p pd=28.78u as=6.138p ps=28.78u w=13.95u l=8u
VAUD236 vbp_bias.t15 audit_d236 0
X249 audit_d236 vbp_bias.t14 avdd.t614 avdd pfet_03v3 ad=8.3864p pd=39u as=8.3864p ps=39u w=19.06u l=8u
VAUD237 avdd.t452 audit_d237 0
X250 audit_d237 avdd.t451 avdd.t452 avdd pfet_05v0 ad=24.1516p pd=0.11066m as=0 ps=0 w=54.89u l=4u
VAUD238 avdd.t481 audit_d238 0
X251 audit_d238 avdd.t479 avdd.t480 avdd pfet_05v0 ad=9.1344p pd=42.4u as=0 ps=0 w=20.76u l=4u
VAUD239 vsua audit_d239 0
X252 audit_d239 vsua auxsu1 avss nfet_05v0 ad=0.44p pd=2.88u as=0.44p ps=2.88u w=1u l=2u
VAUD240 avdd.t538 audit_d240 0
X253 audit_d240 avdd.t536 avdd.t537 avdd pfet_05v0 ad=9.1344p pd=42.4u as=0 ps=0 w=20.76u l=4u
X254 vgn2.t7 avss.t210 cap_mim_2f0fF c_width=59u c_length=59u
VAUD241 vbn_sink.t11 audit_d241 0
X255 audit_d241 vbp_i.t26 avdd.t588 avdd pfet_05v0 ad=8.338p pd=38.78u as=8.338p ps=38.78u w=18.95u l=8u
VAUD242 avdd.t123 audit_d242 0
X256 audit_d242 avdd.t121 avdd.t122 avdd pfet_05v0 ad=8.3556p pd=38.86u as=0 ps=0 w=18.99u l=8u
VAUD243 rbit1top.t0 audit_d243 0
X257 audit_d243 b0_b.t7 rbit0top.t5 dvdd pfet_03v3 ad=17.6p pd=80.88u as=17.6p ps=80.88u w=40u l=0.28u
VAUD244 rbit1top.t3 audit_d244 0
X258 audit_d244 b0_b.t4 rbit0top.t1 dvdd pfet_03v3 ad=17.6p pd=80.88u as=17.6p ps=80.88u w=40u l=0.28u
VAUD245 b3_b.t0 audit_d245 0
X259 audit_d245 b3.t1 dvss.t0 dvss nfet_03v3 ad=0.44p pd=2.88u as=0.44p ps=2.88u w=1u l=0.5u
VAUD246 avdd.t102 audit_d246 0
X260 audit_d246 avdd.t100 avdd.t101 avdd pfet_05v0 ad=8.25p pd=38.38u as=0 ps=0 w=18.75u l=8u
VAUD247 vbn_sink.t12 audit_d247 0
X261 audit_d247 vbp_i.t27 avdd.t589 avdd pfet_05v0 ad=8.338p pd=38.78u as=8.338p ps=38.78u w=18.95u l=8u
VAUD248 vbn_fold.t10 audit_d248 0
X262 audit_d248 vbp_i.t40 avdd.t645 avdd pfet_05v0 ad=8.3556p pd=38.86u as=8.3556p ps=38.86u w=18.99u l=8u
VAUD249 vbn_fold.t3 audit_d249 0
X263 audit_d249 vbp_i.t49 avdd.t580 avdd pfet_05v0 ad=8.3556p pd=38.86u as=8.3556p ps=38.86u w=18.99u l=8u
VAUD250 vx1.t5 audit_d250 0
X264 audit_d250 psrg_m3_feed.t10 avdd.t583 avdd pfet_05v0 ad=7.37p pd=34.38u as=7.37p ps=34.38u w=16.75u l=2u
VAUD251 b5_b.t0 audit_d251 0
X265 audit_d251 b5.t2 dvss.t6 dvss nfet_03v3 ad=0.44p pd=2.88u as=0.44p ps=2.88u w=1u l=0.5u
VAUD252 avss.t84 audit_d252 0
X266 audit_d252 avss.t82 avss.t83 avss nfet_05v0 ad=3.322p pd=15.98u as=0 ps=0 w=7.55u l=4u
VAUD253 vbn_fold.t4 audit_d253 0
X267 audit_d253 vbp_i.t50 avdd.t592 avdd pfet_05v0 ad=8.3556p pd=38.86u as=8.3556p ps=38.86u w=18.99u l=8u
VAUD254 avss.t186 audit_d254 0
X268 audit_d254 avss.t184 avss.t185 avss nfet_05v0 ad=8.1356p pd=37.86u as=0 ps=0 w=18.49u l=6u
VAUD255 avdd.t24 audit_d255 0
X269 audit_d255 avdd.t22 avdd.t23 avdd pfet_05v0 ad=8.25p pd=38.38u as=0 ps=0 w=18.75u l=8u
VAUD256 avss.t177 audit_d256 0
X270 audit_d256 avss.t175 avss.t176 avss nfet_05v0 ad=8.1356p pd=37.86u as=0 ps=0 w=18.49u l=6u
VAUD257 vbn_sink.t8 audit_d257 0
X271 audit_d257 vbp_i.t30 avdd.t581 avdd pfet_05v0 ad=8.338p pd=38.78u as=8.338p ps=38.78u w=18.95u l=8u
VAUD258 avdd.t502 audit_d258 0
X272 audit_d258 avdd.t500 avdd.t501 avdd pfet_05v0 ad=9.7724p pd=45.3u as=0 ps=0 w=22.21u l=8u
VAUD259 vbp_i.t7 audit_d259 0
X273 audit_d259 vbp_i.t6 avdd.t584 avdd pfet_05v0 ad=8.25p pd=38.38u as=8.25p ps=38.38u w=18.75u l=8u
VAUD260 vbn_sink.t3 audit_d260 0
X274 audit_d260 vbp_i.t39 avdd.t568 avdd pfet_05v0 ad=8.338p pd=38.78u as=8.338p ps=38.78u w=18.95u l=8u
VAUD261 avss.t48 audit_d261 0
X275 audit_d261 avss.t46 avss.t47 avss nfet_05v0 ad=7.1896p pd=33.56u as=0 ps=0 w=16.34u l=8u
VAUD262 avdd.t493 audit_d262 0
X276 audit_d262 avdd.t491 avdd.t492 avdd pfet_05v0 ad=9.1344p pd=42.4u as=0 ps=0 w=20.76u l=4u
VAUD263 xf2.t5 audit_d263 0
X277 audit_d263 v2.t4 vsp.t1 avdd pfet_05v0 ad=24.1516p pd=0.11066m as=24.1516p ps=0.11066m w=54.89u l=4u
VAUD264 avdd.t404 audit_d264 0
X278 audit_d264 avdd.t402 avdd.t403 avdd pfet_05v0 ad=7.37p pd=34.38u as=0 ps=0 w=16.75u l=2u
VAUD265 b6_b.t1 audit_d265 0
X279 audit_d265 b6.t0 dvdd.t5 dvdd pfet_03v3 ad=1.32p pd=6.88u as=1.32p ps=6.88u w=3u l=0.5u
VAUD266 psrg_mf1_protected.t1 audit_d266 0
X280 audit_d266 vbn_fold.t15 xf1.t5 avss nfet_05v0 ad=8.1356p pd=37.86u as=8.1356p ps=37.86u w=18.49u l=6u
VAUD267 pm1.t5 audit_d267 0
X281 audit_d267 y1.t8 avdd.t629 avdd pfet_05v0 ad=9.1344p pd=42.4u as=9.1344p ps=42.4u w=20.76u l=4u
VAUD268 bgsu1 audit_d268 0
X282 audit_d268 bgsu1 bgsu2 avss nfet_03v3 ad=0.44p pd=2.88u as=0.44p ps=2.88u w=1u l=2u
VAUD269 psrg_m3_feed.t0 audit_d269 0
X283 audit_d269 psrg_vnc.t11 psrg_m3_protected.t2 avss nfet_05v0 ad=6.424p pd=30.08u as=6.424p ps=30.08u w=14.6u l=4u
VAUD270 vx1.t1 audit_d270 0
X284 audit_d270 psrg_m3_feed.t23 avdd.t600 avdd pfet_05v0 ad=7.37p pd=34.38u as=7.37p ps=34.38u w=16.75u l=2u
VAUD271 vgn1.t5 audit_d271 0
X285 audit_d271 vcasp vx1.t9 avdd pfet_05v0 ad=7.2248p pd=33.72u as=7.2248p ps=33.72u w=16.42u l=4u
VAUD272 avdd.t514 audit_d272 0
X286 audit_d272 avdd.t512 avdd.t513 avdd pfet_05v0 ad=9.7724p pd=45.3u as=0 ps=0 w=22.21u l=8u
VAUD273 vbp_bias.t19 audit_d273 0
X287 audit_d273 vbp_bias.t18 avdd.t619 avdd pfet_03v3 ad=8.3864p pd=39u as=8.3864p ps=39u w=19.06u l=8u
VAUD274 avdd.t231 audit_d274 0
X288 audit_d274 avdd.t229 avdd.t230 avdd pfet_05v0 ad=7.2248p pd=33.72u as=0 ps=0 w=16.42u l=4u
VAUD275 avdd.t174 audit_d275 0
X289 audit_d275 avdd.t172 avdd.t173 avdd pfet_05v0 ad=8.338p pd=38.78u as=0 ps=0 w=18.95u l=8u
VAUD276 avss.t87 audit_d276 0
X290 audit_d276 avss.t85 avss.t86 avss nfet_05v0 ad=3.322p pd=15.98u as=0 ps=0 w=7.55u l=4u
VAUD277 psrg_vnc.t6 audit_d277 0
X291 audit_d277 vbp_i.t14 avdd.t663 avdd pfet_05v0 ad=7.8056p pd=36.36u as=7.8056p ps=36.36u w=17.74u l=4u
VAUD278 avdd.t63 audit_d278 0
X292 audit_d278 avdd.t61 avdd.t62 avdd pfet_05v0 ad=8.3556p pd=38.86u as=0 ps=0 w=18.99u l=8u
VAUD279 avss.t54 audit_d279 0
X293 audit_d279 avss.t52 avss.t53 avss nfet_05v0 ad=6.424p pd=30.08u as=0 ps=0 w=14.6u l=4u
VAUD280 vbn_fold.t6 audit_d280 0
X294 audit_d280 vbp_i.t42 avdd.t596 avdd pfet_05v0 ad=8.3556p pd=38.86u as=8.3556p ps=38.86u w=18.99u l=8u
VAUD281 avdd.t341 audit_d281 0
X295 audit_d281 avdd.t339 avdd.t340 avdd pfet_05v0 ad=7.2248p pd=33.72u as=0 ps=0 w=16.42u l=4u
VAUD282 b1_b.t1 audit_d282 0
X296 audit_d282 b1.t2 dvdd.t4 dvdd pfet_03v3 ad=1.32p pd=6.88u as=1.32p ps=6.88u w=3u l=0.5u
VAUD283 iref_gate.t2 audit_d283 0
X297 audit_d283 vbp_i.t12 avdd.t665 avdd pfet_05v0 ad=35.2p pd=0.16088m as=35.2p ps=0.16088m w=80u l=1u
VAUD284 vbp_cas.t11 audit_d284 0
X298 audit_d284 vbp_cas.t10 vbp_bias.t6 avdd pfet_05v0 ad=8.3292p pd=38.74u as=8.3292p ps=38.74u w=18.93u l=8u
X299 vq3.t0 rbit6top.t2 avss ppolyf_u_1k r_width=6.6u r_length=0.128m
VAUD285 avss.t78 audit_d285 0
X300 audit_d285 avss.t76 avss.t77 avss nfet_05v0 ad=3.322p pd=15.98u as=0 ps=0 w=7.55u l=4u
VAUD286 vgn1.t3 audit_d286 0
X301 audit_d286 vgn1.t2 v1.t1 avss nfet_05v0 ad=6.424p pd=30.08u as=6.424p ps=30.08u w=14.6u l=4u
VAUD287 avdd.t60 audit_d287 0
X302 audit_d287 avdd.t58 avdd.t59 avdd pfet_05v0 ad=8.3556p pd=38.86u as=0 ps=0 w=18.99u l=8u
VAUD288 avdd.t414 audit_d288 0
X303 audit_d288 avdd.t413 avdd.t414 avdd pfet_05v0 ad=24.1516p pd=0.11066m as=0 ps=0 w=54.89u l=4u
VAUD289 vq3.t2 audit_d289 0
X304 audit_d289 b6_b.t2 rbit6top.t4 dvdd pfet_03v3 ad=1.65p pd=8.38u as=1.65p ps=8.38u w=3.75u l=0.28u
VAUD290 avdd.t356 audit_d290 0
X305 audit_d290 avdd.t354 avdd.t355 avdd pfet_05v0 ad=7.2248p pd=33.72u as=0 ps=0 w=16.42u l=4u
VAUD291 vbp_cas.t7 audit_d291 0
X306 audit_d291 vbp_cas.t6 vbp_bias.t5 avdd pfet_05v0 ad=8.3292p pd=38.74u as=8.3292p ps=38.74u w=18.93u l=8u
VAUD292 avdd.t219 audit_d292 0
X307 audit_d292 avdd.t217 avdd.t218 avdd pfet_05v0 ad=7.2248p pd=33.72u as=0 ps=0 w=16.42u l=4u
VAUD293 rbit3top.t4 audit_d293 0
X308 audit_d293 b2_b.t4 rbit2top.t3 dvdd pfet_03v3 ad=8.8p pd=40.88u as=8.8p ps=40.88u w=20u l=0.28u
VAUD294 avdd.t359 audit_d294 0
X309 audit_d294 avdd.t357 avdd.t358 avdd pfet_05v0 ad=7.2248p pd=33.72u as=0 ps=0 w=16.42u l=4u
VAUD295 avss.t168 audit_d295 0
X310 audit_d295 avss.t166 avss.t167 avss nfet_05v0 ad=8.1356p pd=37.86u as=0 ps=0 w=18.49u l=6u
VAUD296 vref.t3 audit_d296 0
X311 audit_d296 vcasp vx3.t8 avdd pfet_05v0 ad=7.2248p pd=33.72u as=7.2248p ps=33.72u w=16.42u l=4u
VAUD297 vbp_cas.t13 audit_d297 0
X312 audit_d297 vbp_cas.t12 vbp_bias.t3 avdd pfet_05v0 ad=8.3292p pd=38.74u as=8.3292p ps=38.74u w=18.93u l=8u
VAUD298 psrg_vnc.t2 audit_d298 0
X313 audit_d298 vbp_i.t16 avdd.t594 avdd pfet_05v0 ad=7.8056p pd=36.36u as=7.8056p ps=36.36u w=17.74u l=4u
VAUD299 psrg_m3_protected.t3 audit_d299 0
X314 audit_d299 vgn2.t8 v2.t1 avss nfet_05v0 ad=6.424p pd=30.08u as=6.424p ps=30.08u w=14.6u l=4u
VAUD300 vx3.t2 audit_d300 0
X315 audit_d300 psrg_m3_feed.t11 avdd.t608 avdd pfet_05v0 ad=7.37p pd=34.38u as=7.37p ps=34.38u w=16.75u l=2u
VAUD301 xf2.t1 audit_d301 0
X316 audit_d301 vbn_sink.t29 avss.t2 avss nfet_05v0 ad=7.1896p pd=33.56u as=7.1896p ps=33.56u w=16.34u l=8u
VAUD302 vx3.t3 audit_d302 0
X317 audit_d302 psrg_m3_feed.t16 avdd.t616 avdd pfet_05v0 ad=7.37p pd=34.38u as=7.37p ps=34.38u w=16.75u l=2u
VAUD303 avdd.t460 audit_d303 0
X318 audit_d303 avdd.t459 avdd.t460 avdd pfet_05v0 ad=24.1516p pd=0.11066m as=0 ps=0 w=54.89u l=4u
VAUD304 avdd.t289 audit_d304 0
X319 audit_d304 avdd.t288 avdd.t289 avdd pfet_05v0 ad=24.1516p pd=0.11066m as=0 ps=0 w=54.89u l=4u
VAUD305 psrg_m3_protected.t0 audit_d305 0
X320 audit_d305 vgn2.t9 v2.t0 avss nfet_05v0 ad=6.424p pd=30.08u as=6.424p ps=30.08u w=14.6u l=4u
VAUD306 vgn1.t7 audit_d306 0
X321 audit_d306 vcasp vx1.t6 avdd pfet_05v0 ad=7.2248p pd=33.72u as=7.2248p ps=33.72u w=16.42u l=4u
VAUD307 avdd.t54 audit_d307 0
X322 audit_d307 avdd.t52 avdd.t53 avdd pfet_05v0 ad=8.3556p pd=38.86u as=0 ps=0 w=18.99u l=8u
VAUD308 avdd.t401 audit_d308 0
X323 audit_d308 avdd.t399 avdd.t400 avdd pfet_05v0 ad=7.37p pd=34.38u as=0 ps=0 w=16.75u l=2u
VAUD309 vgn1.t6 audit_d309 0
X324 audit_d309 vcasp vx1.t10 avdd pfet_05v0 ad=7.2248p pd=33.72u as=7.2248p ps=33.72u w=16.42u l=4u
VAUD310 avdd.t317 audit_d310 0
X325 audit_d310 avdd.t315 avdd.t316 avdd pfet_05v0 ad=7.2248p pd=33.72u as=0 ps=0 w=16.42u l=4u
VAUD311 avdd.t454 audit_d311 0
X326 audit_d311 avdd.t453 avdd.t454 avdd pfet_05v0 ad=24.1516p pd=0.11066m as=0 ps=0 w=54.89u l=4u
VAUD312 rbit2top.t8 audit_d312 0
X327 audit_d312 b2.t2 rbit3top.t7 dvss nfet_03v3 ad=8.8p pd=40.88u as=8.8p ps=40.88u w=20u l=0.28u
VAUD313 xf1.t10 audit_d313 0
X328 audit_d313 v1.t2 vsp.t7 avdd pfet_05v0 ad=24.1516p pd=0.11066m as=24.1516p ps=0.11066m w=54.89u l=4u
VAUD314 avdd.t99 audit_d314 0
X329 audit_d314 avdd.t97 avdd.t98 avdd pfet_05v0 ad=8.25p pd=38.38u as=0 ps=0 w=18.75u l=8u
VAUD315 avdd.t180 audit_d315 0
X330 audit_d315 avdd.t178 avdd.t179 avdd pfet_05v0 ad=8.338p pd=38.78u as=0 ps=0 w=18.95u l=8u
VAUD316 vx2.t5 audit_d316 0
X331 audit_d316 psrg_m3_feed.t9 avdd.t612 avdd pfet_05v0 ad=7.37p pd=34.38u as=7.37p ps=34.38u w=16.75u l=2u
VAUD317 vsu audit_d317 0
X332 audit_d317 psrg_m3_feed.t8 avdd.t0 avdd pfet_05v0 ad=0.88p pd=4.88u as=0.88p ps=4.88u w=2u l=2u
VAUD318 avdd.t96 audit_d318 0
X333 audit_d318 avdd.t94 avdd.t95 avdd pfet_05v0 ad=8.25p pd=38.38u as=0 ps=0 w=18.75u l=8u
X334 vref.t12 avss.t218 cap_mim_2f0fF c_width=70.7u c_length=70.7u
VAUD319 avdd.t177 audit_d319 0
X335 audit_d319 avdd.t175 avdd.t176 avdd pfet_05v0 ad=8.338p pd=38.78u as=0 ps=0 w=18.95u l=8u
VAUD320 rbit5top.t5 audit_d320 0
X336 audit_d320 b5.t1 rbit6top.t5 dvss nfet_03v3 ad=1.1p pd=5.88u as=1.1p ps=5.88u w=2.5u l=0.28u
VAUD321 avdd.t440 audit_d321 0
X337 audit_d321 avdd.t438 avdd.t439 avdd pfet_05v0 ad=9.7724p pd=45.3u as=0 ps=0 w=22.21u l=8u
VAUD322 xf2.t6 audit_d322 0
X338 audit_d322 v2.t6 vsp.t8 avdd pfet_05v0 ad=24.1516p pd=0.11066m as=24.1516p ps=0.11066m w=54.89u l=4u
VAUD323 avss.t63 audit_d323 0
X339 audit_d323 avss.t61 avss.t62 avss nfet_05v0 ad=6.424p pd=30.08u as=0 ps=0 w=14.6u l=4u
VAUD324 avdd.t21 audit_d324 0
X340 audit_d324 avdd.t19 avdd.t20 avdd pfet_05v0 ad=8.25p pd=38.38u as=0 ps=0 w=18.75u l=8u
X341 vref.t7 avss.t228 cap_mim_2f0fF c_width=70.7u c_length=70.7u
VAUD325 avdd.t407 audit_d325 0
X342 audit_d325 avdd.t405 avdd.t406 avdd pfet_05v0 ad=7.37p pd=34.38u as=0 ps=0 w=16.75u l=2u
VAUD326 vbp_bias.t23 audit_d326 0
X343 audit_d326 vbp_bias.t22 avdd.t586 avdd pfet_03v3 ad=8.3864p pd=39u as=8.3864p ps=39u w=19.06u l=8u
X344 rbit1top.t6 rbit0top.t7 avss ppolyf_u_1k r_width=6.6u r_length=2u
VAUD327 vgn1.t8 audit_d327 0
X345 audit_d327 vcasp vx1.t7 avdd pfet_05v0 ad=7.2248p pd=33.72u as=7.2248p ps=33.72u w=16.42u l=4u
X346 vref.t15 avss.t212 cap_mim_2f0fF c_width=70.7u c_length=70.7u
VAUD328 vbn_i.t5 audit_d328 0
X347 audit_d328 vbp_i.t53 avdd.t634 avdd pfet_05v0 ad=8.25p pd=38.38u as=8.25p ps=38.38u w=18.75u l=8u
VAUD329 avdd.t18 audit_d329 0
X348 audit_d329 avdd.t16 avdd.t17 avdd pfet_05v0 ad=8.25p pd=38.38u as=0 ps=0 w=18.75u l=8u
VAUD330 avdd.t297 audit_d330 0
X349 audit_d330 avdd.t296 avdd.t297 avdd pfet_05v0 ad=24.1516p pd=0.11066m as=0 ps=0 w=54.89u l=4u
VAUD331 vbn_i.t2 audit_d331 0
X350 audit_d331 vbp_i.t55 avdd.t604 avdd pfet_05v0 ad=8.25p pd=38.38u as=8.25p ps=38.38u w=18.75u l=8u
VAUD332 avdd.t141 audit_d332 0
X351 audit_d332 avdd.t139 avdd.t140 avdd pfet_05v0 ad=8.3556p pd=38.86u as=0 ps=0 w=18.99u l=8u
X352 vref.t10 avss.t222 cap_mim_2f0fF c_width=70.7u c_length=70.7u
VAUD333 avss.t105 audit_d333 0
X353 audit_d333 avss.t103 avss.t104 avss nfet_05v0 ad=6.424p pd=30.08u as=0 ps=0 w=14.6u l=4u
VAUD334 avdd.t344 audit_d334 0
X354 audit_d334 avdd.t342 avdd.t343 avdd pfet_05v0 ad=7.37p pd=34.38u as=0 ps=0 w=16.75u l=2u
VAUD335 b4_b.t1 audit_d335 0
X355 audit_d335 b4.t0 dvdd.t2 dvdd pfet_03v3 ad=1.32p pd=6.88u as=1.32p ps=6.88u w=3u l=0.5u
VAUD336 vnx_bias audit_d336 0
X356 audit_d336 vnx_bias avss.t209 avss nfet_03v3 ad=0.7128p pd=4.12u as=0.7128p ps=4.12u w=1.62u l=8u
VAUD337 vbn.t2 audit_d337 0
X357 audit_d337 vcasp vaux.t0 avdd pfet_05v0 ad=7.04p pd=32.88u as=7.04p ps=32.88u w=16u l=4u
VAUD338 vx1.t3 audit_d338 0
X358 audit_d338 psrg_m3_feed.t15 avdd.t615 avdd pfet_05v0 ad=7.37p pd=34.38u as=7.37p ps=34.38u w=16.75u l=2u
VAUD339 rbit2top.t7 audit_d339 0
X359 audit_d339 b1_b.t2 rbit1top.t10 dvdd pfet_03v3 ad=17.6p pd=80.88u as=17.6p ps=80.88u w=40u l=0.28u
VAUD340 vbn_fold.t7 audit_d340 0
X360 audit_d340 vbp_i.t43 avdd.t597 avdd pfet_05v0 ad=8.3556p pd=38.86u as=8.3556p ps=38.86u w=18.99u l=8u
VAUD341 pm2.t5 audit_d341 0
X361 audit_d341 y1.t7 avdd.t570 avdd pfet_05v0 ad=9.1344p pd=42.4u as=9.1344p ps=42.4u w=20.76u l=4u
VAUD342 avss.t66 audit_d342 0
X362 audit_d342 avss.t64 avss.t65 avss nfet_05v0 ad=6.424p pd=30.08u as=0 ps=0 w=14.6u l=4u
VAUD343 avdd.t252 audit_d343 0
X363 audit_d343 avdd.t250 avdd.t251 avdd pfet_05v0 ad=7.2248p pd=33.72u as=0 ps=0 w=16.42u l=4u
VAUD344 vbn_sink.t0 audit_d344 0
X364 audit_d344 vbp_i.t36 avdd.t565 avdd pfet_05v0 ad=8.338p pd=38.78u as=8.338p ps=38.78u w=18.95u l=8u
VAUD345 vbn_fold.t12 audit_d345 0
X365 audit_d345 vbp_i.t44 avdd.t658 avdd pfet_05v0 ad=8.3556p pd=38.86u as=8.3556p ps=38.86u w=18.99u l=8u
VAUD346 avss.t189 audit_d346 0
X366 audit_d346 avss.t187 avss.t188 avss nfet_05v0 ad=8.1356p pd=37.86u as=0 ps=0 w=18.49u l=6u
VAUD347 b1_b.t0 audit_d347 0
X367 audit_d347 b1.t1 dvss.t4 dvss nfet_03v3 ad=0.44p pd=2.88u as=0.44p ps=2.88u w=1u l=0.5u
VAUD348 avss.t57 audit_d348 0
X368 audit_d348 avss.t55 avss.t56 avss nfet_05v0 ad=6.424p pd=30.08u as=0 ps=0 w=14.6u l=4u
VAUD349 vbp_bias.t21 audit_d349 0
X369 audit_d349 vbp_bias.t20 avdd.t654 avdd pfet_03v3 ad=8.3864p pd=39u as=8.3864p ps=39u w=19.06u l=8u
VAUD350 xf2.t11 audit_d350 0
X370 audit_d350 vbn_sink.t21 avss.t240 avss nfet_05v0 ad=7.1896p pd=33.56u as=7.1896p ps=33.56u w=16.34u l=8u
VAUD351 rbit1top.t13 audit_d351 0
X371 audit_d351 b1.t0 rbit2top.t9 dvss nfet_03v3 ad=17.6p pd=80.88u as=17.6p ps=80.88u w=40u l=0.28u
VAUD352 pm1.t1 audit_d352 0
X372 audit_d352 y1.t16 avdd.t627 avdd pfet_05v0 ad=9.1344p pd=42.4u as=9.1344p ps=42.4u w=20.76u l=4u
VAUD353 vsu audit_d353 0
X373 audit_d353 vsu bgsu1 avss nfet_05v0 ad=0.44p pd=2.88u as=0.44p ps=2.88u w=1u l=2u
VAUD354 vgn2.t4 audit_d354 0
X374 audit_d354 vbp_cas.t25 pm2.t10 avdd pfet_05v0 ad=9.7724p pd=45.3u as=9.7724p ps=45.3u w=22.21u l=8u
VAUD355 avss.t81 audit_d355 0
X375 audit_d355 avss.t79 avss.t80 avss nfet_05v0 ad=3.322p pd=15.98u as=0 ps=0 w=7.55u l=4u
VAUD356 avdd.t523 audit_d356 0
X376 audit_d356 avdd.t521 avdd.t522 avdd pfet_05v0 ad=9.7724p pd=45.3u as=0 ps=0 w=22.21u l=8u
VAUD357 xf1.t3 audit_d357 0
X377 audit_d357 vbn_sink.t22 avss.t201 avss nfet_05v0 ad=7.1896p pd=33.56u as=7.1896p ps=33.56u w=16.34u l=8u
VAUD358 b4_b.t0 audit_d358 0
X378 audit_d358 b4.t1 dvss.t2 dvss nfet_03v3 ad=0.44p pd=2.88u as=0.44p ps=2.88u w=1u l=0.5u
VAUD359 vbn_sink.t4 audit_d359 0
X379 audit_d359 vbp_i.t34 avdd.t574 avdd pfet_05v0 ad=8.338p pd=38.78u as=8.338p ps=38.78u w=18.95u l=8u
VAUD360 vbp_cas.t19 audit_d360 0
X380 audit_d360 vbp_cas.t18 vbp_bias.t2 avdd pfet_05v0 ad=8.3292p pd=38.74u as=8.3292p ps=38.74u w=18.93u l=8u
VAUD361 avdd.t117 audit_d361 0
X381 audit_d361 avdd.t115 avdd.t116 avdd pfet_05v0 ad=8.25p pd=38.38u as=0 ps=0 w=18.75u l=8u
VAUD362 xf1.t0 audit_d362 0
X382 audit_d362 vbn_sink.t30 avss.t3 avss nfet_05v0 ad=7.1896p pd=33.56u as=7.1896p ps=33.56u w=16.34u l=8u
VAUD363 avdd.t472 audit_d363 0
X383 audit_d363 avdd.t470 avdd.t471 avdd pfet_05v0 ad=9.7724p pd=45.3u as=0 ps=0 w=22.21u l=8u
VAUD364 vsp.t15 audit_d364 0
X384 audit_d364 vbp_tail.t7 avdd.t650 avdd pfet_03v3 ad=12.7204p pd=58.7u as=12.7204p ps=58.7u w=28.91u l=6u
VAUD365 avdd.t183 audit_d365 0
X385 audit_d365 avdd.t181 avdd.t182 avdd pfet_05v0 ad=8.338p pd=38.78u as=0 ps=0 w=18.95u l=8u
VAUD366 vbp_cas.t15 audit_d366 0
X386 audit_d366 vbp_cas.t14 vbp_bias.t1 avdd pfet_05v0 ad=8.3292p pd=38.74u as=8.3292p ps=38.74u w=18.93u l=8u
VAUD367 aux_gate audit_d367 0
X387 audit_d367 vbn_i.t8 avss.t199 avss nfet_05v0 ad=0.44p pd=2.88u as=0.44p ps=2.88u w=1u l=8u
VAUD368 avdd.t51 audit_d368 0
X388 audit_d368 avdd.t49 avdd.t50 avdd pfet_05v0 ad=8.3556p pd=38.86u as=0 ps=0 w=18.99u l=8u
VAUD369 avdd.t39 audit_d369 0
X389 audit_d369 avdd.t37 avdd.t38 avdd pfet_05v0 ad=8.25p pd=38.38u as=0 ps=0 w=18.75u l=8u
VAUD370 avdd.t338 audit_d370 0
X390 audit_d370 avdd.t336 avdd.t337 avdd pfet_05v0 ad=7.2248p pd=33.72u as=0 ps=0 w=16.42u l=4u
VAUD371 avdd.t279 audit_d371 0
X391 audit_d371 avdd.t277 avdd.t278 avdd pfet_05v0 ad=7.37p pd=34.38u as=0 ps=0 w=16.75u l=2u
VAUD372 avdd.t291 audit_d372 0
X392 audit_d372 avdd.t290 avdd.t291 avdd pfet_05v0 ad=24.1516p pd=0.11066m as=0 ps=0 w=54.89u l=4u
VAUD373 avss.t162 audit_d373 0
X393 audit_d373 avss.t160 avss.t161 avss nfet_05v0 ad=7.1896p pd=33.56u as=0 ps=0 w=16.34u l=8u
VAUD374 avdd.t48 audit_d374 0
X394 audit_d374 avdd.t46 avdd.t47 avdd pfet_05v0 ad=8.3556p pd=38.86u as=0 ps=0 w=18.99u l=8u
VAUD375 vgn1.t1 audit_d375 0
X395 audit_d375 vgn1.t0 v1.t0 avss nfet_05v0 ad=6.424p pd=30.08u as=6.424p ps=30.08u w=14.6u l=4u
VAUD376 rb_mid audit_d376 0
X396 audit_d376 rb_mid avss.t200 avss nfet_05v0 ad=0.2376p pd=1.96u as=0.2376p ps=1.96u w=0.54u l=20u
VAUD377 avdd.t478 audit_d377 0
X397 audit_d377 avdd.t476 avdd.t477 avdd pfet_05v0 ad=9.1344p pd=42.4u as=0 ps=0 w=20.76u l=4u
VAUD378 avdd.t456 audit_d378 0
X398 audit_d378 avdd.t455 avdd.t456 avdd pfet_05v0 ad=24.1516p pd=0.11066m as=0 ps=0 w=54.89u l=4u
VAUD379 avss.t159 audit_d379 0
X399 audit_d379 avss.t157 avss.t158 avss nfet_05v0 ad=7.1896p pd=33.56u as=0 ps=0 w=16.34u l=8u
VAUD380 avdd.t437 audit_d380 0
X400 audit_d380 avdd.t435 avdd.t436 avdd pfet_05v0 ad=9.7724p pd=45.3u as=0 ps=0 w=22.21u l=8u
VAUD381 rbit1top.t2 audit_d381 0
X401 audit_d381 b0_b.t5 rbit0top.t4 dvdd pfet_03v3 ad=17.6p pd=80.88u as=17.6p ps=80.88u w=40u l=0.28u
VAUD382 vref.t2 audit_d382 0
X402 audit_d382 vcasp vx3.t9 avdd pfet_05v0 ad=7.2248p pd=33.72u as=7.2248p ps=33.72u w=16.42u l=4u
VAUD383 xf2.t3 audit_d383 0
X403 audit_d383 vbn_sink.t25 avss.t196 avss nfet_05v0 ad=7.1896p pd=33.56u as=7.1896p ps=33.56u w=16.34u l=8u
VAUD384 avdd.t287 audit_d384 0
X404 audit_d384 avdd.t286 avdd.t287 avdd pfet_05v0 ad=24.1516p pd=0.11066m as=0 ps=0 w=54.89u l=4u
VAUD385 avdd.t108 audit_d385 0
X405 audit_d385 avdd.t106 avdd.t107 avdd pfet_05v0 ad=8.25p pd=38.38u as=0 ps=0 w=18.75u l=8u
VAUD386 avdd.t434 audit_d386 0
X406 audit_d386 avdd.t432 avdd.t433 avdd pfet_05v0 ad=9.7724p pd=45.3u as=0 ps=0 w=22.21u l=8u
VAUD387 b0_b.t0 audit_d387 0
X407 audit_d387 b0.t0 dvss.t1 dvss nfet_03v3 ad=0.44p pd=2.88u as=0.44p ps=2.88u w=1u l=0.5u
VAUD388 y1.t3 audit_d388 0
X408 audit_d388 vbp_cas.t22 pm1.t8 avdd pfet_05v0 ad=9.7724p pd=45.3u as=9.7724p ps=45.3u w=22.21u l=8u
VAUD389 vbp_tail.t6 audit_d389 0
X409 audit_d389 vbp_tail.t5 avdd.t571 avdd pfet_03v3 ad=6.05p pd=28.38u as=6.05p ps=28.38u w=13.75u l=6u
VAUD390 rbit6top.t3 audit_d390 0
X410 audit_d390 b6.t1 vq3.t1 dvss nfet_03v3 ad=0.55p pd=3.38u as=0.55p ps=3.38u w=1.25u l=0.28u
VAUD391 xf2.t9 audit_d391 0
X411 audit_d391 v2.t7 vsp.t14 avdd pfet_05v0 ad=24.1516p pd=0.11066m as=24.1516p ps=0.11066m w=54.89u l=4u
VAUD392 vbp_i.t1 audit_d392 0
X412 audit_d392 vbp_i.t0 avdd.t667 avdd pfet_05v0 ad=8.25p pd=38.38u as=8.25p ps=38.38u w=18.75u l=8u
VAUD393 avdd.t464 audit_d393 0
X413 audit_d393 avdd.t463 avdd.t464 avdd pfet_05v0 ad=24.1516p pd=0.11066m as=0 ps=0 w=54.89u l=4u
VAUD394 vbp_bias.t25 audit_d394 0
X414 audit_d394 vbp_bias.t24 avdd.t587 avdd pfet_03v3 ad=8.3864p pd=39u as=8.3864p ps=39u w=19.06u l=8u
VAUD395 vbn_i.t0 audit_d395 0
X415 audit_d395 vbp_i.t56 avdd.t573 avdd pfet_05v0 ad=8.25p pd=38.38u as=8.25p ps=38.38u w=18.75u l=8u
X416 vref.t14 avss.t214 cap_mim_2f0fF c_width=70.7u c_length=70.7u
VAUD396 avdd.t30 audit_d396 0
X417 audit_d396 avdd.t28 avdd.t29 avdd pfet_05v0 ad=8.25p pd=38.38u as=0 ps=0 w=18.75u l=8u
VAUD397 avss.t39 audit_d397 0
X418 audit_d397 avss.t37 avss.t38 avss nfet_05v0 ad=5.4164p pd=25.5u as=0 ps=0 w=12.31u l=8u
VAUD398 avdd.t186 audit_d398 0
X419 audit_d398 avdd.t184 avdd.t185 avdd pfet_05v0 ad=8.338p pd=38.78u as=0 ps=0 w=18.95u l=8u
VAUD399 vbn_sink.t1 audit_d399 0
X420 audit_d399 vbp_i.t37 avdd.t566 avdd pfet_05v0 ad=8.338p pd=38.78u as=8.338p ps=38.78u w=18.95u l=8u
VAUD400 vx3.t0 audit_d400 0
X421 audit_d400 psrg_m3_feed.t12 avdd.t572 avdd pfet_05v0 ad=7.37p pd=34.38u as=7.37p ps=34.38u w=16.75u l=2u
VAUD401 vx2.t1 audit_d401 0
X422 audit_d401 psrg_m3_feed.t22 avdd.t599 avdd pfet_05v0 ad=7.37p pd=34.38u as=7.37p ps=34.38u w=16.75u l=2u
VAUD402 avdd.t264 audit_d402 0
X423 audit_d402 avdd.t262 avdd.t263 avdd pfet_05v0 ad=7.37p pd=34.38u as=0 ps=0 w=16.75u l=2u
VAUD403 avdd.t490 audit_d403 0
X424 audit_d403 avdd.t488 avdd.t489 avdd pfet_05v0 ad=9.1344p pd=42.4u as=0 ps=0 w=20.76u l=4u
X425 vref.t9 avss.t224 cap_mim_2f0fF c_width=70.7u c_length=70.7u
VAUD404 iref_gate.t1 audit_d404 0
X426 audit_d404 vbp_i.t11 avdd.t644 avdd pfet_05v0 ad=35.2p pd=0.16088m as=35.2p ps=0.16088m w=80u l=1u
VAUD405 avss.t36 audit_d405 0
X427 audit_d405 avss.t34 avss.t35 avss nfet_05v0 ad=5.4164p pd=25.5u as=0 ps=0 w=12.31u l=8u
VAUD406 avdd.t282 audit_d406 0
X428 audit_d406 avdd.t280 avdd.t281 avdd pfet_05v0 ad=7.37p pd=34.38u as=0 ps=0 w=16.75u l=2u
VAUD407 vsua audit_d407 0
X429 audit_d407 vcasp avdd.t640 avdd pfet_05v0 ad=0.88p pd=4.88u as=0.88p ps=4.88u w=2u l=2u
VAUD408 avdd.t228 audit_d408 0
X430 audit_d408 avdd.t226 avdd.t227 avdd pfet_05v0 ad=7.2248p pd=33.72u as=0 ps=0 w=16.42u l=4u
VAUD409 vbn_sink.t16 audit_d409 0
X431 audit_d409 vbp_i.t29 avdd.t602 avdd pfet_05v0 ad=8.338p pd=38.78u as=8.338p ps=38.78u w=18.95u l=8u
VAUD410 vbn_sink.t2 audit_d410 0
X432 audit_d410 vbp_i.t38 avdd.t567 avdd pfet_05v0 ad=8.338p pd=38.78u as=8.338p ps=38.78u w=18.95u l=8u
VAUD411 avss.t150 audit_d411 0
X433 audit_d411 avss.t148 avss.t149 avss nfet_05v0 ad=7.1896p pd=33.56u as=0 ps=0 w=16.34u l=8u
VAUD412 psrg_vnc.t8 audit_d412 0
X434 audit_d412 vbp_i.t13 avdd.t666 avdd pfet_05v0 ad=7.8056p pd=36.36u as=7.8056p ps=36.36u w=17.74u l=4u
VAUD413 b6_b.t0 audit_d413 0
X435 audit_d413 b6.t2 dvss.t5 dvss nfet_03v3 ad=0.44p pd=2.88u as=0.44p ps=2.88u w=1u l=0.5u
VAUD414 avdd.t428 audit_d414 0
X436 audit_d414 avdd.t426 avdd.t427 avdd pfet_05v0 ad=9.7724p pd=45.3u as=0 ps=0 w=22.21u l=8u
VAUD415 vsu1 audit_d415 0
X437 audit_d415 vbp_i.t22 vsu2 avss nfet_05v0 ad=0.22p pd=1.88u as=0.22p ps=1.88u w=0.5u l=50u
VAUD416 avdd.t398 audit_d416 0
X438 audit_d416 avdd.t396 avdd.t397 avdd pfet_05v0 ad=7.37p pd=34.38u as=0 ps=0 w=16.75u l=2u
VAUD417 avss.t60 audit_d417 0
X439 audit_d417 avss.t58 avss.t59 avss nfet_05v0 ad=6.424p pd=30.08u as=0 ps=0 w=14.6u l=4u
VAUD418 vbp_i.t3 audit_d418 0
X440 audit_d418 vbp_i.t2 avdd.t578 avdd pfet_05v0 ad=8.25p pd=38.38u as=8.25p ps=38.38u w=18.75u l=8u
VAUD419 avdd.t425 audit_d419 0
X441 audit_d419 avdd.t423 avdd.t424 avdd pfet_05v0 ad=9.7724p pd=45.3u as=0 ps=0 w=22.21u l=8u
VAUD420 bgsu2 audit_d420 0
X442 audit_d420 bgsu2 avss.t238 avss nfet_03v3 ad=0.44p pd=2.88u as=0.44p ps=2.88u w=1u l=2u
VAUD421 y1.t6 audit_d421 0
X443 audit_d421 vbp_cas.t27 pm1.t11 avdd pfet_05v0 ad=9.7724p pd=45.3u as=9.7724p ps=45.3u w=22.21u l=8u
VAUD422 xf1.t8 audit_d422 0
X444 audit_d422 v1.t4 vsp.t5 avdd pfet_05v0 ad=24.1516p pd=0.11066m as=24.1516p ps=0.11066m w=54.89u l=4u
VAUD423 vcasp audit_d423 0
X445 audit_d423 vbn.t4 avss.t233 avss nfet_05v0 ad=3.322p pd=15.98u as=3.322p ps=15.98u w=7.55u l=4u
VAUD424 b2_b.t0 audit_d424 0
X446 audit_d424 b2.t1 dvss.t3 dvss nfet_03v3 ad=0.44p pd=2.88u as=0.44p ps=2.88u w=1u l=0.5u
VAUD425 avdd.t165 audit_d425 0
X447 audit_d425 avdd.t163 avdd.t164 avdd pfet_05v0 ad=8.338p pd=38.78u as=0 ps=0 w=18.95u l=8u
VAUD426 avdd.t129 audit_d426 0
X448 audit_d426 avdd.t127 avdd.t128 avdd pfet_05v0 ad=8.3556p pd=38.86u as=0 ps=0 w=18.99u l=8u
VAUD427 vx1.t2 audit_d427 0
X449 audit_d427 psrg_m3_feed.t20 avdd.t653 avdd pfet_05v0 ad=7.37p pd=34.38u as=7.37p ps=34.38u w=16.75u l=2u
VAUD428 su_state.t0 audit_d428 0
X450 audit_d428 vgn2.t10 avss.t234 avss nfet_05v0 ad=1.76p pd=8.88u as=1.76p ps=8.88u w=4u l=1u
VAUD429 vgn2.t3 audit_d429 0
X451 audit_d429 vbp_cas.t28 pm2.t11 avdd pfet_05v0 ad=9.7724p pd=45.3u as=9.7724p ps=45.3u w=22.21u l=8u
VAUD430 avdd.t347 audit_d430 0
X452 audit_d430 avdd.t345 avdd.t346 avdd pfet_05v0 ad=7.37p pd=34.38u as=0 ps=0 w=16.75u l=2u
VAUD431 vref.t0 audit_d431 0
X453 audit_d431 vcasp vx3.t5 avdd pfet_05v0 ad=7.2248p pd=33.72u as=7.2248p ps=33.72u w=16.42u l=4u
VAUD432 rbit3top.t6 audit_d432 0
X454 audit_d432 b2_b.t2 rbit2top.t4 dvdd pfet_03v3 ad=8.8p pd=40.88u as=8.8p ps=40.88u w=20u l=0.28u
X455 rbit5top.t3 rbit4top.t4 avss ppolyf_u_1k r_width=6.6u r_length=32u
VAUD433 avdd.t508 audit_d433 0
X456 audit_d433 avdd.t506 avdd.t507 avdd pfet_05v0 ad=9.1344p pd=42.4u as=0 ps=0 w=20.76u l=4u
VAUD434 auxsu1 audit_d434 0
X457 audit_d434 auxsu1 auxsu2 avss nfet_03v3 ad=0.44p pd=2.88u as=0.44p ps=2.88u w=1u l=2u
VAUD435 vgn1.t4 audit_d435 0
X458 audit_d435 vcasp vx1.t8 avdd pfet_05v0 ad=7.2248p pd=33.72u as=7.2248p ps=33.72u w=16.42u l=4u
VAUD436 vsp.t13 audit_d436 0
X459 audit_d436 vbp_tail.t8 avdd.t649 avdd pfet_03v3 ad=12.7204p pd=58.7u as=12.7204p ps=58.7u w=28.91u l=6u
VAUD437 avdd.t126 audit_d437 0
X460 audit_d437 avdd.t124 avdd.t125 avdd pfet_05v0 ad=8.3556p pd=38.86u as=0 ps=0 w=18.99u l=8u
VAUD438 vbn_sink.t9 audit_d438 0
X461 audit_d438 vbp_i.t31 avdd.t582 avdd pfet_05v0 ad=8.338p pd=38.78u as=8.338p ps=38.78u w=18.95u l=8u
VAUD439 avss.t24 audit_d439 0
X462 audit_d439 avss.t22 avss.t23 avss nfet_05v0 ad=7.1896p pd=33.56u as=0 ps=0 w=16.34u l=8u
VAUD440 b0_b.t1 audit_d440 0
X463 audit_d440 b0.t1 dvdd.t1 dvdd pfet_03v3 ad=1.32p pd=6.88u as=1.32p ps=6.88u w=3u l=0.5u
VAUD441 avdd.t383 audit_d441 0
X464 audit_d441 avdd.t381 avdd.t382 avdd pfet_05v0 ad=7.2248p pd=33.72u as=0 ps=0 w=16.42u l=4u
VAUD442 avss.t111 audit_d442 0
X465 audit_d442 avss.t109 avss.t110 avss nfet_05v0 ad=3.322p pd=15.98u as=0 ps=0 w=7.55u l=4u
X466 rbit2top.t2 rbit1top.t7 avss ppolyf_u_1k r_width=6.6u r_length=4u
VAUD443 avdd.t326 audit_d443 0
X467 audit_d443 avdd.t324 avdd.t325 avdd pfet_05v0 ad=7.37p pd=34.38u as=0 ps=0 w=16.75u l=2u
VAUD444 aux_gate audit_d444 0
X468 audit_d444 vcasp avdd.t638 avdd pfet_05v0 ad=0.22p pd=1.88u as=0.22p ps=1.88u w=0.5u l=10u
VAUD445 avss.t21 audit_d445 0
X469 audit_d445 avss.t19 avss.t20 avss nfet_05v0 ad=7.1896p pd=33.56u as=0 ps=0 w=16.34u l=8u
VAUD446 vx3.t1 audit_d446 0
X470 audit_d446 psrg_m3_feed.t21 avdd.t598 avdd pfet_05v0 ad=7.37p pd=34.38u as=7.37p ps=34.38u w=16.75u l=2u
VAUD447 avdd.t240 audit_d447 0
X471 audit_d447 avdd.t238 avdd.t239 avdd pfet_05v0 ad=7.2248p pd=33.72u as=0 ps=0 w=16.42u l=4u
VAUD448 avdd.t553 audit_d448 0
X472 audit_d448 avdd.t551 avdd.t552 avdd pfet_05v0 ad=9.1344p pd=42.4u as=0 ps=0 w=20.76u l=4u
VAUD449 avss.t108 audit_d449 0
X473 audit_d449 avss.t106 avss.t107 avss nfet_05v0 ad=3.322p pd=15.98u as=0 ps=0 w=7.55u l=4u
VAUD450 avdd.t314 audit_d450 0
X474 audit_d450 avdd.t312 avdd.t313 avdd pfet_05v0 ad=7.2248p pd=33.72u as=0 ps=0 w=16.42u l=4u
VAUD451 xf1.t1 audit_d451 0
X475 audit_d451 vbn_sink.t26 avss.t197 avss nfet_05v0 ad=7.1896p pd=33.56u as=7.1896p ps=33.56u w=16.34u l=8u
VAUD452 vgn2.t5 audit_d452 0
X476 audit_d452 vbp_cas.t24 pm2.t9 avdd pfet_05v0 ad=9.7724p pd=45.3u as=9.7724p ps=45.3u w=22.21u l=8u
VAUD453 avdd.t532 audit_d453 0
X477 audit_d453 avdd.t530 avdd.t531 avdd pfet_05v0 ad=9.7724p pd=45.3u as=0 ps=0 w=22.21u l=8u
VAUD454 avdd.t105 audit_d454 0
X478 audit_d454 avdd.t103 avdd.t104 avdd pfet_05v0 ad=8.25p pd=38.38u as=0 ps=0 w=18.75u l=8u
VAUD455 avdd.t544 audit_d455 0
X479 audit_d455 avdd.t542 avdd.t543 avdd pfet_05v0 ad=9.1344p pd=42.4u as=0 ps=0 w=20.76u l=4u
VAUD456 rbit1top.t5 audit_d456 0
X480 audit_d456 b0_b.t2 rbit0top.t2 dvdd pfet_03v3 ad=17.6p pd=80.88u as=17.6p ps=80.88u w=40u l=0.28u
VAUD457 y1.t1 audit_d457 0
X481 audit_d457 vbp_cas.t30 pm1.t6 avdd pfet_05v0 ad=9.7724p pd=45.3u as=9.7724p ps=45.3u w=22.21u l=8u
VAUD458 avss.t138 audit_d458 0
X482 audit_d458 avss.t136 avss.t137 avss nfet_05v0 ad=7.1896p pd=33.56u as=0 ps=0 w=16.34u l=8u
VAUD459 vsp.t2 audit_d459 0
X483 audit_d459 vbp_tail.t10 avdd.t613 avdd pfet_03v3 ad=12.7204p pd=58.7u as=12.7204p ps=58.7u w=28.91u l=6u
VAUD460 avdd.t90 audit_d460 0
X484 audit_d460 avdd.t88 avdd.t89 avdd pfet_05v0 ad=8.25p pd=38.38u as=0 ps=0 w=18.75u l=8u
VAUD461 vx2.t4 audit_d461 0
X485 audit_d461 psrg_m3_feed.t14 avdd.t606 avdd pfet_05v0 ad=7.37p pd=34.38u as=7.37p ps=34.38u w=16.75u l=2u
VAUD462 y1.t2 audit_d462 0
X486 audit_d462 vbp_cas.t31 pm1.t7 avdd pfet_05v0 ad=9.7724p pd=45.3u as=9.7724p ps=45.3u w=22.21u l=8u
VAUD463 avdd.t66 audit_d463 0
X487 audit_d463 avdd.t64 avdd.t65 avdd pfet_05v0 ad=8.25p pd=38.38u as=0 ps=0 w=18.75u l=8u
VAUD464 avdd.t475 audit_d464 0
X488 audit_d464 avdd.t473 avdd.t474 avdd pfet_05v0 ad=9.1344p pd=42.4u as=0 ps=0 w=20.76u l=4u
VAUD465 xf1.t7 audit_d465 0
X489 audit_d465 v1.t6 vsp.t3 avdd pfet_05v0 ad=24.1516p pd=0.11066m as=24.1516p ps=0.11066m w=54.89u l=4u
VAUD466 avss.t171 audit_d466 0
X490 audit_d466 avss.t169 avss.t170 avss nfet_05v0 ad=8.1356p pd=37.86u as=0 ps=0 w=18.49u l=6u
VAUD467 vx3.t10 audit_d467 0
X491 audit_d467 psrg_m3_feed.t19 avdd.t652 avdd pfet_05v0 ad=7.37p pd=34.38u as=7.37p ps=34.38u w=16.75u l=2u
VAUD468 avdd.t27 audit_d468 0
X492 audit_d468 avdd.t25 avdd.t26 avdd pfet_05v0 ad=8.25p pd=38.38u as=0 ps=0 w=18.75u l=8u
VAUD469 avdd.t237 audit_d469 0
X493 audit_d469 avdd.t235 avdd.t236 avdd pfet_05v0 ad=7.2248p pd=33.72u as=0 ps=0 w=16.42u l=4u
VAUD470 avdd.t392 audit_d470 0
X494 audit_d470 avdd.t390 avdd.t391 avdd pfet_05v0 ad=7.37p pd=34.38u as=0 ps=0 w=16.75u l=2u
VAUD471 avdd.t255 audit_d471 0
X495 audit_d471 avdd.t253 avdd.t254 avdd pfet_05v0 ad=7.2248p pd=33.72u as=0 ps=0 w=16.42u l=4u
VAUD472 auxsu2 audit_d472 0
X496 audit_d472 auxsu2 avss.t237 avss nfet_03v3 ad=0.44p pd=2.88u as=0.44p ps=2.88u w=1u l=2u
VAUD473 avdd.t12 audit_d473 0
X497 audit_d473 avdd.t10 avdd.t11 avdd pfet_05v0 ad=8.25p pd=38.38u as=0 ps=0 w=18.75u l=8u
VAUD474 rbit1top.t1 audit_d474 0
X498 audit_d474 b0_b.t6 rbit0top.t3 dvdd pfet_03v3 ad=17.6p pd=80.88u as=17.6p ps=80.88u w=40u l=0.28u
VAUD475 avss.t120 audit_d475 0
X499 audit_d475 avss.t118 avss.t119 avss nfet_05v0 ad=3.322p pd=15.98u as=0 ps=0 w=7.55u l=4u
VAUD476 avdd.t466 audit_d476 0
X500 audit_d476 avdd.t465 avdd.t466 avdd pfet_05v0 ad=24.1516p pd=0.11066m as=0 ps=0 w=54.89u l=4u
VAUD477 avss.t33 audit_d477 0
X501 audit_d477 avss.t31 avss.t32 avss nfet_05v0 ad=5.4164p pd=25.5u as=0 ps=0 w=12.31u l=8u
VAUD478 avdd.t147 audit_d478 0
X502 audit_d478 avdd.t145 avdd.t146 avdd pfet_05v0 ad=8.3556p pd=38.86u as=0 ps=0 w=18.99u l=8u
VAUD479 pm2.t1 audit_d479 0
X503 audit_d479 y1.t15 avdd.t626 avdd pfet_05v0 ad=9.1344p pd=42.4u as=9.1344p ps=42.4u w=20.76u l=4u
VAUD480 avdd.t210 audit_d480 0
X504 audit_d480 avdd.t208 avdd.t209 avdd pfet_05v0 ad=8.338p pd=38.78u as=0 ps=0 w=18.95u l=8u
VAUD481 avss.t12 audit_d481 0
X505 audit_d481 avss.t10 avss.t11 avss nfet_05v0 ad=7.1896p pd=33.56u as=0 ps=0 w=16.34u l=8u
VAUD482 avss.t147 audit_d482 0
X506 audit_d482 avss.t145 avss.t146 avss nfet_05v0 ad=7.1896p pd=33.56u as=0 ps=0 w=16.34u l=8u
VAUD483 avdd.t499 audit_d483 0
X507 audit_d483 avdd.t497 avdd.t498 avdd pfet_05v0 ad=9.7724p pd=45.3u as=0 ps=0 w=22.21u l=8u
VAUD484 rbit2top.t6 audit_d484 0
X508 audit_d484 b1_b.t3 rbit1top.t11 dvdd pfet_03v3 ad=17.6p pd=80.88u as=17.6p ps=80.88u w=40u l=0.28u
VAUD485 avdd.t412 audit_d485 0
X509 audit_d485 avdd.t411 avdd.t412 avdd pfet_05v0 ad=24.1516p pd=0.11066m as=0 ps=0 w=54.89u l=4u
VAUD486 avss.t30 audit_d486 0
X510 audit_d486 avss.t28 avss.t29 avss nfet_05v0 ad=5.4164p pd=25.5u as=0 ps=0 w=12.31u l=8u
VAUD487 avdd.t144 audit_d487 0
X511 audit_d487 avdd.t142 avdd.t143 avdd pfet_05v0 ad=8.3556p pd=38.86u as=0 ps=0 w=18.99u l=8u
VAUD488 avss.t144 audit_d488 0
X512 audit_d488 avss.t142 avss.t143 avss nfet_05v0 ad=7.1896p pd=33.56u as=0 ps=0 w=16.34u l=8u
VAUD489 avdd.t422 audit_d489 0
X513 audit_d489 avdd.t420 avdd.t421 avdd pfet_05v0 ad=9.7724p pd=45.3u as=0 ps=0 w=22.21u l=8u
VAUD490 avdd.t311 audit_d490 0
X514 audit_d490 avdd.t310 avdd.t311 avdd pfet_05v0 ad=24.1516p pd=0.11066m as=0 ps=0 w=54.89u l=4u
VAUD491 avss.t123 audit_d491 0
X515 audit_d491 avss.t121 avss.t122 avss nfet_05v0 ad=3.322p pd=15.98u as=0 ps=0 w=7.55u l=4u
VAUD492 vgn2.t6 audit_d492 0
X516 audit_d492 vbp_cas.t21 pm2.t8 avdd pfet_05v0 ad=9.7724p pd=45.3u as=9.7724p ps=45.3u w=22.21u l=8u
VAUD493 pm1.t0 audit_d493 0
X517 audit_d493 y1.t17 avdd.t660 avdd pfet_05v0 ad=9.1344p pd=42.4u as=9.1344p ps=42.4u w=20.76u l=4u
VAUD494 avdd.t419 audit_d494 0
X518 audit_d494 avdd.t417 avdd.t418 avdd pfet_05v0 ad=9.7724p pd=45.3u as=0 ps=0 w=22.21u l=8u
VAUD495 psrg_vnc.t5 audit_d495 0
X519 audit_d495 vbp_i.t19 avdd.t611 avdd pfet_05v0 ad=7.8056p pd=36.36u as=7.8056p ps=36.36u w=17.74u l=4u
VAUD496 avss.t75 audit_d496 0
X520 audit_d496 avss.t73 avss.t74 avss nfet_05v0 ad=6.424p pd=30.08u as=0 ps=0 w=14.6u l=4u
VAUD497 rbit0top.t9 audit_d497 0
X521 audit_d497 b0.t3 rbit1top.t8 dvss nfet_03v3 ad=17.6p pd=80.88u as=17.6p ps=80.88u w=40u l=0.28u
R0 v1.n4 v1.t2 67.301
R1 v1.n1 v1.t6 65.546
R2 v1.n7 v1.t5 65.501
R3 v1.n4 v1.t3 65.4526
R4 v1.n5 v1.t4 65.4526
R5 v1.n1 v1.n0 46.7105
R6 v1.n2 v1.n0 18.0905
R7 v1.n3 v1.t1 15.379
R8 v1.n2 v1.t0 13.8293
R9 v1.n10 v1.n0 12.5555
R10 v1 v1.n10 10.3505
R11 v1.n5 v1.n4 7.6505
R12 v1.n9 v1.n8 4.1205
R13 v1.n1 v1.n7 3.8705
R14 v1.n10 v1.n9 2.2335
R15 v1.n9 v1.n3 2.02901
R16 v1.n8 v1.n1 1.1705
R17 v1.n8 v1.n6 0.699338
R18 v1.n6 v1.n5 0.555141
R19 v1.n7 v1.n6 0.480177
R20 v1.n3 v1.n2 0.233095
R21 net4 net4.t0 29.5063
R22 vq2 vq2.t0 48.3193
R23 net3 net3.t0 140.775
R24 vref.t15 vref.n0 6.00378
R25 vref.n8 vref.n7 30.3305
R26 vref.t13 vref.n19 27.7295
R27 vref.n20 vref.t11 26.3374
R28 vref.n21 vref.n20 25.4255
R29 vref.n19 vref.n18 25.4132
R30 vref.n9 vref.n8 21.9584
R31 vref.n2 vref.n22 23.0535
R32 vref.n4 vref.n5 17.2918
R33 vref.n12 vref.n11 14.8505
R34 vref.n11 vref.t2 13.8364
R35 vref.t15 vref.n17 10.3635
R36 vref.n7 vref.t5 10.0775
R37 vref.n9 vref.t4 9.28143
R38 vref.n14 vref.t1 9.27752
R39 vref.n12 vref.t3 9.27361
R40 vref.n14 vref.n13 9.2705
R41 vref.n19 vref.t14 9.12959
R42 vref.n21 vref.n5 9.09275
R43 vref.n20 vref.t12 9.07925
R44 vref.t8 vref.n5 9.0075
R45 vref.n3 vref.n22 9.0005
R46 vref.t14 vref.n4 9.0005
R47 vref.n18 vref.n0 10.4353
R48 vref.n18 vref.n4 8.2985
R49 vref.n0 vref.n7 94.7
R50 vref.n22 vref.n21 8.21525
R51 vref.n16 vref.n9 7.6505
R52 vref.n8 vref.t0 4.78535
R53 vref.n1 vref.n2 0.282009
R54 vref.n13 vref.n12 4.5005
R55 vref.n15 vref.n14 4.5005
R56 vref.n11 vref.n10 2.0495
R57 vref vref.n2 1.25494
R58 vref.t15 vref.t14 1.5365
R59 vref.t14 vref.t8 1.5335
R60 vref.n1 vref.n3 1.5165
R61 vref.n16 vref.n15 1.4405
R62 vref.n15 vref.n6 1.1255
R63 vref.n17 vref.n16 1.1255
R64 vref.n13 vref.n10 1.1255
R65 vref.t12 vref.t13 0.951922
R66 vref.n10 vref.n6 0.4325
R67 vref.t14 vref.t9 0.23471
R68 vref.t15 vref.t10 0.23271
R69 vref.n1 vref.t6 0.16771
R70 vref.t12 vref.n3 0.1485
R71 vref.n3 vref.t7 0.14771
R72 vref.n17 vref.n6 0.1445
R73 vref.n1 vref.t11 0.122697
R74 vref.t13 vref.t8 0.104594
R75 b1.n1 b1.t0 553.995
R76 b1.n0 b1.t2 52.3518
R77 b1.n0 b1.t1 34.9128
R78 b1 b1.n1 34.0655
R79 b1.n1 b1.n0 8.7305
R80 b2.n0 b2.t2 299.99
R81 b2.n1 b2.t0 44.8554
R82 b2.n0 b2.t1 30.7964
R83 b2 b2.n1 27.8105
R84 b2.n1 b2.n0 23.4005
R85 vq3 vq3.n0 46.2005
R86 vq3.n0 vq3.t2 22.347
R87 vq3.n2 vq3.n1 18.3321
R88 vq3.n2 vq3.t0 16.1042
R89 vq3.n1 vq3.t1 13.5475
R90 vq3 vq3.n2 13.1253
R91 vq3.n1 vq3.n0 4.5005
R92 b6 b6.n1 46.0805
R93 b6.n1 b6.t0 44.9115
R94 b6.n0 b6.t2 44.5322
R95 b6.n0 b6.t1 42.8627
R96 b6.n1 b6.n0 11.8355
R97 b5.n0 b5.t1 63.7544
R98 b5.n0 b5.t2 49.1564
R99 b5.n1 b5.t0 45.1489
R100 b5 b5.n1 37.0805
R101 b5.n1 b5.n0 6.2105
R102 b0.n0 b0.t3 557.883
R103 b0.n0 b0.t2 547.923
R104 b0.n1 b0.t1 44.9587
R105 b0 b0.n2 44.2355
R106 b0.n2 b0.t0 37.0514
R107 b0.n1 b0.n0 19.4405
R108 b0.n2 b0.n1 8.9555
R109 b4.n0 b4.t2 109.124
R110 b4.n1 b4.t0 49.3969
R111 b4 b4.n1 41.0855
R112 b4.n0 b4.t1 35.1074
R113 b4.n1 b4.n0 25.2455
R114 b3.n0 b3.t2 178.858
R115 b3.n1 b3.t0 44.8894
R116 b3 b3.n1 38.0705
R117 b3.n0 b3.t1 37.0593
R118 b3.n1 b3.n0 17.2355
R119 dvss dvss.n5 36.9527
R120 dvss.n2 dvss.t0 25.4907
R121 dvss.n0 dvss.t5 25.0538
R122 dvss.n1 dvss.t2 18.8163
R123 dvss.n1 dvss.n0 15.1205
R124 dvss.n5 dvss.n4 14.9766
R125 dvss.n4 dvss.t3 14.0112
R126 dvss.n0 dvss.t6 13.838
R127 dvss.n3 dvss.t4 13.7961
R128 dvss.n4 dvss.n3 10.3955
R129 dvss.n5 dvss.t1 9.2885
R130 dvss.n2 dvss.n1 4.8155
R131 dvss.n3 dvss.n2 0.9455
R132 avdd.n338 avdd.n301 57.6905
R133 avdd.n307 avdd.t310 52.1245
R134 avdd.n309 avdd.t308 52.1245
R135 avdd.n311 avdd.t306 52.1245
R136 avdd.n313 avdd.t304 52.1245
R137 avdd.n315 avdd.t302 52.1245
R138 avdd.n317 avdd.t300 52.1245
R139 avdd.n319 avdd.t298 52.1245
R140 avdd.n321 avdd.t296 52.1245
R141 avdd.n323 avdd.t294 52.1245
R142 avdd.n325 avdd.t292 52.1245
R143 avdd.n327 avdd.t290 52.1245
R144 avdd.n329 avdd.t288 52.1245
R145 avdd.n331 avdd.t286 52.1245
R146 avdd.n289 avdd.t411 52.1245
R147 avdd.n203 avdd.t413 52.1245
R148 avdd.n286 avdd.t415 52.1245
R149 avdd.n204 avdd.t465 52.1245
R150 avdd.n205 avdd.t463 52.1245
R151 avdd.n206 avdd.t461 52.1245
R152 avdd.n207 avdd.t459 52.1245
R153 avdd.n208 avdd.t457 52.1245
R154 avdd.n209 avdd.t455 52.1245
R155 avdd.n210 avdd.t453 52.1245
R156 avdd.n211 avdd.t451 52.1245
R157 avdd.n212 avdd.t449 52.1245
R158 avdd.n213 avdd.t447 52.1245
R159 avdd.n214 avdd.t445 52.1245
R160 avdd.n199 avdd.t443 52.1245
R161 avdd.n292 avdd.t441 51.8176
R162 avdd.n308 avdd.n306 46.6205
R163 avdd.n42 avdd.n278 46.3505
R164 avdd.n418 avdd.n417 43.8747
R165 avdd.n278 avdd.n277 40.5005
R166 avdd.n397 avdd.n17 38.336
R167 avdd.n2 avdd.t280 34.1748
R168 avdd.n3 avdd.t277 34.1748
R169 avdd.n4 avdd.t274 34.1748
R170 avdd.n5 avdd.t271 34.1748
R171 avdd.n6 avdd.t268 34.1748
R172 avdd.n7 avdd.t265 34.1748
R173 avdd.n8 avdd.t408 34.1748
R174 avdd.n9 avdd.t405 34.1748
R175 avdd.n10 avdd.t402 34.1748
R176 avdd.n11 avdd.t399 34.1748
R177 avdd.n12 avdd.t396 34.1748
R178 avdd.n13 avdd.t393 34.1748
R179 avdd.n14 avdd.t390 34.1748
R180 avdd.n15 avdd.t387 34.1748
R181 avdd.n16 avdd.t360 34.1748
R182 avdd.n17 avdd.t363 34.1748
R183 avdd.n18 avdd.t342 34.1748
R184 avdd.n19 avdd.t345 34.1748
R185 avdd.n20 avdd.t327 34.1748
R186 avdd.n21 avdd.t324 34.1748
R187 avdd.n22 avdd.t262 34.1748
R188 avdd.n23 avdd.t283 34.1748
R189 avdd.n193 avdd.n97 34.1547
R190 avdd.n188 avdd.n20 34.0085
R191 avdd.n86 avdd.n19 33.9927
R192 avdd.n370 avdd.n360 32.9126
R193 avdd.n343 avdd.t623 31.011
R194 avdd.n521 avdd.t609 30.8341
R195 avdd.n0 avdd.n24 27.9549
R196 avdd.n85 avdd.n25 27.8904
R197 avdd.n288 avdd.n287 27.0672
R198 avdd.n442 avdd.t574 25.6018
R199 avdd.n421 avdd.t656 25.1177
R200 avdd.n276 avdd.t642 24.0425
R201 avdd.n407 avdd.n107 23.6705
R202 avdd.n290 avdd.n288 23.3323
R203 avdd.n420 avdd.t638 22.7703
R204 avdd.n299 avdd.n294 22.5905
R205 avdd.n333 avdd.n332 22.2755
R206 avdd.n197 avdd.t585 21.2629
R207 avdd.n520 avdd.t578 21.2414
R208 avdd.n436 avdd.t602 21.2292
R209 avdd.n446 avdd.t565 21.228
R210 avdd.n482 avdd.t645 21.2278
R211 avdd.n461 avdd.t579 21.2278
R212 avdd.n503 avdd.t563 21.2278
R213 avdd.n431 avdd.t601 21.0905
R214 avdd.n24 avdd.t536 20.7944
R215 avdd.n25 avdd.t506 20.7944
R216 avdd.n26 avdd.t494 20.7944
R217 avdd.n27 avdd.t491 20.7944
R218 avdd.n28 avdd.t488 20.7944
R219 avdd.n29 avdd.t485 20.7944
R220 avdd.n30 avdd.t482 20.7944
R221 avdd.n31 avdd.t479 20.7944
R222 avdd.n32 avdd.t476 20.7944
R223 avdd.n33 avdd.t473 20.7944
R224 avdd.n34 avdd.t542 20.7944
R225 avdd.n35 avdd.t560 20.7944
R226 avdd.n36 avdd.t557 20.7944
R227 avdd.n37 avdd.t554 20.7944
R228 avdd.n38 avdd.t551 20.7944
R229 avdd.n39 avdd.t548 20.7944
R230 avdd.n40 avdd.t545 20.7944
R231 avdd.n41 avdd.t539 20.7944
R232 avdd.n243 avdd.t533 20.674
R233 avdd.n246 avdd.t503 20.674
R234 avdd.n306 avdd.t622 20.6195
R235 avdd.n451 avdd.t567 20.418
R236 avdd.n471 avdd.t592 20.4178
R237 avdd.n333 avdd.t632 20.0552
R238 avdd.n201 avdd.t665 19.6327
R239 avdd.n422 avdd.n421 18.4955
R240 avdd.n275 avdd.t639 18.206
R241 avdd.n276 avdd.t662 17.8718
R242 avdd.n277 avdd.t643 17.8522
R243 avdd.n276 avdd.n275 17.7305
R244 avdd.n439 avdd.n142 17.6549
R245 avdd.n274 avdd.n232 16.8652
R246 avdd.n45 avdd.t315 16.8102
R247 avdd.n46 avdd.t318 16.8102
R248 avdd.n47 avdd.t321 16.8102
R249 avdd.n48 avdd.t333 16.8102
R250 avdd.n49 avdd.t336 16.8102
R251 avdd.n50 avdd.t339 16.8102
R252 avdd.n51 avdd.t351 16.8102
R253 avdd.n52 avdd.t354 16.8102
R254 avdd.n53 avdd.t357 16.8102
R255 avdd.n54 avdd.t384 16.8102
R256 avdd.n55 avdd.t381 16.8102
R257 avdd.n56 avdd.t378 16.8102
R258 avdd.n57 avdd.t375 16.8102
R259 avdd.n58 avdd.t372 16.8102
R260 avdd.n59 avdd.t369 16.8102
R261 avdd.n60 avdd.t366 16.8102
R262 avdd.n61 avdd.t348 16.8102
R263 avdd.n62 avdd.t330 16.8102
R264 avdd.n63 avdd.t312 16.8102
R265 avdd.n64 avdd.t217 16.8102
R266 avdd.n65 avdd.t220 16.8102
R267 avdd.n66 avdd.t223 16.8102
R268 avdd.n67 avdd.t226 16.8102
R269 avdd.n68 avdd.t229 16.8102
R270 avdd.n69 avdd.t232 16.8102
R271 avdd.n70 avdd.t235 16.8102
R272 avdd.n71 avdd.t244 16.8102
R273 avdd.n72 avdd.t241 16.8102
R274 avdd.n73 avdd.t238 16.8102
R275 avdd.n74 avdd.t250 16.8102
R276 avdd.n75 avdd.t253 16.8102
R277 avdd.n76 avdd.t256 16.8102
R278 avdd.n77 avdd.t259 16.8102
R279 avdd.n437 avdd.n141 16.7549
R280 avdd.n198 avdd.n131 16.7436
R281 avdd.n351 avdd.t247 16.7137
R282 avdd.n441 avdd.t582 16.5942
R283 avdd.n362 avdd.n8 16.3872
R284 avdd.n340 avdd.t620 16.3751
R285 avdd.n536 avdd.t569 16.3364
R286 avdd.n537 avdd.t633 16.2991
R287 avdd.n535 avdd.t584 16.2991
R288 avdd.n302 avdd.t650 16.2294
R289 avdd.n233 avdd.t0 16.147
R290 avdd.n445 avdd.t575 16.0773
R291 avdd.n435 avdd.t577 16.0429
R292 avdd.n507 avdd.t596 16.0078
R293 avdd.n202 avdd.n201 15.7955
R294 avdd.n295 avdd.t666 15.7386
R295 avdd.n523 avdd.t667 15.7064
R296 avdd.n534 avdd.n165 14.7781
R297 avdd.n532 avdd.t603 14.6341
R298 avdd.n423 avdd.t614 14.4932
R299 avdd.n373 avdd.n372 14.4782
R300 avdd.n343 avdd.t647 14.3338
R301 avdd.n344 avdd.t648 13.9738
R302 avdd.n442 avdd.t591 13.9392
R303 avdd.n552 avdd.t659 13.9249
R304 avdd.n470 avdd.t593 13.9249
R305 avdd.n450 avdd.t568 13.9173
R306 avdd.n524 avdd.t573 13.9141
R307 avdd.n339 avdd.t618 13.9127
R308 avdd.n419 avdd.t571 13.8808
R309 avdd.n340 avdd.t655 13.8664
R310 avdd.n356 avdd.n355 13.8155
R311 avdd.n295 avdd.t663 13.8021
R312 avdd.n297 avdd.t594 13.8021
R313 avdd.n300 avdd.t610 13.8021
R314 avdd.n296 avdd.t664 13.7586
R315 avdd.n335 avdd.t586 13.7532
R316 avdd.n304 avdd.t613 13.7364
R317 avdd.n302 avdd.t649 13.6877
R318 avdd.n303 avdd.t607 13.6795
R319 avdd.n421 avdd.n420 13.3205
R320 avdd.n522 avdd.n157 12.9781
R321 avdd.n420 avdd.n419 12.9155
R322 avdd.n368 avdd.n361 12.1672
R323 avdd.n288 avdd.n203 12.1643
R324 avdd.n551 avdd.t658 12.0928
R325 avdd.n508 avdd.n507 12.0605
R326 avdd.n448 avdd.n443 11.9705
R327 avdd.n438 avdd.n435 11.9705
R328 avdd.n337 avdd.n336 11.9705
R329 avdd.n187 avdd.n284 11.6105
R330 avdd.n372 avdd.n359 11.2925
R331 avdd.n87 avdd.t438 11.0479
R332 avdd.n88 avdd.t435 11.0479
R333 avdd.n89 avdd.t432 11.0479
R334 avdd.n90 avdd.t429 11.0479
R335 avdd.n91 avdd.t426 11.0479
R336 avdd.n92 avdd.t423 11.0479
R337 avdd.n93 avdd.t420 11.0479
R338 avdd.n94 avdd.t417 11.0479
R339 avdd.n95 avdd.t470 11.0479
R340 avdd.n96 avdd.t467 11.0479
R341 avdd.n97 avdd.t500 11.0479
R342 avdd.n98 avdd.t497 11.0479
R343 avdd.n99 avdd.t530 11.0479
R344 avdd.n100 avdd.t527 11.0479
R345 avdd.n101 avdd.t524 11.0479
R346 avdd.n102 avdd.t521 11.0479
R347 avdd.n103 avdd.t518 11.0479
R348 avdd.n104 avdd.t515 11.0479
R349 avdd.n105 avdd.t512 11.0479
R350 avdd.n106 avdd.t509 11.0479
R351 avdd.n274 avdd.n0 10.9655
R352 avdd.n484 avdd.n483 10.9355
R353 avdd.n403 avdd.n402 10.7105
R354 avdd.n410 avdd.n409 10.6824
R355 avdd.n363 avdd.n10 10.5072
R356 avdd.n366 avdd.n13 10.5072
R357 avdd.n367 avdd.n14 10.5072
R358 avdd.n399 avdd.n15 10.5072
R359 avdd.n416 avdd.n2 10.4952
R360 avdd.n415 avdd.n3 10.4952
R361 avdd.n414 avdd.n4 10.4952
R362 avdd.n413 avdd.n5 10.4952
R363 avdd.n412 avdd.n6 10.4952
R364 avdd.n369 avdd.n368 10.3212
R365 avdd.n258 avdd.t624 10.1244
R366 avdd.n264 avdd.t570 10.1244
R367 avdd.n390 avdd.t612 10.0857
R368 avdd.n381 avdd.t615 10.0857
R369 avdd.n374 avdd.t598 10.0857
R370 avdd.n390 avdd.t583 9.79773
R371 avdd.n391 avdd.t608 9.79773
R372 avdd.n392 avdd.t572 9.79773
R373 avdd.n393 avdd.t605 9.79773
R374 avdd.n394 avdd.t606 9.79773
R375 avdd.n381 avdd.t616 9.79773
R376 avdd.n382 avdd.t617 9.79773
R377 avdd.n383 avdd.t651 9.79773
R378 avdd.n384 avdd.t652 9.79773
R379 avdd.n385 avdd.t653 9.79773
R380 avdd.n374 avdd.t599 9.79773
R381 avdd.n375 avdd.t600 9.79773
R382 avdd.n376 avdd.t635 9.79773
R383 avdd.n377 avdd.t636 9.79773
R384 avdd.n378 avdd.t637 9.79773
R385 avdd.n258 avdd.t625 9.74635
R386 avdd.n259 avdd.t626 9.74635
R387 avdd.n260 avdd.t627 9.74635
R388 avdd.n261 avdd.t660 9.74635
R389 avdd.n262 avdd.t661 9.74635
R390 avdd.n264 avdd.t629 9.74635
R391 avdd.n265 avdd.t628 9.74635
R392 avdd.n266 avdd.t630 9.74635
R393 avdd.n267 avdd.t631 9.74635
R394 avdd.n268 avdd.t641 9.74635
R395 avdd.n301 avdd.n300 9.6755
R396 avdd.n109 avdd.t118 9.56798
R397 avdd.n110 avdd.t145 9.56798
R398 avdd.n111 avdd.t73 9.56798
R399 avdd.n112 avdd.t121 9.56798
R400 avdd.n113 avdd.t142 9.56798
R401 avdd.n114 avdd.t139 9.56798
R402 avdd.n115 avdd.t136 9.56798
R403 avdd.n116 avdd.t133 9.56798
R404 avdd.n117 avdd.t127 9.56798
R405 avdd.n118 avdd.t124 9.56798
R406 avdd.n119 avdd.t40 9.56798
R407 avdd.n120 avdd.t43 9.56798
R408 avdd.n121 avdd.t46 9.56798
R409 avdd.n122 avdd.t49 9.56798
R410 avdd.n123 avdd.t52 9.56798
R411 avdd.n124 avdd.t55 9.56798
R412 avdd.n125 avdd.t58 9.56798
R413 avdd.n126 avdd.t61 9.56798
R414 avdd.n127 avdd.t76 9.56798
R415 avdd.n43 avdd.t130 9.55923
R416 avdd.n128 avdd.t172 9.5496
R417 avdd.n129 avdd.t178 9.5496
R418 avdd.n130 avdd.t175 9.5496
R419 avdd.n131 avdd.t190 9.5496
R420 avdd.n132 avdd.t214 9.5496
R421 avdd.n133 avdd.t211 9.5496
R422 avdd.n134 avdd.t208 9.5496
R423 avdd.n135 avdd.t205 9.5496
R424 avdd.n136 avdd.t202 9.5496
R425 avdd.n137 avdd.t199 9.5496
R426 avdd.n138 avdd.t196 9.5496
R427 avdd.n139 avdd.t193 9.5496
R428 avdd.n140 avdd.t187 9.5496
R429 avdd.n141 avdd.t184 9.5496
R430 avdd.n142 avdd.t181 9.5496
R431 avdd.n143 avdd.t169 9.5496
R432 avdd.n144 avdd.t166 9.5496
R433 avdd.n145 avdd.t163 9.5496
R434 avdd.n146 avdd.t160 9.5496
R435 avdd.n147 avdd.t157 9.5496
R436 avdd.n148 avdd.t154 9.5496
R437 avdd.n149 avdd.t151 9.5496
R438 avdd.n150 avdd.t148 9.5496
R439 avdd.n431 avdd.t589 9.47292
R440 avdd.n151 avdd.t37 9.45768
R441 avdd.n152 avdd.t34 9.45768
R442 avdd.n153 avdd.t31 9.45768
R443 avdd.n154 avdd.t28 9.45768
R444 avdd.n155 avdd.t25 9.45768
R445 avdd.n156 avdd.t1 9.45768
R446 avdd.n157 avdd.t64 9.45768
R447 avdd.n158 avdd.t4 9.45768
R448 avdd.n159 avdd.t7 9.45768
R449 avdd.n160 avdd.t10 9.45768
R450 avdd.n161 avdd.t13 9.45768
R451 avdd.n162 avdd.t16 9.45768
R452 avdd.n163 avdd.t19 9.45768
R453 avdd.n164 avdd.t22 9.45768
R454 avdd.n165 avdd.t67 9.45768
R455 avdd.n166 avdd.t70 9.45768
R456 avdd.n167 avdd.t79 9.45768
R457 avdd.n168 avdd.t82 9.45768
R458 avdd.n169 avdd.t85 9.45768
R459 avdd.n170 avdd.t88 9.45768
R460 avdd.n171 avdd.t91 9.45768
R461 avdd.n172 avdd.t94 9.45768
R462 avdd.n173 avdd.t97 9.45768
R463 avdd.n174 avdd.t100 9.45768
R464 avdd.n175 avdd.t103 9.45768
R465 avdd.n176 avdd.t106 9.45768
R466 avdd.n177 avdd.t109 9.45768
R467 avdd.n78 avdd.t112 9.44903
R468 avdd.n80 avdd.t115 9.44903
R469 avdd.n422 avdd.t657 9.44874
R470 avdd.n533 avdd.t634 9.31644
R471 avdd.n337 avdd.t619 9.31374
R472 avdd.n301 avdd.t611 9.30213
R473 avdd.n197 avdd.t576 9.30055
R474 avdd.n434 avdd.t588 9.30055
R475 avdd.n520 avdd.t604 9.27907
R476 avdd.n336 avdd.t654 9.27324
R477 avdd.n436 avdd.t581 9.2668
R478 avdd.n440 avdd.t590 9.2668
R479 avdd.n298 avdd.t595 9.25863
R480 avdd.n334 avdd.t587 9.24726
R481 avdd.n482 avdd.t646 9.24493
R482 avdd.n461 avdd.t580 9.24493
R483 avdd.n503 avdd.t564 9.24493
R484 avdd.n506 avdd.t597 9.24493
R485 avdd.n446 avdd.t566 9.2373
R486 avdd.n458 avdd.n180 9.20563
R487 avdd.n467 avdd.n465 9.18707
R488 avdd.n305 avdd.t621 9.17845
R489 avdd.n488 avdd.n485 9.16095
R490 avdd.n490 avdd.n489 9.15963
R491 avdd.n492 avdd.n491 9.15963
R492 avdd.n495 avdd.n494 9.1294
R493 avdd.n493 avdd.n487 9.12895
R494 avdd.n201 avdd.t644 9.11234
R495 avdd.n481 avdd.n480 9.0805
R496 avdd.n515 avdd.n514 9.0805
R497 avdd.n498 avdd.n484 9.0805
R498 avdd.n474 avdd.n469 9.07055
R499 avdd.n476 avdd.n466 9.03338
R500 avdd.n473 avdd.n182 9.02607
R501 avdd.n513 avdd.n512 9.0045
R502 avdd.n233 avdd.n232 9.00078
R503 avdd.n194 avdd.n181 9.00058
R504 avdd.n478 avdd.n477 9.00054
R505 avdd.n84 avdd.n479 9.0005
R506 avdd.n432 avdd.n430 8.9105
R507 avdd.n185 avdd.n423 8.645
R508 avdd.n279 avdd.n99 8.45972
R509 avdd.n444 avdd.n129 8.45089
R510 avdd.n452 avdd.n143 8.45089
R511 avdd.n539 avdd.n167 8.45034
R512 avdd.n225 avdd.n87 8.43347
R513 avdd.n516 avdd.n151 8.42934
R514 avdd.n424 avdd.n132 8.40739
R515 avdd.n554 avdd.n553 8.2805
R516 avdd.n449 avdd.n448 8.2805
R517 avdd.n511 avdd.n510 8.2805
R518 avdd.n445 avdd.n444 8.1455
R519 avdd.n247 avdd.n26 7.61495
R520 avdd.n235 avdd.n35 7.61495
R521 avdd.n449 avdd.n128 7.59588
R522 avdd.n525 avdd.n156 7.57434
R523 avdd.n341 avdd.n64 7.5715
R524 avdd.n336 avdd.n335 7.4705
R525 avdd.n335 avdd.n334 7.3805
R526 avdd.n532 avdd.n183 7.2275
R527 avdd.n480 avdd.n464 7.1555
R528 avdd.n525 avdd.n524 7.1555
R529 avdd.n234 avdd.n233 7.10976
R530 avdd.n534 avdd.n533 7.0205
R531 avdd.n521 avdd.n520 7.0205
R532 avdd.n440 avdd.n439 7.0205
R533 avdd.n434 avdd.n433 7.0205
R534 avdd.n198 avdd.n197 7.0205
R535 avdd.n437 avdd.n436 7.0205
R536 avdd.n305 avdd.n304 6.8855
R537 avdd.n483 avdd.n482 6.8405
R538 avdd.n506 avdd.n459 6.8405
R539 avdd.n447 avdd.n446 6.8405
R540 avdd.n462 avdd.n461 6.8405
R541 avdd.n504 avdd.n503 6.8405
R542 avdd.n432 avdd.n431 6.7955
R543 avdd.n298 avdd.n297 6.7505
R544 avdd.n232 avdd.t640 6.74714
R545 avdd.n553 avdd.n552 6.6605
R546 avdd.n450 avdd.n449 6.6605
R547 avdd.n423 avdd.n422 6.6155
R548 avdd.n533 avdd.n532 6.5705
R549 avdd.n419 avdd.n418 6.5705
R550 avdd.n338 avdd.n337 6.3905
R551 avdd.n308 avdd.n307 6.08935
R552 avdd.n310 avdd.n309 6.08935
R553 avdd.n312 avdd.n311 6.08935
R554 avdd.n314 avdd.n313 6.08935
R555 avdd.n316 avdd.n315 6.08935
R556 avdd.n318 avdd.n317 6.08935
R557 avdd.n320 avdd.n319 6.08935
R558 avdd.n322 avdd.n321 6.08935
R559 avdd.n324 avdd.n323 6.08935
R560 avdd.n326 avdd.n325 6.08935
R561 avdd.n328 avdd.n327 6.08935
R562 avdd.n330 avdd.n329 6.08935
R563 avdd.n332 avdd.n331 6.08935
R564 avdd.n290 avdd.n289 6.08935
R565 avdd.n287 avdd.n286 6.08935
R566 avdd.n186 avdd.n204 6.08935
R567 avdd.n224 avdd.n205 6.08935
R568 avdd.n223 avdd.n206 6.08935
R569 avdd.n222 avdd.n207 6.08935
R570 avdd.n221 avdd.n208 6.08935
R571 avdd.n220 avdd.n209 6.08935
R572 avdd.n219 avdd.n210 6.08935
R573 avdd.n218 avdd.n211 6.08935
R574 avdd.n217 avdd.n212 6.08935
R575 avdd.n216 avdd.n213 6.08935
R576 avdd.n215 avdd.n214 6.08935
R577 avdd.n200 avdd.n199 6.08935
R578 avdd.n299 avdd.n298 6.0305
R579 avdd.n364 avdd.n11 6.00121
R580 avdd.n411 avdd.n7 5.99522
R581 avdd.n410 avdd.n22 5.99522
R582 avdd.n417 avdd.n23 5.99522
R583 avdd.n362 avdd.n9 5.99372
R584 avdd.n365 avdd.n12 5.99372
R585 avdd.n396 avdd.n16 5.98097
R586 avdd.n86 avdd.n18 5.97872
R587 avdd.n188 avdd.n21 5.97872
R588 avdd.n412 avdd.n411 5.9405
R589 avdd.n417 avdd.n416 5.9405
R590 avdd.n366 avdd.n365 5.9405
R591 avdd.n363 avdd.n362 5.9405
R592 avdd.n348 avdd.n70 5.9065
R593 avdd.n358 avdd.n73 5.905
R594 avdd.n247 avdd.n27 5.90495
R595 avdd.n248 avdd.n28 5.90495
R596 avdd.n249 avdd.n29 5.90495
R597 avdd.n250 avdd.n30 5.90495
R598 avdd.n251 avdd.n31 5.90495
R599 avdd.n252 avdd.n32 5.90495
R600 avdd.n253 avdd.n33 5.90495
R601 avdd.n240 avdd.n34 5.90495
R602 avdd.n235 avdd.n36 5.90495
R603 avdd.n236 avdd.n37 5.90495
R604 avdd.n237 avdd.n38 5.90495
R605 avdd.n238 avdd.n39 5.90495
R606 avdd.n239 avdd.n40 5.90495
R607 avdd.n234 avdd.n41 5.90495
R608 avdd.n400 avdd.n54 5.88794
R609 avdd.n359 avdd.n45 5.881
R610 avdd.n372 avdd.n46 5.881
R611 avdd.n373 avdd.n47 5.881
R612 avdd.n360 avdd.n48 5.881
R613 avdd.n370 avdd.n49 5.881
R614 avdd.n371 avdd.n50 5.881
R615 avdd.n361 avdd.n51 5.881
R616 avdd.n368 avdd.n52 5.881
R617 avdd.n369 avdd.n53 5.881
R618 avdd.n401 avdd.n55 5.881
R619 avdd.n402 avdd.n56 5.881
R620 avdd.n403 avdd.n57 5.881
R621 avdd.n404 avdd.n58 5.881
R622 avdd.n405 avdd.n59 5.881
R623 avdd.n406 avdd.n60 5.881
R624 avdd.n179 avdd.n61 5.881
R625 avdd.n178 avdd.n62 5.881
R626 avdd.n108 avdd.n63 5.881
R627 avdd.n341 avdd.n65 5.881
R628 avdd.n342 avdd.n66 5.881
R629 avdd.n190 avdd.n67 5.881
R630 avdd.n346 avdd.n68 5.881
R631 avdd.n347 avdd.n69 5.881
R632 avdd.n355 avdd.n71 5.881
R633 avdd.n357 avdd.n72 5.881
R634 avdd.n107 avdd.n74 5.881
R635 avdd.n407 avdd.n75 5.881
R636 avdd.n408 avdd.n76 5.881
R637 avdd.n409 avdd.n77 5.881
R638 avdd.n231 avdd.n94 5.86847
R639 avdd.n538 avdd.n166 5.85471
R640 avdd.n430 avdd.n140 5.85363
R641 avdd.n538 avdd.n537 5.851
R642 avdd.n225 avdd.n88 5.84972
R643 avdd.n226 avdd.n89 5.84972
R644 avdd.n227 avdd.n90 5.84972
R645 avdd.n228 avdd.n91 5.84972
R646 avdd.n229 avdd.n92 5.84972
R647 avdd.n230 avdd.n93 5.84972
R648 avdd.n278 avdd.n95 5.84972
R649 avdd.n42 avdd.n96 5.84972
R650 avdd.n193 avdd.n98 5.84972
R651 avdd.n279 avdd.n100 5.84972
R652 avdd.n280 avdd.n101 5.84972
R653 avdd.n281 avdd.n102 5.84972
R654 avdd.n282 avdd.n103 5.84972
R655 avdd.n283 avdd.n104 5.84972
R656 avdd.n284 avdd.n105 5.84972
R657 avdd.n187 avdd.n106 5.84972
R658 avdd.n457 avdd.n150 5.84838
R659 avdd.n515 avdd.n109 5.84099
R660 avdd.n488 avdd.n110 5.84099
R661 avdd.n512 avdd.n111 5.84099
R662 avdd.n484 avdd.n112 5.84099
R663 avdd.n494 avdd.n113 5.84099
R664 avdd.n493 avdd.n114 5.84099
R665 avdd.n492 avdd.n115 5.84099
R666 avdd.n489 avdd.n116 5.84099
R667 avdd.n557 avdd.n117 5.84099
R668 avdd.n180 avdd.n118 5.84099
R669 avdd.n472 avdd.n119 5.84099
R670 avdd.n182 avdd.n120 5.84099
R671 avdd.n181 avdd.n121 5.84099
R672 avdd.n469 avdd.n122 5.84099
R673 avdd.n466 avdd.n123 5.84099
R674 avdd.n478 avdd.n124 5.84099
R675 avdd.n479 avdd.n125 5.84099
R676 avdd.n465 avdd.n126 5.84099
R677 avdd.n480 avdd.n127 5.84099
R678 avdd.n444 avdd.n130 5.84088
R679 avdd.n424 avdd.n133 5.84088
R680 avdd.n425 avdd.n134 5.84088
R681 avdd.n426 avdd.n135 5.84088
R682 avdd.n427 avdd.n136 5.84088
R683 avdd.n185 avdd.n137 5.84088
R684 avdd.n428 avdd.n138 5.84088
R685 avdd.n429 avdd.n139 5.84088
R686 avdd.n452 avdd.n144 5.84088
R687 avdd.n453 avdd.n145 5.84088
R688 avdd.n454 avdd.n146 5.84088
R689 avdd.n455 avdd.n147 5.84088
R690 avdd.n456 avdd.n148 5.84088
R691 avdd.n184 avdd.n149 5.84088
R692 avdd.n516 avdd.n152 5.84034
R693 avdd.n517 avdd.n153 5.84034
R694 avdd.n518 avdd.n154 5.84034
R695 avdd.n519 avdd.n155 5.84034
R696 avdd.n526 avdd.n158 5.84034
R697 avdd.n527 avdd.n159 5.84034
R698 avdd.n528 avdd.n160 5.84034
R699 avdd.n529 avdd.n161 5.84034
R700 avdd.n530 avdd.n162 5.84034
R701 avdd.n531 avdd.n163 5.84034
R702 avdd.n183 avdd.n164 5.84034
R703 avdd.n539 avdd.n168 5.84034
R704 avdd.n540 avdd.n169 5.84034
R705 avdd.n541 avdd.n170 5.84034
R706 avdd.n542 avdd.n171 5.84034
R707 avdd.n543 avdd.n172 5.84034
R708 avdd.n544 avdd.n173 5.84034
R709 avdd.n545 avdd.n174 5.84034
R710 avdd.n546 avdd.n175 5.84034
R711 avdd.n547 avdd.n176 5.84034
R712 avdd.n548 avdd.n177 5.84034
R713 avdd.n483 avdd.n459 5.5805
R714 avdd.n447 avdd.n445 5.5805
R715 avdd.n433 avdd.n198 5.5805
R716 avdd.n275 avdd.n274 5.4905
R717 avdd.n507 avdd.n506 5.2205
R718 avdd.n471 avdd.n470 5.2205
R719 avdd.n451 avdd.n450 5.2205
R720 avdd.n435 avdd.n434 5.2205
R721 avdd.n254 avdd.n253 5.10463
R722 avdd.n291 avdd.n290 5.10463
R723 avdd.n272 avdd.n85 5.07913
R724 avdd.n294 avdd.n293 5.04078
R725 avdd.n418 avdd.n340 4.9955
R726 avdd.n349 avdd.n348 4.99282
R727 avdd.n400 avdd.n399 4.947
R728 avdd.n349 avdd.n345 4.8438
R729 avdd.n354 avdd.n353 4.78705
R730 avdd.n522 avdd.n521 4.6805
R731 avdd.n438 avdd.n437 4.6805
R732 avdd.n257 avdd.n256 4.6686
R733 avdd.n441 avdd.n440 4.6355
R734 avdd.n44 avdd.n191 0.0968457
R735 avdd.n379 avdd.n373 4.56198
R736 avdd.n388 avdd.n371 4.56161
R737 avdd.n398 avdd.n369 4.56123
R738 avdd.n79 avdd.n548 4.84354
R739 avdd.n272 avdd.n243 4.50652
R740 avdd.n254 avdd.n246 4.50652
R741 avdd.n292 avdd.n291 4.50652
R742 avdd.n351 avdd.n350 4.50652
R743 avdd.n192 avdd.n191 2.24018
R744 avdd.n511 avdd.n460 4.5005
R745 avdd.n552 avdd.n551 4.5005
R746 avdd.n79 avdd.n78 1.34398
R747 avdd.n0 avdd.n242 4.5005
R748 avdd.n85 avdd.n271 4.5005
R749 avdd.n245 avdd.n244 4.5005
R750 avdd.n85 avdd.n257 4.5005
R751 avdd.n189 avdd.n188 0.273405
R752 avdd.n387 avdd.n86 4.5005
R753 avdd.n397 avdd.n396 4.5005
R754 avdd.n356 avdd.n190 4.487
R755 avdd.n345 avdd.n344 4.37586
R756 avdd.n550 avdd.n549 4.2755
R757 avdd.n364 avdd.n363 3.72782
R758 avdd.n408 avdd.n407 3.58817
R759 avdd.n358 avdd.n357 3.54317
R760 avdd.n187 avdd.n186 3.2255
R761 avdd.n182 avdd.n471 3.14825
R762 avdd.n242 avdd.n241 3.11988
R763 avdd.n184 avdd.n451 3.11
R764 avdd.n535 avdd.n534 2.8805
R765 avdd.n537 avdd.n536 2.8805
R766 avdd.n433 avdd.n432 2.8805
R767 avdd.n285 avdd.n42 2.8505
R768 avdd.n421 avdd.n339 2.7905
R769 avdd.n508 avdd.n505 2.7005
R770 avdd.n502 avdd.n464 2.7005
R771 avdd.n536 avdd.n535 2.7005
R772 avdd.n479 avdd.n465 2.6105
R773 avdd.n479 avdd.n478 2.6105
R774 avdd.n478 avdd.n466 2.6105
R775 avdd.n469 avdd.n466 2.6105
R776 avdd.n181 avdd.n469 2.6105
R777 avdd.n182 avdd.n181 2.6105
R778 avdd.n183 avdd.n519 2.6105
R779 avdd.n519 avdd.n518 2.6105
R780 avdd.n518 avdd.n517 2.6105
R781 avdd.n517 avdd.n516 2.6105
R782 avdd.n531 avdd.n530 2.6105
R783 avdd.n530 avdd.n529 2.6105
R784 avdd.n529 avdd.n528 2.6105
R785 avdd.n528 avdd.n527 2.6105
R786 avdd.n527 avdd.n526 2.6105
R787 avdd.n523 avdd.n522 2.6105
R788 avdd.n548 avdd.n547 2.6105
R789 avdd.n547 avdd.n546 2.6105
R790 avdd.n546 avdd.n545 2.6105
R791 avdd.n545 avdd.n544 2.6105
R792 avdd.n544 avdd.n543 2.6105
R793 avdd.n543 avdd.n542 2.6105
R794 avdd.n542 avdd.n541 2.6105
R795 avdd.n541 avdd.n540 2.6105
R796 avdd.n540 avdd.n539 2.6105
R797 avdd.n428 avdd.n185 2.6105
R798 avdd.n230 avdd.n229 2.6105
R799 avdd.n229 avdd.n228 2.6105
R800 avdd.n228 avdd.n227 2.6105
R801 avdd.n227 avdd.n226 2.6105
R802 avdd.n226 avdd.n225 2.6105
R803 avdd.n284 avdd.n283 2.6105
R804 avdd.n283 avdd.n282 2.6105
R805 avdd.n282 avdd.n281 2.6105
R806 avdd.n281 avdd.n280 2.6105
R807 avdd.n280 avdd.n279 2.6105
R808 avdd.n427 avdd.n426 2.6105
R809 avdd.n426 avdd.n425 2.6105
R810 avdd.n425 avdd.n424 2.6105
R811 avdd.n184 avdd.n456 2.6105
R812 avdd.n456 avdd.n455 2.6105
R813 avdd.n455 avdd.n454 2.6105
R814 avdd.n454 avdd.n453 2.6105
R815 avdd.n453 avdd.n452 2.6105
R816 avdd.n191 avdd.n557 2.6105
R817 avdd.n492 avdd.n489 2.6105
R818 avdd.n493 avdd.n492 2.6105
R819 avdd.n494 avdd.n493 2.6105
R820 avdd.n489 avdd.n191 2.5955
R821 avdd.n494 avdd.n488 2.582
R822 avdd.n429 avdd.n428 2.567
R823 avdd.n231 avdd.n230 2.5655
R824 avdd.n557 avdd.n180 2.5655
R825 avdd.n81 avdd.n79 2.66611
R826 avdd.n304 avdd.n303 2.5205
R827 avdd.n303 avdd.n302 2.5205
R828 avdd.n1 avdd.n272 0.436242
R829 avdd.n256 avdd.n255 2.27975
R830 avdd.n296 avdd.n295 2.1605
R831 avdd.n470 avdd.n460 2.0705
R832 avdd.n443 avdd.n441 1.9805
R833 avdd.n297 avdd.n296 1.9805
R834 avdd.n357 avdd.n356 1.9355
R835 avdd.n554 avdd.n459 1.8005
R836 avdd.n448 avdd.n447 1.8005
R837 avdd.n553 avdd.n515 1.7555
R838 avdd.n512 avdd.n511 1.7555
R839 avdd.n401 avdd.n400 1.72149
R840 avdd.n505 avdd.n504 1.7105
R841 avdd.n330 avdd.n328 1.7105
R842 avdd.n328 avdd.n326 1.7105
R843 avdd.n326 avdd.n324 1.7105
R844 avdd.n324 avdd.n322 1.7105
R845 avdd.n322 avdd.n320 1.7105
R846 avdd.n320 avdd.n318 1.7105
R847 avdd.n318 avdd.n316 1.7105
R848 avdd.n316 avdd.n314 1.7105
R849 avdd.n314 avdd.n312 1.7105
R850 avdd.n312 avdd.n310 1.7105
R851 avdd.n310 avdd.n308 1.7105
R852 avdd.n294 avdd.n200 1.7105
R853 avdd.n215 avdd.n200 1.7105
R854 avdd.n216 avdd.n215 1.7105
R855 avdd.n217 avdd.n216 1.7105
R856 avdd.n218 avdd.n217 1.7105
R857 avdd.n219 avdd.n218 1.7105
R858 avdd.n220 avdd.n219 1.7105
R859 avdd.n221 avdd.n220 1.7105
R860 avdd.n222 avdd.n221 1.7105
R861 avdd.n223 avdd.n222 1.7105
R862 avdd.n224 avdd.n223 1.7105
R863 avdd.n186 avdd.n224 1.7105
R864 avdd.n252 avdd.n251 1.7105
R865 avdd.n251 avdd.n250 1.7105
R866 avdd.n250 avdd.n249 1.7105
R867 avdd.n249 avdd.n248 1.7105
R868 avdd.n248 avdd.n247 1.7105
R869 avdd.n239 avdd.n238 1.7105
R870 avdd.n238 avdd.n237 1.7105
R871 avdd.n237 avdd.n236 1.7105
R872 avdd.n236 avdd.n235 1.7105
R873 avdd.n409 avdd.n408 1.7105
R874 avdd.n405 avdd.n404 1.7105
R875 avdd.n404 avdd.n403 1.7105
R876 avdd.n402 avdd.n401 1.7105
R877 avdd.n371 avdd.n370 1.7105
R878 avdd.n347 avdd.n346 1.7105
R879 avdd.n190 avdd.n342 1.7105
R880 avdd.n342 avdd.n341 1.7105
R881 avdd.n510 avdd.n462 1.7105
R882 avdd.n240 avdd.n239 1.6955
R883 avdd.n355 avdd.n354 1.6895
R884 avdd.n406 avdd.n405 1.682
R885 avdd.n332 avdd.n330 1.6805
R886 avdd.n253 avdd.n252 1.673
R887 avdd.n108 avdd.n359 1.6655
R888 avdd.n178 avdd.n360 1.6655
R889 avdd.n179 avdd.n361 1.6655
R890 avdd.n348 avdd.n347 1.6655
R891 avdd.n241 avdd.n240 1.63129
R892 avdd.n277 avdd.n276 1.6205
R893 avdd.n379 avdd.n189 1.31496
R894 avdd.n413 avdd.n412 1.4405
R895 avdd.n414 avdd.n413 1.4405
R896 avdd.n415 avdd.n414 1.4405
R897 avdd.n416 avdd.n415 1.4405
R898 avdd.n367 avdd.n366 1.4405
R899 avdd.n353 avdd.n352 1.43481
R900 avdd.n293 avdd.t442 1.38724
R901 avdd.n510 avdd.n509 1.3655
R902 avdd.n271 avdd.n263 1.3415
R903 avdd.n285 avdd.n186 1.34105
R904 avdd.n513 avdd.n460 1.2855
R905 avdd.n344 avdd.n343 1.2605
R906 avdd.n365 avdd.n364 1.22379
R907 avdd.n179 avdd.n406 1.22082
R908 avdd.n334 avdd.n333 1.2155
R909 avdd.n399 avdd.n367 1.2155
R910 avdd.n411 avdd.n410 1.1705
R911 avdd.n82 avdd.n556 1.1295
R912 avdd.n509 avdd.n508 1.1255
R913 avdd.n505 avdd.n463 1.1255
R914 avdd.n502 avdd.n501 1.1255
R915 avdd.n500 avdd.n464 1.1255
R916 avdd.n270 avdd.n269 1.1255
R917 avdd.n386 avdd.n380 1.1255
R918 avdd.n395 avdd.n389 1.1255
R919 avdd.n339 avdd.n338 1.0805
R920 avdd.n430 avdd.n429 1.06944
R921 avdd.n551 avdd.n550 0.9455
R922 avdd.n524 avdd.n523 0.9005
R923 avdd.n443 avdd.n442 0.9005
R924 avdd.n439 avdd.n438 0.9005
R925 avdd.n526 avdd.n525 0.8555
R926 avdd.n504 avdd.n502 0.8105
R927 avdd.n508 avdd.n462 0.8105
R928 avdd.n287 avdd.n285 0.725787
R929 avdd.n399 avdd.n398 0.7205
R930 avdd.n556 avdd.n554 0.5855
R931 avdd.n293 avdd.n202 0.551312
R932 avdd.n353 avdd.n350 0.501038
R933 avdd.n300 avdd.n299 0.4955
R934 avdd.n549 avdd.n538 0.47529
R935 avdd.n549 avdd.n81 2.69722
R936 avdd.n271 avdd.n270 0.442245
R937 avdd.n396 avdd.n395 0.411125
R938 avdd.n291 avdd.n202 0.409662
R939 avdd.t442 avdd.n292 0.404702
R940 avdd.n354 avdd.n345 0.399831
R941 avdd.n389 avdd.n388 0.398975
R942 avdd.n380 avdd.n379 0.383225
R943 avdd.n262 avdd.n261 0.3785
R944 avdd.n261 avdd.n260 0.3785
R945 avdd.n260 avdd.n259 0.3785
R946 avdd.n259 avdd.n258 0.3785
R947 avdd.n268 avdd.n267 0.3785
R948 avdd.n267 avdd.n266 0.3785
R949 avdd.n266 avdd.n265 0.3785
R950 avdd.n265 avdd.n264 0.3785
R951 avdd.n257 avdd.n245 0.368921
R952 avdd.n387 avdd.n380 0.337775
R953 avdd.n44 avdd.n43 3.39671
R954 avdd.n255 avdd.n254 0.325737
R955 avdd.n397 avdd.n389 0.322025
R956 avdd.n556 avdd.n555 0.291612
R957 avdd.n394 avdd.n393 0.2885
R958 avdd.n393 avdd.n392 0.2885
R959 avdd.n392 avdd.n391 0.2885
R960 avdd.n391 avdd.n390 0.2885
R961 avdd.n385 avdd.n384 0.2885
R962 avdd.n384 avdd.n383 0.2885
R963 avdd.n383 avdd.n382 0.2885
R964 avdd.n382 avdd.n381 0.2885
R965 avdd.n378 avdd.n377 0.2885
R966 avdd.n377 avdd.n376 0.2885
R967 avdd.n376 avdd.n375 0.2885
R968 avdd.n375 avdd.n374 0.2885
R969 avdd.n481 avdd.n84 0.284152
R970 avdd.n1 avdd.n0 2.44088
R971 avdd.n45 avdd.t317 0.259912
R972 avdd.n46 avdd.t320 0.259912
R973 avdd.n47 avdd.t323 0.259912
R974 avdd.n48 avdd.t335 0.259912
R975 avdd.n49 avdd.t338 0.259912
R976 avdd.n50 avdd.t341 0.259912
R977 avdd.n51 avdd.t353 0.259912
R978 avdd.n52 avdd.t356 0.259912
R979 avdd.n53 avdd.t359 0.259912
R980 avdd.n54 avdd.t386 0.259912
R981 avdd.n55 avdd.t383 0.259912
R982 avdd.n56 avdd.t380 0.259912
R983 avdd.n57 avdd.t377 0.259912
R984 avdd.n58 avdd.t374 0.259912
R985 avdd.n59 avdd.t371 0.259912
R986 avdd.n60 avdd.t368 0.259912
R987 avdd.n61 avdd.t350 0.259912
R988 avdd.n62 avdd.t332 0.259912
R989 avdd.n63 avdd.t314 0.259912
R990 avdd.n352 avdd.t248 0.259912
R991 avdd.n352 avdd.t249 0.259912
R992 avdd.n64 avdd.t219 0.259912
R993 avdd.n65 avdd.t222 0.259912
R994 avdd.n66 avdd.t225 0.259912
R995 avdd.n67 avdd.t228 0.259912
R996 avdd.n68 avdd.t231 0.259912
R997 avdd.n69 avdd.t234 0.259912
R998 avdd.n70 avdd.t237 0.259912
R999 avdd.n71 avdd.t246 0.259912
R1000 avdd.n72 avdd.t243 0.259912
R1001 avdd.n73 avdd.t240 0.259912
R1002 avdd.n74 avdd.t252 0.259912
R1003 avdd.n75 avdd.t255 0.259912
R1004 avdd.n76 avdd.t258 0.259912
R1005 avdd.n77 avdd.t261 0.259912
R1006 avdd.n2 avdd.t282 0.257728
R1007 avdd.n3 avdd.t279 0.257728
R1008 avdd.n4 avdd.t276 0.257728
R1009 avdd.n5 avdd.t273 0.257728
R1010 avdd.n6 avdd.t270 0.257728
R1011 avdd.n7 avdd.t267 0.257728
R1012 avdd.n8 avdd.t410 0.257728
R1013 avdd.n9 avdd.t407 0.257728
R1014 avdd.n10 avdd.t404 0.257728
R1015 avdd.n11 avdd.t401 0.257728
R1016 avdd.n12 avdd.t398 0.257728
R1017 avdd.n13 avdd.t395 0.257728
R1018 avdd.n14 avdd.t392 0.257728
R1019 avdd.n15 avdd.t389 0.257728
R1020 avdd.n16 avdd.t362 0.257728
R1021 avdd.n17 avdd.t365 0.257728
R1022 avdd.n18 avdd.t344 0.257728
R1023 avdd.n19 avdd.t347 0.257728
R1024 avdd.n20 avdd.t329 0.257728
R1025 avdd.n21 avdd.t326 0.257728
R1026 avdd.n22 avdd.t264 0.257728
R1027 avdd.n23 avdd.t285 0.257728
R1028 avdd.n509 avdd.n463 0.2565
R1029 avdd.n501 avdd.n500 0.2565
R1030 avdd.n398 avdd.n397 0.2525
R1031 avdd.n388 avdd.n387 0.2525
R1032 avdd.n501 avdd.n463 0.2405
R1033 avdd.n550 avdd.n515 0.234387
R1034 avdd.n255 avdd.n245 0.2327
R1035 avdd.n151 avdd.t39 0.227567
R1036 avdd.n152 avdd.t36 0.227567
R1037 avdd.n153 avdd.t33 0.227567
R1038 avdd.n154 avdd.t30 0.227567
R1039 avdd.n155 avdd.t27 0.227567
R1040 avdd.n156 avdd.t3 0.227567
R1041 avdd.n157 avdd.t66 0.227567
R1042 avdd.n158 avdd.t6 0.227567
R1043 avdd.n159 avdd.t9 0.227567
R1044 avdd.n160 avdd.t12 0.227567
R1045 avdd.n161 avdd.t15 0.227567
R1046 avdd.n162 avdd.t18 0.227567
R1047 avdd.n163 avdd.t21 0.227567
R1048 avdd.n164 avdd.t24 0.227567
R1049 avdd.n165 avdd.t69 0.227567
R1050 avdd.n166 avdd.t72 0.227567
R1051 avdd.n78 avdd.t114 0.227567
R1052 avdd.n167 avdd.t81 0.227567
R1053 avdd.n168 avdd.t84 0.227567
R1054 avdd.n169 avdd.t87 0.227567
R1055 avdd.n170 avdd.t90 0.227567
R1056 avdd.n171 avdd.t93 0.227567
R1057 avdd.n172 avdd.t96 0.227567
R1058 avdd.n173 avdd.t99 0.227567
R1059 avdd.n174 avdd.t102 0.227567
R1060 avdd.n175 avdd.t105 0.227567
R1061 avdd.n176 avdd.t108 0.227567
R1062 avdd.n177 avdd.t111 0.227567
R1063 avdd.n80 avdd.t117 0.227567
R1064 avdd.n128 avdd.t174 0.226542
R1065 avdd.n129 avdd.t180 0.226542
R1066 avdd.n130 avdd.t177 0.226542
R1067 avdd.n131 avdd.t192 0.226542
R1068 avdd.n132 avdd.t216 0.226542
R1069 avdd.n133 avdd.t213 0.226542
R1070 avdd.n134 avdd.t210 0.226542
R1071 avdd.n135 avdd.t207 0.226542
R1072 avdd.n136 avdd.t204 0.226542
R1073 avdd.n137 avdd.t201 0.226542
R1074 avdd.n138 avdd.t198 0.226542
R1075 avdd.n139 avdd.t195 0.226542
R1076 avdd.n140 avdd.t189 0.226542
R1077 avdd.n141 avdd.t186 0.226542
R1078 avdd.n142 avdd.t183 0.226542
R1079 avdd.n143 avdd.t171 0.226542
R1080 avdd.n144 avdd.t168 0.226542
R1081 avdd.n145 avdd.t165 0.226542
R1082 avdd.n146 avdd.t162 0.226542
R1083 avdd.n147 avdd.t159 0.226542
R1084 avdd.n148 avdd.t156 0.226542
R1085 avdd.n149 avdd.t153 0.226542
R1086 avdd.n150 avdd.t150 0.226542
R1087 avdd.n109 avdd.t120 0.22634
R1088 avdd.n43 avdd.t132 0.22634
R1089 avdd.n110 avdd.t147 0.22634
R1090 avdd.n111 avdd.t75 0.22634
R1091 avdd.n112 avdd.t123 0.22634
R1092 avdd.n113 avdd.t144 0.22634
R1093 avdd.n114 avdd.t141 0.22634
R1094 avdd.n115 avdd.t138 0.22634
R1095 avdd.n116 avdd.t135 0.22634
R1096 avdd.n117 avdd.t129 0.22634
R1097 avdd.n118 avdd.t126 0.22634
R1098 avdd.n119 avdd.t42 0.22634
R1099 avdd.n120 avdd.t45 0.22634
R1100 avdd.n121 avdd.t48 0.22634
R1101 avdd.n122 avdd.t51 0.22634
R1102 avdd.n123 avdd.t54 0.22634
R1103 avdd.n124 avdd.t57 0.22634
R1104 avdd.n125 avdd.t60 0.22634
R1105 avdd.n126 avdd.t63 0.22634
R1106 avdd.n127 avdd.t78 0.22634
R1107 avdd.n395 avdd.n394 0.2228
R1108 avdd.n386 avdd.n385 0.2228
R1109 avdd.n189 avdd.n378 0.310592
R1110 avdd.n270 avdd.n242 0.2165
R1111 avdd.n24 avdd.t538 0.20635
R1112 avdd.n273 avdd.t534 0.20635
R1113 avdd.n273 avdd.t535 0.20635
R1114 avdd.n25 avdd.t508 0.20635
R1115 avdd.n26 avdd.t496 0.20635
R1116 avdd.n27 avdd.t493 0.20635
R1117 avdd.n28 avdd.t490 0.20635
R1118 avdd.n29 avdd.t487 0.20635
R1119 avdd.n30 avdd.t484 0.20635
R1120 avdd.n31 avdd.t481 0.20635
R1121 avdd.n32 avdd.t478 0.20635
R1122 avdd.n33 avdd.t475 0.20635
R1123 avdd.n256 avdd.t504 0.20635
R1124 avdd.n256 avdd.t505 0.20635
R1125 avdd.n34 avdd.t544 0.20635
R1126 avdd.n35 avdd.t562 0.20635
R1127 avdd.n36 avdd.t559 0.20635
R1128 avdd.n37 avdd.t556 0.20635
R1129 avdd.n38 avdd.t553 0.20635
R1130 avdd.n39 avdd.t550 0.20635
R1131 avdd.n40 avdd.t547 0.20635
R1132 avdd.n41 avdd.t541 0.20635
R1133 avdd.n500 avdd.n499 0.2005
R1134 avdd.n87 avdd.t440 0.193083
R1135 avdd.n88 avdd.t437 0.193083
R1136 avdd.n89 avdd.t434 0.193083
R1137 avdd.n90 avdd.t431 0.193083
R1138 avdd.n91 avdd.t428 0.193083
R1139 avdd.n92 avdd.t425 0.193083
R1140 avdd.n93 avdd.t422 0.193083
R1141 avdd.n94 avdd.t419 0.193083
R1142 avdd.n95 avdd.t472 0.193083
R1143 avdd.n96 avdd.t469 0.193083
R1144 avdd.n97 avdd.t502 0.193083
R1145 avdd.n98 avdd.t499 0.193083
R1146 avdd.n99 avdd.t532 0.193083
R1147 avdd.n100 avdd.t529 0.193083
R1148 avdd.n101 avdd.t526 0.193083
R1149 avdd.n102 avdd.t523 0.193083
R1150 avdd.n103 avdd.t520 0.193083
R1151 avdd.n104 avdd.t517 0.193083
R1152 avdd.n105 avdd.t514 0.193083
R1153 avdd.n106 avdd.t511 0.193083
R1154 avdd.n263 avdd.n262 0.1868
R1155 avdd.n269 avdd.n268 0.1868
R1156 avdd.n475 avdd.n468 0.183707
R1157 avdd.n263 avdd.n244 0.1787
R1158 avdd.n491 avdd.n486 0.170875
R1159 avdd.n195 avdd.n196 0.0487132
R1160 avdd.n273 avdd.n1 1.46668
R1161 avdd.n273 avdd.n243 0.156984
R1162 avdd.n256 avdd.n246 0.156984
R1163 avdd.n514 avdd.n513 0.156929
R1164 avdd.n331 avdd.t287 0.155181
R1165 avdd.n329 avdd.t289 0.155181
R1166 avdd.n327 avdd.t291 0.155181
R1167 avdd.n325 avdd.t293 0.155181
R1168 avdd.n323 avdd.t295 0.155181
R1169 avdd.n321 avdd.t297 0.155181
R1170 avdd.n319 avdd.t299 0.155181
R1171 avdd.n317 avdd.t301 0.155181
R1172 avdd.n315 avdd.t303 0.155181
R1173 avdd.n313 avdd.t305 0.155181
R1174 avdd.n311 avdd.t307 0.155181
R1175 avdd.n309 avdd.t309 0.155181
R1176 avdd.n307 avdd.t311 0.155181
R1177 avdd.n289 avdd.t412 0.155181
R1178 avdd.n286 avdd.t416 0.155181
R1179 avdd.n214 avdd.t446 0.155181
R1180 avdd.n213 avdd.t448 0.155181
R1181 avdd.n212 avdd.t450 0.155181
R1182 avdd.n211 avdd.t452 0.155181
R1183 avdd.n210 avdd.t454 0.155181
R1184 avdd.n209 avdd.t456 0.155181
R1185 avdd.n208 avdd.t458 0.155181
R1186 avdd.n207 avdd.t460 0.155181
R1187 avdd.n206 avdd.t462 0.155181
R1188 avdd.n205 avdd.t464 0.155181
R1189 avdd.n204 avdd.t466 0.155181
R1190 avdd.n203 avdd.t414 0.155181
R1191 avdd.n199 avdd.t444 0.155181
R1192 avdd.n555 avdd.n192 0.17017
R1193 avdd.n194 avdd.n473 0.135989
R1194 avdd.n306 avdd.n305 0.1355
R1195 avdd.n499 avdd.n498 0.128929
R1196 avdd.n477 avdd.n476 0.127989
R1197 avdd.n352 avdd.n351 0.125484
R1198 avdd.n477 avdd.n84 0.119989
R1199 avdd.n491 avdd.n490 0.101981
R1200 avdd.n497 avdd.n496 0.1005
R1201 avdd.n474 avdd.n195 0.0943978
R1202 avdd.n495 avdd.n485 0.0904484
R1203 avdd.n557 avdd.n83 9.14876
R1204 avdd.n83 avdd.n82 0.0355714
R1205 avdd.n475 avdd.n474 0.0885
R1206 avdd.n196 avdd.n473 0.0620137
R1207 avdd.n497 avdd.n485 0.0861055
R1208 avdd.n514 avdd.n458 0.0843923
R1209 avdd.n195 avdd.n194 0.0826923
R1210 avdd.n83 avdd.n458 0.0998572
R1211 avdd.n241 avdd.n234 0.0791087
R1212 avdd.n498 avdd.n497 0.0767
R1213 avdd.n350 avdd.n349 0.0748204
R1214 avdd.n495 avdd.n487 0.0725
R1215 avdd.n496 avdd.n486 0.0725
R1216 avdd.n468 avdd.n467 0.0725
R1217 avdd.n499 avdd.n481 0.0645
R1218 avdd.n196 avdd.n472 9.31584
R1219 avdd.n42 avdd.n193 1.01368
R1220 avdd.n555 avdd.n44 4.59378
R1221 avdd.n490 avdd.n82 0.0520066
R1222 avdd.n496 avdd.n495 0.0485
R1223 avdd.n477 avdd.n468 0.0477727
R1224 avdd.n476 avdd.n475 0.0443571
R1225 avdd.n487 avdd.n486 0.0441364
R1226 avdd avdd.n192 4.62755
R1227 avdd.n185 avdd.n427 2.6105
R1228 avdd.n183 avdd.n531 2.6105
R1229 avdd.n182 avdd.n472 2.6105
R1230 avdd.n457 avdd.n184 2.603
R1231 avdd.n180 avdd.n457 1.99344
R1232 avdd.n346 avdd.n190 1.7105
R1233 avdd.n178 avdd.n179 1.23732
R1234 avdd.n108 avdd.n178 1.23732
R1235 avdd.n107 avdd.n108 1.23732
R1236 avdd.n107 avdd.n358 1.23732
R1237 avdd.n193 avdd.n187 1.02867
R1238 avdd.n86 avdd.n386 0.437375
R1239 avdd.n80 avdd.t116 0.255526
R1240 avdd.n177 avdd.t110 0.247754
R1241 avdd.n176 avdd.t107 0.247754
R1242 avdd.n175 avdd.t104 0.247754
R1243 avdd.n174 avdd.t101 0.247754
R1244 avdd.n173 avdd.t98 0.247754
R1245 avdd.n172 avdd.t95 0.247754
R1246 avdd.n171 avdd.t92 0.247754
R1247 avdd.n170 avdd.t89 0.247754
R1248 avdd.n169 avdd.t86 0.247754
R1249 avdd.n168 avdd.t83 0.247754
R1250 avdd.n167 avdd.t80 0.247754
R1251 avdd.n166 avdd.t71 0.247754
R1252 avdd.n165 avdd.t68 0.247754
R1253 avdd.n164 avdd.t23 0.247754
R1254 avdd.n163 avdd.t20 0.247754
R1255 avdd.n162 avdd.t17 0.247754
R1256 avdd.n161 avdd.t14 0.247754
R1257 avdd.n160 avdd.t11 0.247754
R1258 avdd.n159 avdd.t8 0.247754
R1259 avdd.n158 avdd.t5 0.247754
R1260 avdd.n157 avdd.t65 0.247754
R1261 avdd.n156 avdd.t2 0.247754
R1262 avdd.n155 avdd.t26 0.247754
R1263 avdd.n154 avdd.t29 0.247754
R1264 avdd.n153 avdd.t32 0.247754
R1265 avdd.n152 avdd.t35 0.247754
R1266 avdd.n151 avdd.t38 0.247754
R1267 avdd.n150 avdd.t149 0.246919
R1268 avdd.n149 avdd.t152 0.246919
R1269 avdd.n148 avdd.t155 0.246919
R1270 avdd.n147 avdd.t158 0.246919
R1271 avdd.n146 avdd.t161 0.246919
R1272 avdd.n145 avdd.t164 0.246919
R1273 avdd.n144 avdd.t167 0.246919
R1274 avdd.n143 avdd.t170 0.246919
R1275 avdd.n142 avdd.t182 0.246919
R1276 avdd.n141 avdd.t185 0.246919
R1277 avdd.n140 avdd.t188 0.246919
R1278 avdd.n139 avdd.t194 0.246919
R1279 avdd.n138 avdd.t197 0.246919
R1280 avdd.n137 avdd.t200 0.246919
R1281 avdd.n136 avdd.t203 0.246919
R1282 avdd.n135 avdd.t206 0.246919
R1283 avdd.n134 avdd.t209 0.246919
R1284 avdd.n133 avdd.t212 0.246919
R1285 avdd.n132 avdd.t215 0.246919
R1286 avdd.n131 avdd.t191 0.246919
R1287 avdd.n130 avdd.t176 0.246919
R1288 avdd.n129 avdd.t179 0.246919
R1289 avdd.n128 avdd.t173 0.246919
R1290 avdd.n127 avdd.t77 0.246754
R1291 avdd.n126 avdd.t62 0.246754
R1292 avdd.n125 avdd.t59 0.246754
R1293 avdd.n124 avdd.t56 0.246754
R1294 avdd.n123 avdd.t53 0.246754
R1295 avdd.n122 avdd.t50 0.246754
R1296 avdd.n121 avdd.t47 0.246754
R1297 avdd.n120 avdd.t44 0.246754
R1298 avdd.n119 avdd.t41 0.246754
R1299 avdd.n118 avdd.t125 0.246754
R1300 avdd.n117 avdd.t128 0.246754
R1301 avdd.n116 avdd.t134 0.246754
R1302 avdd.n115 avdd.t137 0.246754
R1303 avdd.n114 avdd.t140 0.246754
R1304 avdd.n113 avdd.t143 0.246754
R1305 avdd.n112 avdd.t122 0.246754
R1306 avdd.n111 avdd.t74 0.246754
R1307 avdd.n110 avdd.t146 0.246754
R1308 avdd.n109 avdd.t119 0.246754
R1309 avdd.n106 avdd.t510 0.216528
R1310 avdd.n105 avdd.t513 0.216528
R1311 avdd.n104 avdd.t516 0.216528
R1312 avdd.n103 avdd.t519 0.216528
R1313 avdd.n102 avdd.t522 0.216528
R1314 avdd.n101 avdd.t525 0.216528
R1315 avdd.n100 avdd.t528 0.216528
R1316 avdd.n99 avdd.t531 0.216528
R1317 avdd.n98 avdd.t498 0.216528
R1318 avdd.n97 avdd.t501 0.216528
R1319 avdd.n96 avdd.t468 0.216528
R1320 avdd.n95 avdd.t471 0.216528
R1321 avdd.n94 avdd.t418 0.216528
R1322 avdd.n93 avdd.t421 0.216528
R1323 avdd.n92 avdd.t424 0.216528
R1324 avdd.n91 avdd.t427 0.216528
R1325 avdd.n90 avdd.t430 0.216528
R1326 avdd.n89 avdd.t433 0.216528
R1327 avdd.n88 avdd.t436 0.216528
R1328 avdd.n87 avdd.t439 0.216528
R1329 avdd.n85 avdd.n244 0.13985
R1330 avdd.n467 avdd.n84 0.0721208
R1331 avdd avdd.n82 0.0659211
R1332 avdd.n81 avdd.n80 1.34398
R1333 avdd.n42 avdd.n231 1.02493
R1334 avdd.n23 avdd.t284 0.297099
R1335 avdd.n22 avdd.t263 0.297099
R1336 avdd.n21 avdd.t325 0.297099
R1337 avdd.n20 avdd.t328 0.297099
R1338 avdd.n19 avdd.t346 0.297099
R1339 avdd.n18 avdd.t343 0.297099
R1340 avdd.n17 avdd.t364 0.297099
R1341 avdd.n16 avdd.t361 0.297099
R1342 avdd.n15 avdd.t388 0.297099
R1343 avdd.n14 avdd.t391 0.297099
R1344 avdd.n13 avdd.t394 0.297099
R1345 avdd.n12 avdd.t397 0.297099
R1346 avdd.n11 avdd.t400 0.297099
R1347 avdd.n10 avdd.t403 0.297099
R1348 avdd.n9 avdd.t406 0.297099
R1349 avdd.n8 avdd.t409 0.297099
R1350 avdd.n7 avdd.t266 0.297099
R1351 avdd.n6 avdd.t269 0.297099
R1352 avdd.n5 avdd.t272 0.297099
R1353 avdd.n4 avdd.t275 0.297099
R1354 avdd.n3 avdd.t278 0.297099
R1355 avdd.n2 avdd.t281 0.297099
R1356 avdd.n77 avdd.t260 0.288017
R1357 avdd.n76 avdd.t257 0.288017
R1358 avdd.n75 avdd.t254 0.288017
R1359 avdd.n74 avdd.t251 0.288017
R1360 avdd.n73 avdd.t239 0.288017
R1361 avdd.n72 avdd.t242 0.288017
R1362 avdd.n71 avdd.t245 0.288017
R1363 avdd.n70 avdd.t236 0.288017
R1364 avdd.n69 avdd.t233 0.288017
R1365 avdd.n68 avdd.t230 0.288017
R1366 avdd.n67 avdd.t227 0.288017
R1367 avdd.n66 avdd.t224 0.288017
R1368 avdd.n65 avdd.t221 0.288017
R1369 avdd.n64 avdd.t218 0.288017
R1370 avdd.n63 avdd.t313 0.288017
R1371 avdd.n62 avdd.t331 0.288017
R1372 avdd.n61 avdd.t349 0.288017
R1373 avdd.n60 avdd.t367 0.288017
R1374 avdd.n59 avdd.t370 0.288017
R1375 avdd.n58 avdd.t373 0.288017
R1376 avdd.n57 avdd.t376 0.288017
R1377 avdd.n56 avdd.t379 0.288017
R1378 avdd.n55 avdd.t382 0.288017
R1379 avdd.n54 avdd.t385 0.288017
R1380 avdd.n53 avdd.t358 0.288017
R1381 avdd.n52 avdd.t355 0.288017
R1382 avdd.n51 avdd.t352 0.288017
R1383 avdd.n50 avdd.t340 0.288017
R1384 avdd.n49 avdd.t337 0.288017
R1385 avdd.n48 avdd.t334 0.288017
R1386 avdd.n47 avdd.t322 0.288017
R1387 avdd.n46 avdd.t319 0.288017
R1388 avdd.n45 avdd.t316 0.288017
R1389 avdd.n269 avdd.n0 0.26255
R1390 avdd.n78 avdd.t113 0.255526
R1391 avdd.n43 avdd.t131 0.254627
R1392 avdd.n41 avdd.t540 0.240736
R1393 avdd.n40 avdd.t546 0.240736
R1394 avdd.n39 avdd.t549 0.240736
R1395 avdd.n38 avdd.t552 0.240736
R1396 avdd.n37 avdd.t555 0.240736
R1397 avdd.n36 avdd.t558 0.240736
R1398 avdd.n35 avdd.t561 0.240736
R1399 avdd.n34 avdd.t543 0.240736
R1400 avdd.n33 avdd.t474 0.240736
R1401 avdd.n32 avdd.t477 0.240736
R1402 avdd.n31 avdd.t480 0.240736
R1403 avdd.n30 avdd.t483 0.240736
R1404 avdd.n29 avdd.t486 0.240736
R1405 avdd.n28 avdd.t489 0.240736
R1406 avdd.n27 avdd.t492 0.240736
R1407 avdd.n26 avdd.t495 0.240736
R1408 avdd.n25 avdd.t507 0.240736
R1409 avdd.n24 avdd.t537 0.240736
R1410 dvdd.n11 dvdd.n10 41.2133
R1411 dvdd.n12 dvdd.n11 25.9411
R1412 dvdd.n10 dvdd.n9 23.4735
R1413 dvdd.n2 dvdd.n3 20.0705
R1414 dvdd.n6 dvdd.t6 16.5268
R1415 dvdd.n8 dvdd.t5 15.1483
R1416 dvdd.n2 dvdd.t0 15.0931
R1417 dvdd.n3 dvdd.t3 15.0481
R1418 dvdd.n11 dvdd.t1 10.5249
R1419 dvdd.n10 dvdd.t4 10.5033
R1420 dvdd.n5 dvdd.t2 10.4782
R1421 dvdd.n2 dvdd.n8 10.4405
R1422 dvdd.n5 dvdd.n4 6.0305
R1423 dvdd.n6 dvdd.n5 5.13038
R1424 dvdd.n4 dvdd.n1 2.53348
R1425 dvdd.n9 dvdd.n2 2.4305
R1426 dvdd.n8 dvdd.n7 1.35458
R1427 dvdd.n2 dvdd.n1 1.1705
R1428 dvdd.n7 dvdd.n6 1.12573
R1429 dvdd.n9 dvdd.n0 1.1255
R1430 dvdd dvdd.n12 1.00821
R1431 dvdd.n12 dvdd.n0 0.761363
R1432 dvdd.n7 dvdd.n1 0.199468
R1433 dvdd.n4 dvdd.n3 0.1355
R1434 dvdd.n1 dvdd.n0 0.1205
R1435 avss.n1869 avss.n1867 122.168
R1436 avss.n1871 avss.n1867 122.168
R1437 avss.n1871 avss.n1870 122.168
R1438 avss.n1870 avss.n1869 122.168
R1439 avss.n1766 avss.n1764 122.168
R1440 avss.n1768 avss.n1764 122.168
R1441 avss.n1768 avss.n1767 122.168
R1442 avss.n1767 avss.n1766 122.168
R1443 avss.n1757 avss.n1755 122.168
R1444 avss.n1759 avss.n1755 122.168
R1445 avss.n1759 avss.n1758 122.168
R1446 avss.n1758 avss.n1757 122.168
R1447 avss.n1743 avss.n1741 122.168
R1448 avss.n1745 avss.n1741 122.168
R1449 avss.n1745 avss.n1744 122.168
R1450 avss.n1744 avss.n1743 122.168
R1451 avss.n1796 avss.n1794 122.168
R1452 avss.n1798 avss.n1794 122.168
R1453 avss.n1798 avss.n1797 122.168
R1454 avss.n1797 avss.n1796 122.168
R1455 avss.n1733 avss.n1731 122.168
R1456 avss.n1735 avss.n1731 122.168
R1457 avss.n1735 avss.n1734 122.168
R1458 avss.n1734 avss.n1733 122.168
R1459 avss.n1817 avss.n1815 122.168
R1460 avss.n1819 avss.n1815 122.168
R1461 avss.n1819 avss.n1818 122.168
R1462 avss.n1818 avss.n1817 122.168
R1463 avss.n1806 avss.n1804 122.168
R1464 avss.n1808 avss.n1804 122.168
R1465 avss.n1808 avss.n1807 122.168
R1466 avss.n1807 avss.n1806 122.168
R1467 avss.n1783 avss.n1781 122.168
R1468 avss.n1785 avss.n1781 122.168
R1469 avss.n1785 avss.n1784 122.168
R1470 avss.n1784 avss.n1783 122.168
R1471 avss.n1775 avss.n1773 122.168
R1472 avss.n1777 avss.n1773 122.168
R1473 avss.n1777 avss.n1776 122.168
R1474 avss.n1776 avss.n1775 122.168
R1475 avss.n1828 avss.n321 56.9413
R1476 avss.n92 avss.t218 34.4009
R1477 avss.n88 avss.t216 34.3877
R1478 avss.n87 avss.t214 32.981
R1479 avss.n93 avss.t212 32.966
R1480 avss.n212 avss.n134 32.6655
R1481 avss.n270 avss.n262 28.8005
R1482 avss.n318 avss.t220 26.2661
R1483 avss.n1833 avss 25.1725
R1484 avss.n109 avss 24.3005
R1485 avss.n277 avss.n134 23.3105
R1486 avss.n111 avss.t237 23.0375
R1487 avss.n1752 avss.t200 22.9013
R1488 avss.n319 avss.n317 20.1265
R1489 avss.n1831 avss.n1830 20.0705
R1490 avss.n1836 avss.n1835 19.6655
R1491 avss.n316 avss.n315 19.6205
R1492 avss.n1837 avss.t0 18.6687
R1493 avss.n1833 avss.n1832 18.6305
R1494 avss.n111 avss.t238 18.3645
R1495 avss.n139 avss.t199 18.3299
R1496 avss.n1824 avss.n1823 18.2705
R1497 avss.n1832 avss.t207 17.852
R1498 avss.n316 avss.n115 17.7305
R1499 avss.n86 avss.n1728 17.2733
R1500 avss.n1830 avss.t209 16.619
R1501 avss.n1836 avss.n111 15.9755
R1502 avss.n90 avss.n129 15.7588
R1503 avss.n305 avss.t208 15.5285
R1504 avss.n269 avss.n268 15.3455
R1505 avss.n17 avss.t73 15.1395
R1506 avss.n18 avss.t88 15.1395
R1507 avss.n19 avss.t91 15.1395
R1508 avss.n20 avss.t94 15.1395
R1509 avss.n21 avss.t97 15.1395
R1510 avss.n22 avss.t100 15.1395
R1511 avss.n23 avss.t103 15.1395
R1512 avss.n24 avss.t67 15.1395
R1513 avss.n25 avss.t64 15.1395
R1514 avss.n26 avss.t61 15.1395
R1515 avss.n27 avss.t58 15.1395
R1516 avss.n28 avss.t55 15.1395
R1517 avss.n29 avss.t52 15.1395
R1518 avss.n30 avss.t70 15.1395
R1519 avss.n1834 avss.t206 14.7703
R1520 avss.n1841 avss.t204 14.7027
R1521 avss.n1835 avss.t232 14.1655
R1522 avss.n307 avss.t239 13.9283
R1523 avss.n1850 avss.n1843 13.8021
R1524 avss.n1840 avss.n78 13.6894
R1525 avss.n1837 avss.n1836 13.4105
R1526 avss.n242 avss.n0 13.4469
R1527 avss.n1835 avss.n1834 12.5555
R1528 avss.n31 avss.t166 12.4325
R1529 avss.n32 avss.t181 12.4325
R1530 avss.n33 avss.t175 12.4325
R1531 avss.n34 avss.t172 12.4325
R1532 avss.n35 avss.t169 12.4325
R1533 avss.n36 avss.t184 12.4325
R1534 avss.n37 avss.t187 12.4325
R1535 avss.n38 avss.t190 12.4325
R1536 avss.n39 avss.t193 12.4325
R1537 avss.n285 avss.t178 12.4049
R1538 avss.n1825 avss.n1824 12.0207
R1539 avss.n228 avss.n200 11.5205
R1540 avss.n227 avss.n226 11.5205
R1541 avss.n245 avss.n242 11.5205
R1542 avss.n232 avss.n200 11.1605
R1543 avss.n1847 avss.n1846 10.7105
R1544 avss.n1848 avss.n1847 10.6655
R1545 avss.n1047 avss.n1046 10.5005
R1546 avss.n156 avss.n40 10.4555
R1547 avss.n151 avss.t240 10.3787
R1548 avss.n190 avss.t198 10.3787
R1549 avss.n321 avss.t205 10.3067
R1550 avss.n317 avss.t234 10.2353
R1551 avss.n151 avss.t201 9.82074
R1552 avss.n152 avss.t202 9.82074
R1553 avss.n153 avss.t203 9.82074
R1554 avss.n154 avss.t196 9.82074
R1555 avss.n155 avss.t197 9.82074
R1556 avss.n190 avss.t1 9.82074
R1557 avss.n191 avss.t2 9.82074
R1558 avss.n192 avss.t3 9.82074
R1559 avss.n193 avss.t235 9.82074
R1560 avss.n194 avss.t236 9.82074
R1561 avss.n1839 avss.t233 9.70008
R1562 avss.n1762 avss 9.2255
R1563 avss.n318 avss.t230 9.2111
R1564 avss.n92 avss.t228 9.2036
R1565 avss.n88 avss.t226 9.2036
R1566 avss.n87 avss.t224 9.2036
R1567 avss.n1823 avss.n1822 9.1805
R1568 avss.n1864 avss.n1863 9.1355
R1569 avss.n1762 avss 9.0905
R1570 avss.n1792 avss 9.0905
R1571 avss.n1801 avss 9.0905
R1572 avss avss.n95 9.0905
R1573 avss avss.n69 0.0458889
R1574 avss.n68 avss.n69 4.51233
R1575 avss.n1813 avss 9.014
R1576 avss.n1789 avss 9.014
R1577 avss.n321 avss.n320 9.0005
R1578 avss.n1739 avss.n1738 9.0005
R1579 avss.n1788 avss 9.0005
R1580 avss.n1831 avss.n112 8.9555
R1581 avss.n72 avss.t79 8.66734
R1582 avss.n73 avss.t121 8.66734
R1583 avss.n74 avss.t118 8.66734
R1584 avss.n75 avss.t115 8.66734
R1585 avss.n76 avss.t112 8.66734
R1586 avss.n77 avss.t106 8.66734
R1587 avss.n78 avss.t109 8.66734
R1588 avss.n79 avss.t82 8.66734
R1589 avss.n80 avss.t85 8.66734
R1590 avss.n81 avss.t76 8.66734
R1591 avss.n43 avss.t25 8.35004
R1592 avss.n44 avss.t163 8.35004
R1593 avss.n45 avss.t151 8.35004
R1594 avss.n46 avss.t148 8.35004
R1595 avss.n47 avss.t145 8.35004
R1596 avss.n48 avss.t160 8.35004
R1597 avss.n49 avss.t157 8.35004
R1598 avss.n50 avss.t154 8.35004
R1599 avss.n51 avss.t139 8.35004
R1600 avss.n52 avss.t46 8.35004
R1601 avss.n53 avss.t136 8.35004
R1602 avss.n54 avss.t22 8.35004
R1603 avss.n55 avss.t19 8.35004
R1604 avss.n56 avss.t16 8.35004
R1605 avss.n57 avss.t13 8.35004
R1606 avss.n58 avss.t10 8.35004
R1607 avss.n59 avss.t7 8.35004
R1608 avss.n60 avss.t4 8.35004
R1609 avss.n239 avss.t142 8.29121
R1610 avss.n197 avss.t43 8.29121
R1611 avss.n306 avss.n119 8.2805
R1612 avss.n1726 avss.n326 8.16717
R1613 avss.n220 avss.n219 7.9925
R1614 avss.n222 avss.n202 7.988
R1615 avss.n289 avss.n288 7.772
R1616 avss.n110 avss.n80 7.73065
R1617 avss.n101 avss.n73 7.62445
R1618 avss.n1844 avss.n24 7.53742
R1619 avss.n15 avss.n1841 7.5155
R1620 avss.n676 avss.n326 7.0005
R1621 avss.n676 avss.n675 7.0005
R1622 avss.n680 avss.n675 7.0005
R1623 avss.n681 avss.n680 7.0005
R1624 avss.n682 avss.n681 7.0005
R1625 avss.n682 avss.n673 7.0005
R1626 avss.n686 avss.n673 7.0005
R1627 avss.n687 avss.n686 7.0005
R1628 avss.n688 avss.n687 7.0005
R1629 avss.n688 avss.n671 7.0005
R1630 avss.n692 avss.n671 7.0005
R1631 avss.n693 avss.n692 7.0005
R1632 avss.n694 avss.n693 7.0005
R1633 avss.n694 avss.n669 7.0005
R1634 avss.n698 avss.n669 7.0005
R1635 avss.n699 avss.n698 7.0005
R1636 avss.n700 avss.n699 7.0005
R1637 avss.n700 avss.n667 7.0005
R1638 avss.n704 avss.n667 7.0005
R1639 avss.n705 avss.n704 7.0005
R1640 avss.n706 avss.n705 7.0005
R1641 avss.n706 avss.n665 7.0005
R1642 avss.n710 avss.n665 7.0005
R1643 avss.n711 avss.n710 7.0005
R1644 avss.n712 avss.n711 7.0005
R1645 avss.n712 avss.n663 7.0005
R1646 avss.n716 avss.n663 7.0005
R1647 avss.n717 avss.n716 7.0005
R1648 avss.n718 avss.n717 7.0005
R1649 avss.n718 avss.n661 7.0005
R1650 avss.n722 avss.n661 7.0005
R1651 avss.n723 avss.n722 7.0005
R1652 avss.n724 avss.n723 7.0005
R1653 avss.n724 avss.n659 7.0005
R1654 avss.n728 avss.n659 7.0005
R1655 avss.n729 avss.n728 7.0005
R1656 avss.n730 avss.n729 7.0005
R1657 avss.n730 avss.n657 7.0005
R1658 avss.n734 avss.n657 7.0005
R1659 avss.n735 avss.n734 7.0005
R1660 avss.n736 avss.n735 7.0005
R1661 avss.n736 avss.n655 7.0005
R1662 avss.n740 avss.n655 7.0005
R1663 avss.n741 avss.n740 7.0005
R1664 avss.n742 avss.n741 7.0005
R1665 avss.n742 avss.n653 7.0005
R1666 avss.n746 avss.n653 7.0005
R1667 avss.n747 avss.n746 7.0005
R1668 avss.n748 avss.n747 7.0005
R1669 avss.n748 avss.n651 7.0005
R1670 avss.n752 avss.n651 7.0005
R1671 avss.n753 avss.n752 7.0005
R1672 avss.n754 avss.n753 7.0005
R1673 avss.n754 avss.n649 7.0005
R1674 avss.n758 avss.n649 7.0005
R1675 avss.n759 avss.n758 7.0005
R1676 avss.n760 avss.n759 7.0005
R1677 avss.n760 avss.n647 7.0005
R1678 avss.n764 avss.n647 7.0005
R1679 avss.n765 avss.n764 7.0005
R1680 avss.n766 avss.n765 7.0005
R1681 avss.n766 avss.n645 7.0005
R1682 avss.n770 avss.n645 7.0005
R1683 avss.n771 avss.n770 7.0005
R1684 avss.n772 avss.n771 7.0005
R1685 avss.n772 avss.n643 7.0005
R1686 avss.n776 avss.n643 7.0005
R1687 avss.n777 avss.n776 7.0005
R1688 avss.n778 avss.n777 7.0005
R1689 avss.n778 avss.n641 7.0005
R1690 avss.n782 avss.n641 7.0005
R1691 avss.n783 avss.n782 7.0005
R1692 avss.n784 avss.n783 7.0005
R1693 avss.n784 avss.n639 7.0005
R1694 avss.n788 avss.n639 7.0005
R1695 avss.n789 avss.n788 7.0005
R1696 avss.n790 avss.n789 7.0005
R1697 avss.n790 avss.n637 7.0005
R1698 avss.n794 avss.n637 7.0005
R1699 avss.n795 avss.n794 7.0005
R1700 avss.n796 avss.n795 7.0005
R1701 avss.n796 avss.n635 7.0005
R1702 avss.n800 avss.n635 7.0005
R1703 avss.n801 avss.n800 7.0005
R1704 avss.n802 avss.n801 7.0005
R1705 avss.n802 avss.n633 7.0005
R1706 avss.n806 avss.n633 7.0005
R1707 avss.n807 avss.n806 7.0005
R1708 avss.n808 avss.n807 7.0005
R1709 avss.n808 avss.n631 7.0005
R1710 avss.n812 avss.n631 7.0005
R1711 avss.n813 avss.n812 7.0005
R1712 avss.n814 avss.n813 7.0005
R1713 avss.n814 avss.n629 7.0005
R1714 avss.n818 avss.n629 7.0005
R1715 avss.n819 avss.n818 7.0005
R1716 avss.n820 avss.n819 7.0005
R1717 avss.n820 avss.n627 7.0005
R1718 avss.n824 avss.n627 7.0005
R1719 avss.n825 avss.n824 7.0005
R1720 avss.n826 avss.n825 7.0005
R1721 avss.n826 avss.n625 7.0005
R1722 avss.n830 avss.n625 7.0005
R1723 avss.n831 avss.n830 7.0005
R1724 avss.n832 avss.n831 7.0005
R1725 avss.n832 avss.n623 7.0005
R1726 avss.n836 avss.n623 7.0005
R1727 avss.n837 avss.n836 7.0005
R1728 avss.n838 avss.n837 7.0005
R1729 avss.n838 avss.n621 7.0005
R1730 avss.n842 avss.n621 7.0005
R1731 avss.n843 avss.n842 7.0005
R1732 avss.n844 avss.n843 7.0005
R1733 avss.n844 avss.n619 7.0005
R1734 avss.n848 avss.n619 7.0005
R1735 avss.n849 avss.n848 7.0005
R1736 avss.n850 avss.n849 7.0005
R1737 avss.n850 avss.n617 7.0005
R1738 avss.n854 avss.n617 7.0005
R1739 avss.n855 avss.n854 7.0005
R1740 avss.n856 avss.n855 7.0005
R1741 avss.n856 avss.n615 7.0005
R1742 avss.n860 avss.n615 7.0005
R1743 avss.n861 avss.n860 7.0005
R1744 avss.n862 avss.n861 7.0005
R1745 avss.n862 avss.n613 7.0005
R1746 avss.n866 avss.n613 7.0005
R1747 avss.n867 avss.n866 7.0005
R1748 avss.n868 avss.n867 7.0005
R1749 avss.n868 avss.n611 7.0005
R1750 avss.n872 avss.n611 7.0005
R1751 avss.n873 avss.n872 7.0005
R1752 avss.n874 avss.n873 7.0005
R1753 avss.n874 avss.n609 7.0005
R1754 avss.n878 avss.n609 7.0005
R1755 avss.n879 avss.n878 7.0005
R1756 avss.n880 avss.n879 7.0005
R1757 avss.n880 avss.n607 7.0005
R1758 avss.n884 avss.n607 7.0005
R1759 avss.n885 avss.n884 7.0005
R1760 avss.n886 avss.n885 7.0005
R1761 avss.n886 avss.n605 7.0005
R1762 avss.n890 avss.n605 7.0005
R1763 avss.n891 avss.n890 7.0005
R1764 avss.n892 avss.n891 7.0005
R1765 avss.n892 avss.n603 7.0005
R1766 avss.n896 avss.n603 7.0005
R1767 avss.n897 avss.n896 7.0005
R1768 avss.n898 avss.n897 7.0005
R1769 avss.n898 avss.n601 7.0005
R1770 avss.n902 avss.n601 7.0005
R1771 avss.n903 avss.n902 7.0005
R1772 avss.n904 avss.n903 7.0005
R1773 avss.n904 avss.n599 7.0005
R1774 avss.n908 avss.n599 7.0005
R1775 avss.n909 avss.n908 7.0005
R1776 avss.n910 avss.n909 7.0005
R1777 avss.n910 avss.n597 7.0005
R1778 avss.n914 avss.n597 7.0005
R1779 avss.n915 avss.n914 7.0005
R1780 avss.n916 avss.n915 7.0005
R1781 avss.n916 avss.n595 7.0005
R1782 avss.n920 avss.n595 7.0005
R1783 avss.n921 avss.n920 7.0005
R1784 avss.n922 avss.n921 7.0005
R1785 avss.n922 avss.n593 7.0005
R1786 avss.n926 avss.n593 7.0005
R1787 avss.n927 avss.n926 7.0005
R1788 avss.n928 avss.n927 7.0005
R1789 avss.n928 avss.n591 7.0005
R1790 avss.n932 avss.n591 7.0005
R1791 avss.n933 avss.n932 7.0005
R1792 avss.n934 avss.n933 7.0005
R1793 avss.n934 avss.n589 7.0005
R1794 avss.n938 avss.n589 7.0005
R1795 avss.n939 avss.n938 7.0005
R1796 avss.n940 avss.n939 7.0005
R1797 avss.n940 avss.n587 7.0005
R1798 avss.n944 avss.n587 7.0005
R1799 avss.n945 avss.n944 7.0005
R1800 avss.n946 avss.n945 7.0005
R1801 avss.n946 avss.n585 7.0005
R1802 avss.n950 avss.n585 7.0005
R1803 avss.n951 avss.n950 7.0005
R1804 avss.n952 avss.n951 7.0005
R1805 avss.n952 avss.n583 7.0005
R1806 avss.n956 avss.n583 7.0005
R1807 avss.n957 avss.n956 7.0005
R1808 avss.n958 avss.n957 7.0005
R1809 avss.n958 avss.n581 7.0005
R1810 avss.n962 avss.n581 7.0005
R1811 avss.n963 avss.n962 7.0005
R1812 avss.n964 avss.n963 7.0005
R1813 avss.n964 avss.n579 7.0005
R1814 avss.n968 avss.n579 7.0005
R1815 avss.n969 avss.n968 7.0005
R1816 avss.n970 avss.n969 7.0005
R1817 avss.n970 avss.n577 7.0005
R1818 avss.n974 avss.n577 7.0005
R1819 avss.n975 avss.n974 7.0005
R1820 avss.n976 avss.n975 7.0005
R1821 avss.n976 avss.n575 7.0005
R1822 avss.n980 avss.n575 7.0005
R1823 avss.n981 avss.n980 7.0005
R1824 avss.n982 avss.n981 7.0005
R1825 avss.n982 avss.n573 7.0005
R1826 avss.n986 avss.n573 7.0005
R1827 avss.n987 avss.n986 7.0005
R1828 avss.n988 avss.n987 7.0005
R1829 avss.n988 avss.n571 7.0005
R1830 avss.n992 avss.n571 7.0005
R1831 avss.n993 avss.n992 7.0005
R1832 avss.n994 avss.n993 7.0005
R1833 avss.n994 avss.n569 7.0005
R1834 avss.n998 avss.n569 7.0005
R1835 avss.n999 avss.n998 7.0005
R1836 avss.n1000 avss.n999 7.0005
R1837 avss.n1000 avss.n567 7.0005
R1838 avss.n1004 avss.n567 7.0005
R1839 avss.n1005 avss.n1004 7.0005
R1840 avss.n1006 avss.n1005 7.0005
R1841 avss.n1006 avss.n565 7.0005
R1842 avss.n1010 avss.n565 7.0005
R1843 avss.n1011 avss.n1010 7.0005
R1844 avss.n1012 avss.n1011 7.0005
R1845 avss.n1012 avss.n563 7.0005
R1846 avss.n1016 avss.n563 7.0005
R1847 avss.n1017 avss.n1016 7.0005
R1848 avss.n1018 avss.n1017 7.0005
R1849 avss.n1018 avss.n561 7.0005
R1850 avss.n1022 avss.n561 7.0005
R1851 avss.n1023 avss.n1022 7.0005
R1852 avss.n1024 avss.n1023 7.0005
R1853 avss.n1024 avss.n559 7.0005
R1854 avss.n1028 avss.n559 7.0005
R1855 avss.n1029 avss.n1028 7.0005
R1856 avss.n1030 avss.n1029 7.0005
R1857 avss.n1030 avss.n557 7.0005
R1858 avss.n1034 avss.n557 7.0005
R1859 avss.n1035 avss.n1034 7.0005
R1860 avss.n1036 avss.n1035 7.0005
R1861 avss.n1036 avss.n555 7.0005
R1862 avss.n1040 avss.n555 7.0005
R1863 avss.n1041 avss.n1040 7.0005
R1864 avss.n1042 avss.n1041 7.0005
R1865 avss.n1042 avss.n553 7.0005
R1866 avss.n1046 avss.n553 7.0005
R1867 avss.n1575 avss.n1574 7.0005
R1868 avss.n1576 avss.n1575 7.0005
R1869 avss.n1576 avss.n375 7.0005
R1870 avss.n1580 avss.n375 7.0005
R1871 avss.n1581 avss.n1580 7.0005
R1872 avss.n1582 avss.n1581 7.0005
R1873 avss.n1582 avss.n373 7.0005
R1874 avss.n1586 avss.n373 7.0005
R1875 avss.n1587 avss.n1586 7.0005
R1876 avss.n1588 avss.n1587 7.0005
R1877 avss.n1588 avss.n371 7.0005
R1878 avss.n1592 avss.n371 7.0005
R1879 avss.n1593 avss.n1592 7.0005
R1880 avss.n1594 avss.n1593 7.0005
R1881 avss.n1594 avss.n369 7.0005
R1882 avss.n1598 avss.n369 7.0005
R1883 avss.n1599 avss.n1598 7.0005
R1884 avss.n1600 avss.n1599 7.0005
R1885 avss.n1600 avss.n367 7.0005
R1886 avss.n1604 avss.n367 7.0005
R1887 avss.n1605 avss.n1604 7.0005
R1888 avss.n1606 avss.n1605 7.0005
R1889 avss.n1606 avss.n365 7.0005
R1890 avss.n1610 avss.n365 7.0005
R1891 avss.n1611 avss.n1610 7.0005
R1892 avss.n1612 avss.n1611 7.0005
R1893 avss.n1612 avss.n363 7.0005
R1894 avss.n1616 avss.n363 7.0005
R1895 avss.n1617 avss.n1616 7.0005
R1896 avss.n1618 avss.n1617 7.0005
R1897 avss.n1618 avss.n361 7.0005
R1898 avss.n1622 avss.n361 7.0005
R1899 avss.n1623 avss.n1622 7.0005
R1900 avss.n1624 avss.n1623 7.0005
R1901 avss.n1624 avss.n359 7.0005
R1902 avss.n1628 avss.n359 7.0005
R1903 avss.n1629 avss.n1628 7.0005
R1904 avss.n1630 avss.n1629 7.0005
R1905 avss.n1630 avss.n357 7.0005
R1906 avss.n1634 avss.n357 7.0005
R1907 avss.n1635 avss.n1634 7.0005
R1908 avss.n1636 avss.n1635 7.0005
R1909 avss.n1636 avss.n355 7.0005
R1910 avss.n1640 avss.n355 7.0005
R1911 avss.n1641 avss.n1640 7.0005
R1912 avss.n1642 avss.n1641 7.0005
R1913 avss.n1642 avss.n353 7.0005
R1914 avss.n1646 avss.n353 7.0005
R1915 avss.n1647 avss.n1646 7.0005
R1916 avss.n1648 avss.n1647 7.0005
R1917 avss.n1648 avss.n351 7.0005
R1918 avss.n1652 avss.n351 7.0005
R1919 avss.n1653 avss.n1652 7.0005
R1920 avss.n1654 avss.n1653 7.0005
R1921 avss.n1654 avss.n349 7.0005
R1922 avss.n1658 avss.n349 7.0005
R1923 avss.n1659 avss.n1658 7.0005
R1924 avss.n1660 avss.n1659 7.0005
R1925 avss.n1660 avss.n347 7.0005
R1926 avss.n1664 avss.n347 7.0005
R1927 avss.n1665 avss.n1664 7.0005
R1928 avss.n1666 avss.n1665 7.0005
R1929 avss.n1666 avss.n345 7.0005
R1930 avss.n1670 avss.n345 7.0005
R1931 avss.n1671 avss.n1670 7.0005
R1932 avss.n1672 avss.n1671 7.0005
R1933 avss.n1672 avss.n343 7.0005
R1934 avss.n1676 avss.n343 7.0005
R1935 avss.n1677 avss.n1676 7.0005
R1936 avss.n1678 avss.n1677 7.0005
R1937 avss.n1678 avss.n341 7.0005
R1938 avss.n1682 avss.n341 7.0005
R1939 avss.n1683 avss.n1682 7.0005
R1940 avss.n1684 avss.n1683 7.0005
R1941 avss.n1684 avss.n339 7.0005
R1942 avss.n1688 avss.n339 7.0005
R1943 avss.n1689 avss.n1688 7.0005
R1944 avss.n1690 avss.n1689 7.0005
R1945 avss.n1690 avss.n337 7.0005
R1946 avss.n1694 avss.n337 7.0005
R1947 avss.n1695 avss.n1694 7.0005
R1948 avss.n1696 avss.n1695 7.0005
R1949 avss.n1696 avss.n335 7.0005
R1950 avss.n1700 avss.n335 7.0005
R1951 avss.n1701 avss.n1700 7.0005
R1952 avss.n1702 avss.n1701 7.0005
R1953 avss.n1702 avss.n333 7.0005
R1954 avss.n1706 avss.n333 7.0005
R1955 avss.n1707 avss.n1706 7.0005
R1956 avss.n1708 avss.n1707 7.0005
R1957 avss.n1708 avss.n331 7.0005
R1958 avss.n1712 avss.n331 7.0005
R1959 avss.n1713 avss.n1712 7.0005
R1960 avss.n1714 avss.n1713 7.0005
R1961 avss.n1714 avss.n329 7.0005
R1962 avss.n1718 avss.n329 7.0005
R1963 avss.n1719 avss.n1718 7.0005
R1964 avss.n1720 avss.n1719 7.0005
R1965 avss.n1720 avss.n327 7.0005
R1966 avss.n1724 avss.n327 7.0005
R1967 avss.n1725 avss.n1724 7.0005
R1968 avss.n1726 avss.n1725 7.0005
R1969 avss.n1198 avss.n501 7.0005
R1970 avss.n1198 avss.n1197 7.0005
R1971 avss.n1197 avss.n1196 7.0005
R1972 avss.n1196 avss.n503 7.0005
R1973 avss.n1192 avss.n503 7.0005
R1974 avss.n1192 avss.n1191 7.0005
R1975 avss.n1191 avss.n1190 7.0005
R1976 avss.n1190 avss.n505 7.0005
R1977 avss.n1186 avss.n505 7.0005
R1978 avss.n1186 avss.n1185 7.0005
R1979 avss.n1185 avss.n1184 7.0005
R1980 avss.n1184 avss.n507 7.0005
R1981 avss.n1180 avss.n507 7.0005
R1982 avss.n1180 avss.n1179 7.0005
R1983 avss.n1179 avss.n1178 7.0005
R1984 avss.n1178 avss.n509 7.0005
R1985 avss.n1174 avss.n509 7.0005
R1986 avss.n1174 avss.n1173 7.0005
R1987 avss.n1173 avss.n1172 7.0005
R1988 avss.n1172 avss.n511 7.0005
R1989 avss.n1168 avss.n511 7.0005
R1990 avss.n1168 avss.n1167 7.0005
R1991 avss.n1167 avss.n1166 7.0005
R1992 avss.n1166 avss.n513 7.0005
R1993 avss.n1162 avss.n513 7.0005
R1994 avss.n1162 avss.n1161 7.0005
R1995 avss.n1161 avss.n1160 7.0005
R1996 avss.n1160 avss.n515 7.0005
R1997 avss.n1156 avss.n515 7.0005
R1998 avss.n1156 avss.n1155 7.0005
R1999 avss.n1155 avss.n1154 7.0005
R2000 avss.n1154 avss.n517 7.0005
R2001 avss.n1150 avss.n517 7.0005
R2002 avss.n1150 avss.n1149 7.0005
R2003 avss.n1149 avss.n1148 7.0005
R2004 avss.n1148 avss.n519 7.0005
R2005 avss.n1144 avss.n519 7.0005
R2006 avss.n1144 avss.n1143 7.0005
R2007 avss.n1143 avss.n1142 7.0005
R2008 avss.n1142 avss.n521 7.0005
R2009 avss.n1138 avss.n521 7.0005
R2010 avss.n1138 avss.n1137 7.0005
R2011 avss.n1137 avss.n1136 7.0005
R2012 avss.n1136 avss.n523 7.0005
R2013 avss.n1132 avss.n523 7.0005
R2014 avss.n1132 avss.n1131 7.0005
R2015 avss.n1131 avss.n1130 7.0005
R2016 avss.n1130 avss.n525 7.0005
R2017 avss.n1126 avss.n525 7.0005
R2018 avss.n1126 avss.n1125 7.0005
R2019 avss.n1125 avss.n1124 7.0005
R2020 avss.n1124 avss.n527 7.0005
R2021 avss.n1120 avss.n527 7.0005
R2022 avss.n1120 avss.n1119 7.0005
R2023 avss.n1119 avss.n1118 7.0005
R2024 avss.n1118 avss.n529 7.0005
R2025 avss.n1114 avss.n529 7.0005
R2026 avss.n1114 avss.n1113 7.0005
R2027 avss.n1113 avss.n1112 7.0005
R2028 avss.n1112 avss.n531 7.0005
R2029 avss.n1108 avss.n531 7.0005
R2030 avss.n1108 avss.n1107 7.0005
R2031 avss.n1107 avss.n1106 7.0005
R2032 avss.n1106 avss.n533 7.0005
R2033 avss.n1102 avss.n533 7.0005
R2034 avss.n1102 avss.n1101 7.0005
R2035 avss.n1101 avss.n1100 7.0005
R2036 avss.n1100 avss.n535 7.0005
R2037 avss.n1096 avss.n535 7.0005
R2038 avss.n1096 avss.n1095 7.0005
R2039 avss.n1095 avss.n1094 7.0005
R2040 avss.n1094 avss.n537 7.0005
R2041 avss.n1090 avss.n537 7.0005
R2042 avss.n1090 avss.n1089 7.0005
R2043 avss.n1089 avss.n1088 7.0005
R2044 avss.n1088 avss.n539 7.0005
R2045 avss.n1084 avss.n539 7.0005
R2046 avss.n1084 avss.n1083 7.0005
R2047 avss.n1083 avss.n1082 7.0005
R2048 avss.n1082 avss.n541 7.0005
R2049 avss.n1078 avss.n541 7.0005
R2050 avss.n1078 avss.n1077 7.0005
R2051 avss.n1077 avss.n1076 7.0005
R2052 avss.n1076 avss.n543 7.0005
R2053 avss.n1072 avss.n543 7.0005
R2054 avss.n1072 avss.n1071 7.0005
R2055 avss.n1071 avss.n1070 7.0005
R2056 avss.n1070 avss.n545 7.0005
R2057 avss.n1066 avss.n545 7.0005
R2058 avss.n1066 avss.n1065 7.0005
R2059 avss.n1065 avss.n1064 7.0005
R2060 avss.n1064 avss.n547 7.0005
R2061 avss.n1060 avss.n547 7.0005
R2062 avss.n1060 avss.n1059 7.0005
R2063 avss.n1059 avss.n1058 7.0005
R2064 avss.n1058 avss.n549 7.0005
R2065 avss.n1054 avss.n549 7.0005
R2066 avss.n1054 avss.n1053 7.0005
R2067 avss.n1053 avss.n1052 7.0005
R2068 avss.n1052 avss.n551 7.0005
R2069 avss.n1048 avss.n551 7.0005
R2070 avss.n1048 avss.n1047 7.0005
R2071 avss.n1570 avss.n377 7.0005
R2072 avss.n1570 avss.n1569 7.0005
R2073 avss.n1569 avss.n1568 7.0005
R2074 avss.n1568 avss.n379 7.0005
R2075 avss.n1564 avss.n379 7.0005
R2076 avss.n1564 avss.n1563 7.0005
R2077 avss.n1563 avss.n1562 7.0005
R2078 avss.n1562 avss.n381 7.0005
R2079 avss.n1558 avss.n381 7.0005
R2080 avss.n1558 avss.n1557 7.0005
R2081 avss.n1557 avss.n1556 7.0005
R2082 avss.n1556 avss.n383 7.0005
R2083 avss.n1552 avss.n383 7.0005
R2084 avss.n1552 avss.n1551 7.0005
R2085 avss.n1551 avss.n1550 7.0005
R2086 avss.n1550 avss.n385 7.0005
R2087 avss.n1546 avss.n385 7.0005
R2088 avss.n1546 avss.n1545 7.0005
R2089 avss.n1545 avss.n1544 7.0005
R2090 avss.n1544 avss.n387 7.0005
R2091 avss.n1540 avss.n387 7.0005
R2092 avss.n1540 avss.n1539 7.0005
R2093 avss.n1539 avss.n1538 7.0005
R2094 avss.n1538 avss.n389 7.0005
R2095 avss.n1534 avss.n389 7.0005
R2096 avss.n1534 avss.n1533 7.0005
R2097 avss.n1533 avss.n1532 7.0005
R2098 avss.n1532 avss.n391 7.0005
R2099 avss.n1528 avss.n391 7.0005
R2100 avss.n1528 avss.n1527 7.0005
R2101 avss.n1527 avss.n1526 7.0005
R2102 avss.n1526 avss.n393 7.0005
R2103 avss.n1522 avss.n393 7.0005
R2104 avss.n1522 avss.n1521 7.0005
R2105 avss.n1521 avss.n1520 7.0005
R2106 avss.n1520 avss.n395 7.0005
R2107 avss.n1516 avss.n395 7.0005
R2108 avss.n1516 avss.n1515 7.0005
R2109 avss.n1515 avss.n1514 7.0005
R2110 avss.n1514 avss.n397 7.0005
R2111 avss.n1510 avss.n397 7.0005
R2112 avss.n1510 avss.n1509 7.0005
R2113 avss.n1509 avss.n1508 7.0005
R2114 avss.n1508 avss.n399 7.0005
R2115 avss.n1504 avss.n399 7.0005
R2116 avss.n1504 avss.n1503 7.0005
R2117 avss.n1503 avss.n1502 7.0005
R2118 avss.n1502 avss.n401 7.0005
R2119 avss.n1498 avss.n401 7.0005
R2120 avss.n1498 avss.n1497 7.0005
R2121 avss.n1497 avss.n1496 7.0005
R2122 avss.n1496 avss.n403 7.0005
R2123 avss.n1492 avss.n403 7.0005
R2124 avss.n1492 avss.n1491 7.0005
R2125 avss.n1491 avss.n1490 7.0005
R2126 avss.n1490 avss.n405 7.0005
R2127 avss.n1486 avss.n405 7.0005
R2128 avss.n1486 avss.n1485 7.0005
R2129 avss.n1485 avss.n1484 7.0005
R2130 avss.n1484 avss.n407 7.0005
R2131 avss.n1480 avss.n407 7.0005
R2132 avss.n1480 avss.n1479 7.0005
R2133 avss.n1479 avss.n1478 7.0005
R2134 avss.n1478 avss.n409 7.0005
R2135 avss.n1474 avss.n409 7.0005
R2136 avss.n1474 avss.n1473 7.0005
R2137 avss.n1473 avss.n1472 7.0005
R2138 avss.n1472 avss.n411 7.0005
R2139 avss.n1468 avss.n411 7.0005
R2140 avss.n1468 avss.n1467 7.0005
R2141 avss.n1467 avss.n1466 7.0005
R2142 avss.n1466 avss.n413 7.0005
R2143 avss.n1462 avss.n413 7.0005
R2144 avss.n1462 avss.n1461 7.0005
R2145 avss.n1461 avss.n1460 7.0005
R2146 avss.n1460 avss.n415 7.0005
R2147 avss.n1456 avss.n415 7.0005
R2148 avss.n1456 avss.n1455 7.0005
R2149 avss.n1455 avss.n1454 7.0005
R2150 avss.n1454 avss.n417 7.0005
R2151 avss.n1450 avss.n417 7.0005
R2152 avss.n1450 avss.n1449 7.0005
R2153 avss.n1449 avss.n1448 7.0005
R2154 avss.n1448 avss.n419 7.0005
R2155 avss.n1444 avss.n419 7.0005
R2156 avss.n1444 avss.n1443 7.0005
R2157 avss.n1443 avss.n1442 7.0005
R2158 avss.n1442 avss.n421 7.0005
R2159 avss.n1438 avss.n421 7.0005
R2160 avss.n1438 avss.n1437 7.0005
R2161 avss.n1437 avss.n1436 7.0005
R2162 avss.n1436 avss.n423 7.0005
R2163 avss.n1432 avss.n423 7.0005
R2164 avss.n1432 avss.n1431 7.0005
R2165 avss.n1431 avss.n1430 7.0005
R2166 avss.n1430 avss.n425 7.0005
R2167 avss.n1426 avss.n425 7.0005
R2168 avss.n1426 avss.n1425 7.0005
R2169 avss.n1425 avss.n1424 7.0005
R2170 avss.n1424 avss.n427 7.0005
R2171 avss.n1420 avss.n427 7.0005
R2172 avss.n1420 avss.n1419 7.0005
R2173 avss.n1419 avss.n1418 7.0005
R2174 avss.n1418 avss.n429 7.0005
R2175 avss.n1414 avss.n429 7.0005
R2176 avss.n1414 avss.n1413 7.0005
R2177 avss.n1413 avss.n1412 7.0005
R2178 avss.n1412 avss.n431 7.0005
R2179 avss.n1408 avss.n431 7.0005
R2180 avss.n1408 avss.n1407 7.0005
R2181 avss.n1407 avss.n1406 7.0005
R2182 avss.n1406 avss.n433 7.0005
R2183 avss.n1402 avss.n433 7.0005
R2184 avss.n1402 avss.n1401 7.0005
R2185 avss.n1401 avss.n1400 7.0005
R2186 avss.n1400 avss.n435 7.0005
R2187 avss.n1396 avss.n435 7.0005
R2188 avss.n1396 avss.n1395 7.0005
R2189 avss.n1395 avss.n1394 7.0005
R2190 avss.n1394 avss.n437 7.0005
R2191 avss.n1390 avss.n437 7.0005
R2192 avss.n1390 avss.n1389 7.0005
R2193 avss.n1389 avss.n1388 7.0005
R2194 avss.n1388 avss.n439 7.0005
R2195 avss.n1384 avss.n439 7.0005
R2196 avss.n1384 avss.n1383 7.0005
R2197 avss.n1383 avss.n1382 7.0005
R2198 avss.n1382 avss.n441 7.0005
R2199 avss.n1378 avss.n441 7.0005
R2200 avss.n1378 avss.n1377 7.0005
R2201 avss.n1377 avss.n1376 7.0005
R2202 avss.n1376 avss.n443 7.0005
R2203 avss.n1372 avss.n443 7.0005
R2204 avss.n1372 avss.n1371 7.0005
R2205 avss.n1371 avss.n1370 7.0005
R2206 avss.n1370 avss.n445 7.0005
R2207 avss.n1366 avss.n445 7.0005
R2208 avss.n1366 avss.n1365 7.0005
R2209 avss.n1365 avss.n1364 7.0005
R2210 avss.n1364 avss.n447 7.0005
R2211 avss.n1360 avss.n447 7.0005
R2212 avss.n1360 avss.n1359 7.0005
R2213 avss.n1359 avss.n1358 7.0005
R2214 avss.n1358 avss.n449 7.0005
R2215 avss.n1354 avss.n449 7.0005
R2216 avss.n1354 avss.n1353 7.0005
R2217 avss.n1353 avss.n1352 7.0005
R2218 avss.n1352 avss.n451 7.0005
R2219 avss.n1348 avss.n451 7.0005
R2220 avss.n1348 avss.n1347 7.0005
R2221 avss.n1347 avss.n1346 7.0005
R2222 avss.n1346 avss.n453 7.0005
R2223 avss.n1342 avss.n453 7.0005
R2224 avss.n1342 avss.n1341 7.0005
R2225 avss.n1341 avss.n1340 7.0005
R2226 avss.n1340 avss.n455 7.0005
R2227 avss.n1336 avss.n455 7.0005
R2228 avss.n1336 avss.n1335 7.0005
R2229 avss.n1335 avss.n1334 7.0005
R2230 avss.n1334 avss.n457 7.0005
R2231 avss.n1330 avss.n457 7.0005
R2232 avss.n1330 avss.n1329 7.0005
R2233 avss.n1329 avss.n1328 7.0005
R2234 avss.n1328 avss.n459 7.0005
R2235 avss.n1324 avss.n459 7.0005
R2236 avss.n1324 avss.n1323 7.0005
R2237 avss.n1323 avss.n1322 7.0005
R2238 avss.n1322 avss.n461 7.0005
R2239 avss.n1318 avss.n461 7.0005
R2240 avss.n1318 avss.n1317 7.0005
R2241 avss.n1317 avss.n1316 7.0005
R2242 avss.n1316 avss.n463 7.0005
R2243 avss.n1312 avss.n463 7.0005
R2244 avss.n1312 avss.n1311 7.0005
R2245 avss.n1311 avss.n1310 7.0005
R2246 avss.n1310 avss.n465 7.0005
R2247 avss.n1306 avss.n465 7.0005
R2248 avss.n1306 avss.n1305 7.0005
R2249 avss.n1305 avss.n1304 7.0005
R2250 avss.n1304 avss.n467 7.0005
R2251 avss.n1300 avss.n467 7.0005
R2252 avss.n1300 avss.n1299 7.0005
R2253 avss.n1299 avss.n1298 7.0005
R2254 avss.n1298 avss.n469 7.0005
R2255 avss.n1294 avss.n469 7.0005
R2256 avss.n1294 avss.n1293 7.0005
R2257 avss.n1293 avss.n1292 7.0005
R2258 avss.n1292 avss.n471 7.0005
R2259 avss.n1288 avss.n471 7.0005
R2260 avss.n1288 avss.n1287 7.0005
R2261 avss.n1287 avss.n1286 7.0005
R2262 avss.n1286 avss.n473 7.0005
R2263 avss.n1282 avss.n473 7.0005
R2264 avss.n1282 avss.n1281 7.0005
R2265 avss.n1281 avss.n1280 7.0005
R2266 avss.n1280 avss.n475 7.0005
R2267 avss.n1276 avss.n475 7.0005
R2268 avss.n1276 avss.n1275 7.0005
R2269 avss.n1275 avss.n1274 7.0005
R2270 avss.n1274 avss.n477 7.0005
R2271 avss.n1270 avss.n477 7.0005
R2272 avss.n1270 avss.n1269 7.0005
R2273 avss.n1269 avss.n1268 7.0005
R2274 avss.n1268 avss.n479 7.0005
R2275 avss.n1264 avss.n479 7.0005
R2276 avss.n1264 avss.n1263 7.0005
R2277 avss.n1263 avss.n1262 7.0005
R2278 avss.n1262 avss.n481 7.0005
R2279 avss.n1258 avss.n481 7.0005
R2280 avss.n1258 avss.n1257 7.0005
R2281 avss.n1257 avss.n1256 7.0005
R2282 avss.n1256 avss.n483 7.0005
R2283 avss.n1252 avss.n483 7.0005
R2284 avss.n1252 avss.n1251 7.0005
R2285 avss.n1251 avss.n1250 7.0005
R2286 avss.n1250 avss.n485 7.0005
R2287 avss.n1246 avss.n485 7.0005
R2288 avss.n1246 avss.n1245 7.0005
R2289 avss.n1245 avss.n1244 7.0005
R2290 avss.n1244 avss.n487 7.0005
R2291 avss.n1240 avss.n487 7.0005
R2292 avss.n1240 avss.n1239 7.0005
R2293 avss.n1239 avss.n1238 7.0005
R2294 avss.n1238 avss.n489 7.0005
R2295 avss.n1234 avss.n489 7.0005
R2296 avss.n1234 avss.n1233 7.0005
R2297 avss.n1233 avss.n1232 7.0005
R2298 avss.n1232 avss.n491 7.0005
R2299 avss.n1228 avss.n491 7.0005
R2300 avss.n1228 avss.n1227 7.0005
R2301 avss.n1227 avss.n1226 7.0005
R2302 avss.n1226 avss.n493 7.0005
R2303 avss.n1222 avss.n493 7.0005
R2304 avss.n1222 avss.n1221 7.0005
R2305 avss.n1221 avss.n1220 7.0005
R2306 avss.n1220 avss.n495 7.0005
R2307 avss.n1216 avss.n495 7.0005
R2308 avss.n1216 avss.n1215 7.0005
R2309 avss.n1215 avss.n1214 7.0005
R2310 avss.n1214 avss.n497 7.0005
R2311 avss.n1210 avss.n497 7.0005
R2312 avss.n1210 avss.n1209 7.0005
R2313 avss.n1209 avss.n1208 7.0005
R2314 avss.n1208 avss.n499 7.0005
R2315 avss.n1204 avss.n499 7.0005
R2316 avss.n1204 avss.n1203 7.0005
R2317 avss.n1203 avss.n1202 7.0005
R2318 avss.n68 avss.n67 6.7505
R2319 avss.n308 avss.n307 6.7055
R2320 avss.n1822 avss.n1813 6.7055
R2321 avss.n1790 avss.n1771 6.571
R2322 avss.n82 avss.t37 6.49783
R2323 avss.n83 avss.t31 6.49783
R2324 avss.n84 avss.t28 6.49783
R2325 avss.n85 avss.t34 6.49783
R2326 avss.n61 avss.t49 6.49739
R2327 avss.n62 avss.t40 6.49739
R2328 avss.n63 avss.t124 6.49739
R2329 avss.n64 avss.t127 6.49739
R2330 avss.n65 avss.t130 6.49739
R2331 avss.n66 avss.t133 6.49739
R2332 avss.n305 avss.n304 6.3905
R2333 avss.n71 avss.n70 6.30208
R2334 avss.n119 avss.n61 5.91493
R2335 avss.n304 avss.n62 5.91493
R2336 avss.n303 avss.n63 5.91493
R2337 avss.n121 avss.n64 5.91493
R2338 avss.n296 avss.n65 5.91493
R2339 avss.n295 avss.n66 5.91493
R2340 avss.n1843 avss.n17 5.87242
R2341 avss.n1848 avss.n29 5.87242
R2342 avss.n1857 avss.n18 5.87092
R2343 avss.n1856 avss.n19 5.87092
R2344 avss.n99 avss.n20 5.87092
R2345 avss.n107 avss.n21 5.87092
R2346 avss.n106 avss.n22 5.87092
R2347 avss.n103 avss.n23 5.87092
R2348 avss.n1844 avss.n25 5.87092
R2349 avss.n1845 avss.n26 5.87092
R2350 avss.n1846 avss.n27 5.87092
R2351 avss.n1847 avss.n28 5.87092
R2352 avss.n1849 avss.n30 5.87092
R2353 avss.n290 avss.n31 5.85717
R2354 avss.n129 avss.n32 5.85717
R2355 avss.n268 avss.n33 5.85717
R2356 avss.n263 avss.n34 5.85717
R2357 avss.n126 avss.n35 5.85717
R2358 avss.n284 avss.n36 5.85717
R2359 avss.n130 avss.n37 5.85717
R2360 avss.n278 avss.n38 5.85717
R2361 avss.n277 avss.n39 5.85717
R2362 avss.n110 avss.n79 5.84065
R2363 avss.n70 avss.n81 5.84065
R2364 avss.n1202 avss.n501 5.83383
R2365 avss.n171 avss.n43 5.83375
R2366 avss.n210 avss.n44 5.83375
R2367 avss.n253 avss.n45 5.83375
R2368 avss.n254 avss.n46 5.83375
R2369 avss.n13 avss.n47 5.83375
R2370 avss.n209 avss.n48 5.83375
R2371 avss.n208 avss.n49 5.83375
R2372 avss.n144 avss.n50 5.83375
R2373 avss.n220 avss.n51 5.83375
R2374 avss.n222 avss.n52 5.83375
R2375 avss.n16 avss.n53 5.83375
R2376 avss.n165 avss.n54 5.83375
R2377 avss.n176 avss.n55 5.83375
R2378 avss.n177 avss.n56 5.83375
R2379 avss.n161 avss.n57 5.83375
R2380 avss.n184 avss.n58 5.83375
R2381 avss.n185 avss.n59 5.83375
R2382 avss.n115 avss.n60 5.83375
R2383 avss.n101 avss.n74 5.83165
R2384 avss.n102 avss.n75 5.83165
R2385 avss.n91 avss.n76 5.83165
R2386 avss.n15 avss.n77 5.83165
R2387 avss.n315 avss.n82 5.82266
R2388 avss.n311 avss.n83 5.82266
R2389 avss.n310 avss.n84 5.82266
R2390 avss.n116 avss.n85 5.82266
R2391 avss.n90 avss.n128 5.75585
R2392 avss.n172 avss.n171 5.70518
R2393 avss.n268 avss.n7 5.65171
R2394 avss.n223 avss.n222 5.56143
R2395 avss.n315 avss.n314 5.39275
R2396 avss.n273 avss.n129 5.39196
R2397 avss.n221 avss.n220 5.34335
R2398 avss.n1811 avss.n1802 5.28606
R2399 avss.n1727 avss.n1726 5.2005
R2400 avss.n1725 avss.n325 5.2005
R2401 avss.n1724 avss.n1723 5.2005
R2402 avss.n1722 avss.n327 5.2005
R2403 avss.n1721 avss.n1720 5.2005
R2404 avss.n1719 avss.n328 5.2005
R2405 avss.n1718 avss.n1717 5.2005
R2406 avss.n1716 avss.n329 5.2005
R2407 avss.n1715 avss.n1714 5.2005
R2408 avss.n1713 avss.n330 5.2005
R2409 avss.n1712 avss.n1711 5.2005
R2410 avss.n1710 avss.n331 5.2005
R2411 avss.n1709 avss.n1708 5.2005
R2412 avss.n1707 avss.n332 5.2005
R2413 avss.n1706 avss.n1705 5.2005
R2414 avss.n1704 avss.n333 5.2005
R2415 avss.n1703 avss.n1702 5.2005
R2416 avss.n1701 avss.n334 5.2005
R2417 avss.n1700 avss.n1699 5.2005
R2418 avss.n1698 avss.n335 5.2005
R2419 avss.n1697 avss.n1696 5.2005
R2420 avss.n1695 avss.n336 5.2005
R2421 avss.n1694 avss.n1693 5.2005
R2422 avss.n1692 avss.n337 5.2005
R2423 avss.n1691 avss.n1690 5.2005
R2424 avss.n1689 avss.n338 5.2005
R2425 avss.n1688 avss.n1687 5.2005
R2426 avss.n1686 avss.n339 5.2005
R2427 avss.n1685 avss.n1684 5.2005
R2428 avss.n1683 avss.n340 5.2005
R2429 avss.n1682 avss.n1681 5.2005
R2430 avss.n1680 avss.n341 5.2005
R2431 avss.n1679 avss.n1678 5.2005
R2432 avss.n1677 avss.n342 5.2005
R2433 avss.n1676 avss.n1675 5.2005
R2434 avss.n1674 avss.n343 5.2005
R2435 avss.n1673 avss.n1672 5.2005
R2436 avss.n1671 avss.n344 5.2005
R2437 avss.n1670 avss.n1669 5.2005
R2438 avss.n1668 avss.n345 5.2005
R2439 avss.n1667 avss.n1666 5.2005
R2440 avss.n1665 avss.n346 5.2005
R2441 avss.n1664 avss.n1663 5.2005
R2442 avss.n1662 avss.n347 5.2005
R2443 avss.n1661 avss.n1660 5.2005
R2444 avss.n1659 avss.n348 5.2005
R2445 avss.n1658 avss.n1657 5.2005
R2446 avss.n1656 avss.n349 5.2005
R2447 avss.n1655 avss.n1654 5.2005
R2448 avss.n1653 avss.n350 5.2005
R2449 avss.n1652 avss.n1651 5.2005
R2450 avss.n1650 avss.n351 5.2005
R2451 avss.n1649 avss.n1648 5.2005
R2452 avss.n1647 avss.n352 5.2005
R2453 avss.n1646 avss.n1645 5.2005
R2454 avss.n1644 avss.n353 5.2005
R2455 avss.n1643 avss.n1642 5.2005
R2456 avss.n1641 avss.n354 5.2005
R2457 avss.n1640 avss.n1639 5.2005
R2458 avss.n1638 avss.n355 5.2005
R2459 avss.n1637 avss.n1636 5.2005
R2460 avss.n1635 avss.n356 5.2005
R2461 avss.n1634 avss.n1633 5.2005
R2462 avss.n1632 avss.n357 5.2005
R2463 avss.n1631 avss.n1630 5.2005
R2464 avss.n1629 avss.n358 5.2005
R2465 avss.n1628 avss.n1627 5.2005
R2466 avss.n1626 avss.n359 5.2005
R2467 avss.n1625 avss.n1624 5.2005
R2468 avss.n1623 avss.n360 5.2005
R2469 avss.n1622 avss.n1621 5.2005
R2470 avss.n1620 avss.n361 5.2005
R2471 avss.n1619 avss.n1618 5.2005
R2472 avss.n1617 avss.n362 5.2005
R2473 avss.n1616 avss.n1615 5.2005
R2474 avss.n1614 avss.n363 5.2005
R2475 avss.n1613 avss.n1612 5.2005
R2476 avss.n1611 avss.n364 5.2005
R2477 avss.n1610 avss.n1609 5.2005
R2478 avss.n1608 avss.n365 5.2005
R2479 avss.n1607 avss.n1606 5.2005
R2480 avss.n1605 avss.n366 5.2005
R2481 avss.n1604 avss.n1603 5.2005
R2482 avss.n1602 avss.n367 5.2005
R2483 avss.n1601 avss.n1600 5.2005
R2484 avss.n1599 avss.n368 5.2005
R2485 avss.n1598 avss.n1597 5.2005
R2486 avss.n1596 avss.n369 5.2005
R2487 avss.n1595 avss.n1594 5.2005
R2488 avss.n1593 avss.n370 5.2005
R2489 avss.n1592 avss.n1591 5.2005
R2490 avss.n1590 avss.n371 5.2005
R2491 avss.n1589 avss.n1588 5.2005
R2492 avss.n1587 avss.n372 5.2005
R2493 avss.n1586 avss.n1585 5.2005
R2494 avss.n1584 avss.n373 5.2005
R2495 avss.n1583 avss.n1582 5.2005
R2496 avss.n1581 avss.n374 5.2005
R2497 avss.n1580 avss.n1579 5.2005
R2498 avss.n1578 avss.n375 5.2005
R2499 avss.n1577 avss.n1576 5.2005
R2500 avss.n1575 avss.n376 5.2005
R2501 avss.n1574 avss.n1573 5.2005
R2502 avss.n1202 avss.n1201 5.2005
R2503 avss.n1203 avss.n500 5.2005
R2504 avss.n1205 avss.n1204 5.2005
R2505 avss.n1206 avss.n499 5.2005
R2506 avss.n1208 avss.n1207 5.2005
R2507 avss.n1209 avss.n498 5.2005
R2508 avss.n1211 avss.n1210 5.2005
R2509 avss.n1212 avss.n497 5.2005
R2510 avss.n1214 avss.n1213 5.2005
R2511 avss.n1215 avss.n496 5.2005
R2512 avss.n1217 avss.n1216 5.2005
R2513 avss.n1218 avss.n495 5.2005
R2514 avss.n1220 avss.n1219 5.2005
R2515 avss.n1221 avss.n494 5.2005
R2516 avss.n1223 avss.n1222 5.2005
R2517 avss.n1224 avss.n493 5.2005
R2518 avss.n1226 avss.n1225 5.2005
R2519 avss.n1227 avss.n492 5.2005
R2520 avss.n1229 avss.n1228 5.2005
R2521 avss.n1230 avss.n491 5.2005
R2522 avss.n1232 avss.n1231 5.2005
R2523 avss.n1233 avss.n490 5.2005
R2524 avss.n1235 avss.n1234 5.2005
R2525 avss.n1236 avss.n489 5.2005
R2526 avss.n1238 avss.n1237 5.2005
R2527 avss.n1239 avss.n488 5.2005
R2528 avss.n1241 avss.n1240 5.2005
R2529 avss.n1242 avss.n487 5.2005
R2530 avss.n1244 avss.n1243 5.2005
R2531 avss.n1245 avss.n486 5.2005
R2532 avss.n1247 avss.n1246 5.2005
R2533 avss.n1248 avss.n485 5.2005
R2534 avss.n1250 avss.n1249 5.2005
R2535 avss.n1251 avss.n484 5.2005
R2536 avss.n1253 avss.n1252 5.2005
R2537 avss.n1254 avss.n483 5.2005
R2538 avss.n1256 avss.n1255 5.2005
R2539 avss.n1257 avss.n482 5.2005
R2540 avss.n1259 avss.n1258 5.2005
R2541 avss.n1260 avss.n481 5.2005
R2542 avss.n1262 avss.n1261 5.2005
R2543 avss.n1263 avss.n480 5.2005
R2544 avss.n1265 avss.n1264 5.2005
R2545 avss.n1266 avss.n479 5.2005
R2546 avss.n1268 avss.n1267 5.2005
R2547 avss.n1269 avss.n478 5.2005
R2548 avss.n1271 avss.n1270 5.2005
R2549 avss.n1272 avss.n477 5.2005
R2550 avss.n1274 avss.n1273 5.2005
R2551 avss.n1275 avss.n476 5.2005
R2552 avss.n1277 avss.n1276 5.2005
R2553 avss.n1278 avss.n475 5.2005
R2554 avss.n1280 avss.n1279 5.2005
R2555 avss.n1281 avss.n474 5.2005
R2556 avss.n1283 avss.n1282 5.2005
R2557 avss.n1284 avss.n473 5.2005
R2558 avss.n1286 avss.n1285 5.2005
R2559 avss.n1287 avss.n472 5.2005
R2560 avss.n1289 avss.n1288 5.2005
R2561 avss.n1290 avss.n471 5.2005
R2562 avss.n1292 avss.n1291 5.2005
R2563 avss.n1293 avss.n470 5.2005
R2564 avss.n1295 avss.n1294 5.2005
R2565 avss.n1296 avss.n469 5.2005
R2566 avss.n1298 avss.n1297 5.2005
R2567 avss.n1299 avss.n468 5.2005
R2568 avss.n1301 avss.n1300 5.2005
R2569 avss.n1302 avss.n467 5.2005
R2570 avss.n1304 avss.n1303 5.2005
R2571 avss.n1305 avss.n466 5.2005
R2572 avss.n1307 avss.n1306 5.2005
R2573 avss.n1308 avss.n465 5.2005
R2574 avss.n1310 avss.n1309 5.2005
R2575 avss.n1311 avss.n464 5.2005
R2576 avss.n1313 avss.n1312 5.2005
R2577 avss.n1314 avss.n463 5.2005
R2578 avss.n1316 avss.n1315 5.2005
R2579 avss.n1317 avss.n462 5.2005
R2580 avss.n1319 avss.n1318 5.2005
R2581 avss.n1320 avss.n461 5.2005
R2582 avss.n1322 avss.n1321 5.2005
R2583 avss.n1323 avss.n460 5.2005
R2584 avss.n1325 avss.n1324 5.2005
R2585 avss.n1326 avss.n459 5.2005
R2586 avss.n1328 avss.n1327 5.2005
R2587 avss.n1329 avss.n458 5.2005
R2588 avss.n1331 avss.n1330 5.2005
R2589 avss.n1332 avss.n457 5.2005
R2590 avss.n1334 avss.n1333 5.2005
R2591 avss.n1335 avss.n456 5.2005
R2592 avss.n1337 avss.n1336 5.2005
R2593 avss.n1338 avss.n455 5.2005
R2594 avss.n1340 avss.n1339 5.2005
R2595 avss.n1341 avss.n454 5.2005
R2596 avss.n1343 avss.n1342 5.2005
R2597 avss.n1344 avss.n453 5.2005
R2598 avss.n1346 avss.n1345 5.2005
R2599 avss.n1347 avss.n452 5.2005
R2600 avss.n1349 avss.n1348 5.2005
R2601 avss.n1350 avss.n451 5.2005
R2602 avss.n1352 avss.n1351 5.2005
R2603 avss.n1353 avss.n450 5.2005
R2604 avss.n1355 avss.n1354 5.2005
R2605 avss.n1356 avss.n449 5.2005
R2606 avss.n1358 avss.n1357 5.2005
R2607 avss.n1359 avss.n448 5.2005
R2608 avss.n1361 avss.n1360 5.2005
R2609 avss.n1362 avss.n447 5.2005
R2610 avss.n1364 avss.n1363 5.2005
R2611 avss.n1365 avss.n446 5.2005
R2612 avss.n1367 avss.n1366 5.2005
R2613 avss.n1368 avss.n445 5.2005
R2614 avss.n1370 avss.n1369 5.2005
R2615 avss.n1371 avss.n444 5.2005
R2616 avss.n1373 avss.n1372 5.2005
R2617 avss.n1374 avss.n443 5.2005
R2618 avss.n1376 avss.n1375 5.2005
R2619 avss.n1377 avss.n442 5.2005
R2620 avss.n1379 avss.n1378 5.2005
R2621 avss.n1380 avss.n441 5.2005
R2622 avss.n1382 avss.n1381 5.2005
R2623 avss.n1383 avss.n440 5.2005
R2624 avss.n1385 avss.n1384 5.2005
R2625 avss.n1386 avss.n439 5.2005
R2626 avss.n1388 avss.n1387 5.2005
R2627 avss.n1389 avss.n438 5.2005
R2628 avss.n1391 avss.n1390 5.2005
R2629 avss.n1392 avss.n437 5.2005
R2630 avss.n1394 avss.n1393 5.2005
R2631 avss.n1395 avss.n436 5.2005
R2632 avss.n1397 avss.n1396 5.2005
R2633 avss.n1398 avss.n435 5.2005
R2634 avss.n1400 avss.n1399 5.2005
R2635 avss.n1401 avss.n434 5.2005
R2636 avss.n1403 avss.n1402 5.2005
R2637 avss.n1404 avss.n433 5.2005
R2638 avss.n1406 avss.n1405 5.2005
R2639 avss.n1407 avss.n432 5.2005
R2640 avss.n1409 avss.n1408 5.2005
R2641 avss.n1410 avss.n431 5.2005
R2642 avss.n1412 avss.n1411 5.2005
R2643 avss.n1413 avss.n430 5.2005
R2644 avss.n1415 avss.n1414 5.2005
R2645 avss.n1416 avss.n429 5.2005
R2646 avss.n1418 avss.n1417 5.2005
R2647 avss.n1419 avss.n428 5.2005
R2648 avss.n1421 avss.n1420 5.2005
R2649 avss.n1422 avss.n427 5.2005
R2650 avss.n1424 avss.n1423 5.2005
R2651 avss.n1425 avss.n426 5.2005
R2652 avss.n1427 avss.n1426 5.2005
R2653 avss.n1428 avss.n425 5.2005
R2654 avss.n1430 avss.n1429 5.2005
R2655 avss.n1431 avss.n424 5.2005
R2656 avss.n1433 avss.n1432 5.2005
R2657 avss.n1434 avss.n423 5.2005
R2658 avss.n1436 avss.n1435 5.2005
R2659 avss.n1437 avss.n422 5.2005
R2660 avss.n1439 avss.n1438 5.2005
R2661 avss.n1440 avss.n421 5.2005
R2662 avss.n1442 avss.n1441 5.2005
R2663 avss.n1443 avss.n420 5.2005
R2664 avss.n1445 avss.n1444 5.2005
R2665 avss.n1446 avss.n419 5.2005
R2666 avss.n1448 avss.n1447 5.2005
R2667 avss.n1449 avss.n418 5.2005
R2668 avss.n1451 avss.n1450 5.2005
R2669 avss.n1452 avss.n417 5.2005
R2670 avss.n1454 avss.n1453 5.2005
R2671 avss.n1455 avss.n416 5.2005
R2672 avss.n1457 avss.n1456 5.2005
R2673 avss.n1458 avss.n415 5.2005
R2674 avss.n1460 avss.n1459 5.2005
R2675 avss.n1461 avss.n414 5.2005
R2676 avss.n1463 avss.n1462 5.2005
R2677 avss.n1464 avss.n413 5.2005
R2678 avss.n1466 avss.n1465 5.2005
R2679 avss.n1467 avss.n412 5.2005
R2680 avss.n1469 avss.n1468 5.2005
R2681 avss.n1470 avss.n411 5.2005
R2682 avss.n1472 avss.n1471 5.2005
R2683 avss.n1473 avss.n410 5.2005
R2684 avss.n1475 avss.n1474 5.2005
R2685 avss.n1476 avss.n409 5.2005
R2686 avss.n1478 avss.n1477 5.2005
R2687 avss.n1479 avss.n408 5.2005
R2688 avss.n1481 avss.n1480 5.2005
R2689 avss.n1482 avss.n407 5.2005
R2690 avss.n1484 avss.n1483 5.2005
R2691 avss.n1485 avss.n406 5.2005
R2692 avss.n1487 avss.n1486 5.2005
R2693 avss.n1488 avss.n405 5.2005
R2694 avss.n1490 avss.n1489 5.2005
R2695 avss.n1491 avss.n404 5.2005
R2696 avss.n1493 avss.n1492 5.2005
R2697 avss.n1494 avss.n403 5.2005
R2698 avss.n1496 avss.n1495 5.2005
R2699 avss.n1497 avss.n402 5.2005
R2700 avss.n1499 avss.n1498 5.2005
R2701 avss.n1500 avss.n401 5.2005
R2702 avss.n1502 avss.n1501 5.2005
R2703 avss.n1503 avss.n400 5.2005
R2704 avss.n1505 avss.n1504 5.2005
R2705 avss.n1506 avss.n399 5.2005
R2706 avss.n1508 avss.n1507 5.2005
R2707 avss.n1509 avss.n398 5.2005
R2708 avss.n1511 avss.n1510 5.2005
R2709 avss.n1512 avss.n397 5.2005
R2710 avss.n1514 avss.n1513 5.2005
R2711 avss.n1515 avss.n396 5.2005
R2712 avss.n1517 avss.n1516 5.2005
R2713 avss.n1518 avss.n395 5.2005
R2714 avss.n1520 avss.n1519 5.2005
R2715 avss.n1521 avss.n394 5.2005
R2716 avss.n1523 avss.n1522 5.2005
R2717 avss.n1524 avss.n393 5.2005
R2718 avss.n1526 avss.n1525 5.2005
R2719 avss.n1527 avss.n392 5.2005
R2720 avss.n1529 avss.n1528 5.2005
R2721 avss.n1530 avss.n391 5.2005
R2722 avss.n1532 avss.n1531 5.2005
R2723 avss.n1533 avss.n390 5.2005
R2724 avss.n1535 avss.n1534 5.2005
R2725 avss.n1536 avss.n389 5.2005
R2726 avss.n1538 avss.n1537 5.2005
R2727 avss.n1539 avss.n388 5.2005
R2728 avss.n1541 avss.n1540 5.2005
R2729 avss.n1542 avss.n387 5.2005
R2730 avss.n1544 avss.n1543 5.2005
R2731 avss.n1545 avss.n386 5.2005
R2732 avss.n1547 avss.n1546 5.2005
R2733 avss.n1548 avss.n385 5.2005
R2734 avss.n1550 avss.n1549 5.2005
R2735 avss.n1551 avss.n384 5.2005
R2736 avss.n1553 avss.n1552 5.2005
R2737 avss.n1554 avss.n383 5.2005
R2738 avss.n1556 avss.n1555 5.2005
R2739 avss.n1557 avss.n382 5.2005
R2740 avss.n1559 avss.n1558 5.2005
R2741 avss.n1560 avss.n381 5.2005
R2742 avss.n1562 avss.n1561 5.2005
R2743 avss.n1563 avss.n380 5.2005
R2744 avss.n1565 avss.n1564 5.2005
R2745 avss.n1566 avss.n379 5.2005
R2746 avss.n1568 avss.n1567 5.2005
R2747 avss.n1569 avss.n378 5.2005
R2748 avss.n1571 avss.n1570 5.2005
R2749 avss.n1572 avss.n377 5.2005
R2750 avss.n1200 avss.n501 5.2005
R2751 avss.n1199 avss.n1198 5.2005
R2752 avss.n1197 avss.n502 5.2005
R2753 avss.n1196 avss.n1195 5.2005
R2754 avss.n1194 avss.n503 5.2005
R2755 avss.n1193 avss.n1192 5.2005
R2756 avss.n1191 avss.n504 5.2005
R2757 avss.n1190 avss.n1189 5.2005
R2758 avss.n1188 avss.n505 5.2005
R2759 avss.n1187 avss.n1186 5.2005
R2760 avss.n1185 avss.n506 5.2005
R2761 avss.n1184 avss.n1183 5.2005
R2762 avss.n1182 avss.n507 5.2005
R2763 avss.n1181 avss.n1180 5.2005
R2764 avss.n1179 avss.n508 5.2005
R2765 avss.n1178 avss.n1177 5.2005
R2766 avss.n1176 avss.n509 5.2005
R2767 avss.n1175 avss.n1174 5.2005
R2768 avss.n1173 avss.n510 5.2005
R2769 avss.n1172 avss.n1171 5.2005
R2770 avss.n1170 avss.n511 5.2005
R2771 avss.n1169 avss.n1168 5.2005
R2772 avss.n1167 avss.n512 5.2005
R2773 avss.n1166 avss.n1165 5.2005
R2774 avss.n1164 avss.n513 5.2005
R2775 avss.n1163 avss.n1162 5.2005
R2776 avss.n1161 avss.n514 5.2005
R2777 avss.n1160 avss.n1159 5.2005
R2778 avss.n1158 avss.n515 5.2005
R2779 avss.n1157 avss.n1156 5.2005
R2780 avss.n1155 avss.n516 5.2005
R2781 avss.n1154 avss.n1153 5.2005
R2782 avss.n1152 avss.n517 5.2005
R2783 avss.n1151 avss.n1150 5.2005
R2784 avss.n1149 avss.n518 5.2005
R2785 avss.n1148 avss.n1147 5.2005
R2786 avss.n1146 avss.n519 5.2005
R2787 avss.n1145 avss.n1144 5.2005
R2788 avss.n1143 avss.n520 5.2005
R2789 avss.n1142 avss.n1141 5.2005
R2790 avss.n1140 avss.n521 5.2005
R2791 avss.n1139 avss.n1138 5.2005
R2792 avss.n1137 avss.n522 5.2005
R2793 avss.n1136 avss.n1135 5.2005
R2794 avss.n1134 avss.n523 5.2005
R2795 avss.n1133 avss.n1132 5.2005
R2796 avss.n1131 avss.n524 5.2005
R2797 avss.n1130 avss.n1129 5.2005
R2798 avss.n1128 avss.n525 5.2005
R2799 avss.n1127 avss.n1126 5.2005
R2800 avss.n1125 avss.n526 5.2005
R2801 avss.n1124 avss.n1123 5.2005
R2802 avss.n1122 avss.n527 5.2005
R2803 avss.n1121 avss.n1120 5.2005
R2804 avss.n1119 avss.n528 5.2005
R2805 avss.n1118 avss.n1117 5.2005
R2806 avss.n1116 avss.n529 5.2005
R2807 avss.n1115 avss.n1114 5.2005
R2808 avss.n1113 avss.n530 5.2005
R2809 avss.n1112 avss.n1111 5.2005
R2810 avss.n1110 avss.n531 5.2005
R2811 avss.n1109 avss.n1108 5.2005
R2812 avss.n1107 avss.n532 5.2005
R2813 avss.n1106 avss.n1105 5.2005
R2814 avss.n1104 avss.n533 5.2005
R2815 avss.n1103 avss.n1102 5.2005
R2816 avss.n1101 avss.n534 5.2005
R2817 avss.n1100 avss.n1099 5.2005
R2818 avss.n1098 avss.n535 5.2005
R2819 avss.n1097 avss.n1096 5.2005
R2820 avss.n1095 avss.n536 5.2005
R2821 avss.n1094 avss.n1093 5.2005
R2822 avss.n1092 avss.n537 5.2005
R2823 avss.n1091 avss.n1090 5.2005
R2824 avss.n1089 avss.n538 5.2005
R2825 avss.n1088 avss.n1087 5.2005
R2826 avss.n1086 avss.n539 5.2005
R2827 avss.n1085 avss.n1084 5.2005
R2828 avss.n1083 avss.n540 5.2005
R2829 avss.n1082 avss.n1081 5.2005
R2830 avss.n1080 avss.n541 5.2005
R2831 avss.n1079 avss.n1078 5.2005
R2832 avss.n1077 avss.n542 5.2005
R2833 avss.n1076 avss.n1075 5.2005
R2834 avss.n1074 avss.n543 5.2005
R2835 avss.n1073 avss.n1072 5.2005
R2836 avss.n1071 avss.n544 5.2005
R2837 avss.n1070 avss.n1069 5.2005
R2838 avss.n1068 avss.n545 5.2005
R2839 avss.n1067 avss.n1066 5.2005
R2840 avss.n1065 avss.n546 5.2005
R2841 avss.n1064 avss.n1063 5.2005
R2842 avss.n1062 avss.n547 5.2005
R2843 avss.n1061 avss.n1060 5.2005
R2844 avss.n1059 avss.n548 5.2005
R2845 avss.n1058 avss.n1057 5.2005
R2846 avss.n1056 avss.n549 5.2005
R2847 avss.n1055 avss.n1054 5.2005
R2848 avss.n1053 avss.n550 5.2005
R2849 avss.n1052 avss.n1051 5.2005
R2850 avss.n1050 avss.n551 5.2005
R2851 avss.n1049 avss.n1048 5.2005
R2852 avss.n1047 avss.n552 5.2005
R2853 avss.n326 avss.n324 5.2005
R2854 avss.n677 avss.n676 5.2005
R2855 avss.n678 avss.n675 5.2005
R2856 avss.n680 avss.n679 5.2005
R2857 avss.n681 avss.n674 5.2005
R2858 avss.n683 avss.n682 5.2005
R2859 avss.n684 avss.n673 5.2005
R2860 avss.n686 avss.n685 5.2005
R2861 avss.n687 avss.n672 5.2005
R2862 avss.n689 avss.n688 5.2005
R2863 avss.n690 avss.n671 5.2005
R2864 avss.n692 avss.n691 5.2005
R2865 avss.n693 avss.n670 5.2005
R2866 avss.n695 avss.n694 5.2005
R2867 avss.n696 avss.n669 5.2005
R2868 avss.n698 avss.n697 5.2005
R2869 avss.n699 avss.n668 5.2005
R2870 avss.n701 avss.n700 5.2005
R2871 avss.n702 avss.n667 5.2005
R2872 avss.n704 avss.n703 5.2005
R2873 avss.n705 avss.n666 5.2005
R2874 avss.n707 avss.n706 5.2005
R2875 avss.n708 avss.n665 5.2005
R2876 avss.n710 avss.n709 5.2005
R2877 avss.n711 avss.n664 5.2005
R2878 avss.n713 avss.n712 5.2005
R2879 avss.n714 avss.n663 5.2005
R2880 avss.n716 avss.n715 5.2005
R2881 avss.n717 avss.n662 5.2005
R2882 avss.n719 avss.n718 5.2005
R2883 avss.n720 avss.n661 5.2005
R2884 avss.n722 avss.n721 5.2005
R2885 avss.n723 avss.n660 5.2005
R2886 avss.n725 avss.n724 5.2005
R2887 avss.n726 avss.n659 5.2005
R2888 avss.n728 avss.n727 5.2005
R2889 avss.n729 avss.n658 5.2005
R2890 avss.n731 avss.n730 5.2005
R2891 avss.n732 avss.n657 5.2005
R2892 avss.n734 avss.n733 5.2005
R2893 avss.n735 avss.n656 5.2005
R2894 avss.n737 avss.n736 5.2005
R2895 avss.n738 avss.n655 5.2005
R2896 avss.n740 avss.n739 5.2005
R2897 avss.n741 avss.n654 5.2005
R2898 avss.n743 avss.n742 5.2005
R2899 avss.n744 avss.n653 5.2005
R2900 avss.n746 avss.n745 5.2005
R2901 avss.n747 avss.n652 5.2005
R2902 avss.n749 avss.n748 5.2005
R2903 avss.n750 avss.n651 5.2005
R2904 avss.n752 avss.n751 5.2005
R2905 avss.n753 avss.n650 5.2005
R2906 avss.n755 avss.n754 5.2005
R2907 avss.n756 avss.n649 5.2005
R2908 avss.n758 avss.n757 5.2005
R2909 avss.n759 avss.n648 5.2005
R2910 avss.n761 avss.n760 5.2005
R2911 avss.n762 avss.n647 5.2005
R2912 avss.n764 avss.n763 5.2005
R2913 avss.n765 avss.n646 5.2005
R2914 avss.n767 avss.n766 5.2005
R2915 avss.n768 avss.n645 5.2005
R2916 avss.n770 avss.n769 5.2005
R2917 avss.n771 avss.n644 5.2005
R2918 avss.n773 avss.n772 5.2005
R2919 avss.n774 avss.n643 5.2005
R2920 avss.n776 avss.n775 5.2005
R2921 avss.n777 avss.n642 5.2005
R2922 avss.n779 avss.n778 5.2005
R2923 avss.n780 avss.n641 5.2005
R2924 avss.n782 avss.n781 5.2005
R2925 avss.n783 avss.n640 5.2005
R2926 avss.n785 avss.n784 5.2005
R2927 avss.n786 avss.n639 5.2005
R2928 avss.n788 avss.n787 5.2005
R2929 avss.n789 avss.n638 5.2005
R2930 avss.n791 avss.n790 5.2005
R2931 avss.n792 avss.n637 5.2005
R2932 avss.n794 avss.n793 5.2005
R2933 avss.n795 avss.n636 5.2005
R2934 avss.n797 avss.n796 5.2005
R2935 avss.n798 avss.n635 5.2005
R2936 avss.n800 avss.n799 5.2005
R2937 avss.n801 avss.n634 5.2005
R2938 avss.n803 avss.n802 5.2005
R2939 avss.n804 avss.n633 5.2005
R2940 avss.n806 avss.n805 5.2005
R2941 avss.n807 avss.n632 5.2005
R2942 avss.n809 avss.n808 5.2005
R2943 avss.n810 avss.n631 5.2005
R2944 avss.n812 avss.n811 5.2005
R2945 avss.n813 avss.n630 5.2005
R2946 avss.n815 avss.n814 5.2005
R2947 avss.n816 avss.n629 5.2005
R2948 avss.n818 avss.n817 5.2005
R2949 avss.n819 avss.n628 5.2005
R2950 avss.n821 avss.n820 5.2005
R2951 avss.n822 avss.n627 5.2005
R2952 avss.n824 avss.n823 5.2005
R2953 avss.n825 avss.n626 5.2005
R2954 avss.n827 avss.n826 5.2005
R2955 avss.n828 avss.n625 5.2005
R2956 avss.n830 avss.n829 5.2005
R2957 avss.n831 avss.n624 5.2005
R2958 avss.n833 avss.n832 5.2005
R2959 avss.n834 avss.n623 5.2005
R2960 avss.n836 avss.n835 5.2005
R2961 avss.n837 avss.n622 5.2005
R2962 avss.n839 avss.n838 5.2005
R2963 avss.n840 avss.n621 5.2005
R2964 avss.n842 avss.n841 5.2005
R2965 avss.n843 avss.n620 5.2005
R2966 avss.n845 avss.n844 5.2005
R2967 avss.n846 avss.n619 5.2005
R2968 avss.n848 avss.n847 5.2005
R2969 avss.n849 avss.n618 5.2005
R2970 avss.n851 avss.n850 5.2005
R2971 avss.n852 avss.n617 5.2005
R2972 avss.n854 avss.n853 5.2005
R2973 avss.n855 avss.n616 5.2005
R2974 avss.n857 avss.n856 5.2005
R2975 avss.n858 avss.n615 5.2005
R2976 avss.n860 avss.n859 5.2005
R2977 avss.n861 avss.n614 5.2005
R2978 avss.n863 avss.n862 5.2005
R2979 avss.n864 avss.n613 5.2005
R2980 avss.n866 avss.n865 5.2005
R2981 avss.n867 avss.n612 5.2005
R2982 avss.n869 avss.n868 5.2005
R2983 avss.n870 avss.n611 5.2005
R2984 avss.n872 avss.n871 5.2005
R2985 avss.n873 avss.n610 5.2005
R2986 avss.n875 avss.n874 5.2005
R2987 avss.n876 avss.n609 5.2005
R2988 avss.n878 avss.n877 5.2005
R2989 avss.n879 avss.n608 5.2005
R2990 avss.n881 avss.n880 5.2005
R2991 avss.n882 avss.n607 5.2005
R2992 avss.n884 avss.n883 5.2005
R2993 avss.n885 avss.n606 5.2005
R2994 avss.n887 avss.n886 5.2005
R2995 avss.n888 avss.n605 5.2005
R2996 avss.n890 avss.n889 5.2005
R2997 avss.n891 avss.n604 5.2005
R2998 avss.n893 avss.n892 5.2005
R2999 avss.n894 avss.n603 5.2005
R3000 avss.n896 avss.n895 5.2005
R3001 avss.n897 avss.n602 5.2005
R3002 avss.n899 avss.n898 5.2005
R3003 avss.n900 avss.n601 5.2005
R3004 avss.n902 avss.n901 5.2005
R3005 avss.n903 avss.n600 5.2005
R3006 avss.n905 avss.n904 5.2005
R3007 avss.n906 avss.n599 5.2005
R3008 avss.n908 avss.n907 5.2005
R3009 avss.n909 avss.n598 5.2005
R3010 avss.n911 avss.n910 5.2005
R3011 avss.n912 avss.n597 5.2005
R3012 avss.n914 avss.n913 5.2005
R3013 avss.n915 avss.n596 5.2005
R3014 avss.n917 avss.n916 5.2005
R3015 avss.n918 avss.n595 5.2005
R3016 avss.n920 avss.n919 5.2005
R3017 avss.n921 avss.n594 5.2005
R3018 avss.n923 avss.n922 5.2005
R3019 avss.n924 avss.n593 5.2005
R3020 avss.n926 avss.n925 5.2005
R3021 avss.n927 avss.n592 5.2005
R3022 avss.n929 avss.n928 5.2005
R3023 avss.n930 avss.n591 5.2005
R3024 avss.n932 avss.n931 5.2005
R3025 avss.n933 avss.n590 5.2005
R3026 avss.n935 avss.n934 5.2005
R3027 avss.n936 avss.n589 5.2005
R3028 avss.n938 avss.n937 5.2005
R3029 avss.n939 avss.n588 5.2005
R3030 avss.n941 avss.n940 5.2005
R3031 avss.n942 avss.n587 5.2005
R3032 avss.n944 avss.n943 5.2005
R3033 avss.n945 avss.n586 5.2005
R3034 avss.n947 avss.n946 5.2005
R3035 avss.n948 avss.n585 5.2005
R3036 avss.n950 avss.n949 5.2005
R3037 avss.n951 avss.n584 5.2005
R3038 avss.n953 avss.n952 5.2005
R3039 avss.n954 avss.n583 5.2005
R3040 avss.n956 avss.n955 5.2005
R3041 avss.n957 avss.n582 5.2005
R3042 avss.n959 avss.n958 5.2005
R3043 avss.n960 avss.n581 5.2005
R3044 avss.n962 avss.n961 5.2005
R3045 avss.n963 avss.n580 5.2005
R3046 avss.n965 avss.n964 5.2005
R3047 avss.n966 avss.n579 5.2005
R3048 avss.n968 avss.n967 5.2005
R3049 avss.n969 avss.n578 5.2005
R3050 avss.n971 avss.n970 5.2005
R3051 avss.n972 avss.n577 5.2005
R3052 avss.n974 avss.n973 5.2005
R3053 avss.n975 avss.n576 5.2005
R3054 avss.n977 avss.n976 5.2005
R3055 avss.n978 avss.n575 5.2005
R3056 avss.n980 avss.n979 5.2005
R3057 avss.n981 avss.n574 5.2005
R3058 avss.n983 avss.n982 5.2005
R3059 avss.n984 avss.n573 5.2005
R3060 avss.n986 avss.n985 5.2005
R3061 avss.n987 avss.n572 5.2005
R3062 avss.n989 avss.n988 5.2005
R3063 avss.n990 avss.n571 5.2005
R3064 avss.n992 avss.n991 5.2005
R3065 avss.n993 avss.n570 5.2005
R3066 avss.n995 avss.n994 5.2005
R3067 avss.n996 avss.n569 5.2005
R3068 avss.n998 avss.n997 5.2005
R3069 avss.n999 avss.n568 5.2005
R3070 avss.n1001 avss.n1000 5.2005
R3071 avss.n1002 avss.n567 5.2005
R3072 avss.n1004 avss.n1003 5.2005
R3073 avss.n1005 avss.n566 5.2005
R3074 avss.n1007 avss.n1006 5.2005
R3075 avss.n1008 avss.n565 5.2005
R3076 avss.n1010 avss.n1009 5.2005
R3077 avss.n1011 avss.n564 5.2005
R3078 avss.n1013 avss.n1012 5.2005
R3079 avss.n1014 avss.n563 5.2005
R3080 avss.n1016 avss.n1015 5.2005
R3081 avss.n1017 avss.n562 5.2005
R3082 avss.n1019 avss.n1018 5.2005
R3083 avss.n1020 avss.n561 5.2005
R3084 avss.n1022 avss.n1021 5.2005
R3085 avss.n1023 avss.n560 5.2005
R3086 avss.n1025 avss.n1024 5.2005
R3087 avss.n1026 avss.n559 5.2005
R3088 avss.n1028 avss.n1027 5.2005
R3089 avss.n1029 avss.n558 5.2005
R3090 avss.n1031 avss.n1030 5.2005
R3091 avss.n1032 avss.n557 5.2005
R3092 avss.n1034 avss.n1033 5.2005
R3093 avss.n1035 avss.n556 5.2005
R3094 avss.n1037 avss.n1036 5.2005
R3095 avss.n1038 avss.n555 5.2005
R3096 avss.n1040 avss.n1039 5.2005
R3097 avss.n1041 avss.n554 5.2005
R3098 avss.n1043 avss.n1042 5.2005
R3099 avss.n1044 avss.n553 5.2005
R3100 avss.n1046 avss.n1045 5.2005
R3101 avss.n159 avss.n115 5.13078
R3102 avss.n310 avss.n309 5.11737
R3103 avss.n241 avss.n14 5.11483
R3104 avss.n119 avss.n117 5.11482
R3105 avss.n304 avss.n120 5.0956
R3106 avss.n295 avss.n294 5.03118
R3107 avss.n16 avss.n241 5.0045
R3108 avss.n298 avss.n121 4.9974
R3109 avss.n105 avss.n99 4.99014
R3110 avss.n313 avss.n116 4.98533
R3111 avss.n297 avss.n296 4.96788
R3112 avss.n195 avss.n115 4.9595
R3113 avss.n257 avss.n13 4.95399
R3114 avss.n312 avss.n311 4.95182
R3115 avss.n233 avss.n195 4.92541
R3116 avss.n291 avss.n290 4.8215
R3117 avss.n288 avss.n90 4.78385
R3118 avss.n237 avss.n14 4.73059
R3119 avss.n41 avss.n199 4.73059
R3120 avss.n262 avss.n261 4.7174
R3121 avss.n94 avss.t222 4.72462
R3122 avss.n90 avss.n287 4.69782
R3123 avss.n1840 avss.n1839 4.6355
R3124 avss.n284 avss.n283 4.61459
R3125 avss.n1822 avss 4.5905
R3126 avss.n1865 avss.n67 4.5455
R3127 avss.n41 avss.n42 2.24544
R3128 avss.n0 avss.n16 2.24434
R3129 avss.n1858 avss.n1857 4.529
R3130 avss.n140 avss.n14 4.529
R3131 avss.n249 avss.n144 4.529
R3132 avss.n209 avss.n205 4.529
R3133 avss.n255 avss.n254 4.529
R3134 avss.n106 avss.n104 4.529
R3135 avss.n277 avss.n276 4.52493
R3136 avss.n279 avss.n278 4.52493
R3137 avss.n281 avss.n130 4.52493
R3138 avss.n6 avss.n1748 4.67984
R3139 avss.n253 avss.n252 4.52188
R3140 avss.n211 avss.n210 4.52188
R3141 avss.n208 avss.n207 4.52188
R3142 avss.n1856 avss.n1855 4.52188
R3143 avss.n265 avss.n126 4.51336
R3144 avss.n8 avss.n263 4.99169
R3145 avss.n94 avss.n93 2.2418
R3146 avss.n240 avss.n239 4.50421
R3147 avss.n197 avss.n196 4.50421
R3148 avss.n89 avss.n71 2.25521
R3149 avss.n1863 avss.n67 4.5005
R3150 avss avss.n1873 4.5005
R3151 avss avss.n1770 4.5005
R3152 avss avss.n1761 4.5005
R3153 avss.n186 avss.n185 4.5005
R3154 avss.n184 avss.n183 4.5005
R3155 avss.n181 avss.n161 4.5005
R3156 avss.n178 avss.n177 4.5005
R3157 avss.n176 avss.n175 4.5005
R3158 avss.n173 avss.n165 4.5005
R3159 avss.n303 avss.n302 4.5005
R3160 avss avss.n1747 4.5005
R3161 avss avss.n1800 4.5005
R3162 avss.n1811 avss 4.5005
R3163 avss.n1812 avss.n1811 4.5005
R3164 avss avss.n1737 4.5005
R3165 avss.n1823 avss.n1729 4.5005
R3166 avss avss.n1821 4.5005
R3167 avss avss.n1810 4.5005
R3168 avss avss.n1787 4.5005
R3169 avss avss.n1779 4.5005
R3170 avss.n270 avss.n269 4.4555
R3171 avss.n1834 avss.n1833 3.9155
R3172 avss.n1860 avss.n1859 3.7445
R3173 avss.n1574 avss.n377 3.5005
R3174 avss.n89 avss.n1837 3.4985
R3175 avss.n309 avss.n113 2.74784
R3176 avss.n228 avss.n227 2.7005
R3177 avss.n226 avss.n202 2.7005
R3178 avss.n219 avss.n150 2.7005
R3179 avss.n246 avss.n245 2.7005
R3180 avss.n306 avss.n305 2.7005
R3181 avss.n185 avss.n115 2.6105
R3182 avss.n185 avss.n184 2.6105
R3183 avss.n184 avss.n161 2.6105
R3184 avss.n177 avss.n161 2.6105
R3185 avss.n177 avss.n176 2.6105
R3186 avss.n176 avss.n165 2.6105
R3187 avss.n208 avss.n144 2.6105
R3188 avss.n209 avss.n208 2.6105
R3189 avss.n210 avss.n209 2.6105
R3190 avss.n254 avss.n13 2.6105
R3191 avss.n254 avss.n253 2.6105
R3192 avss.n253 avss.n144 2.6105
R3193 avss.n296 avss.n121 2.6105
R3194 avss.n315 avss.n116 2.6105
R3195 avss.n1824 avss.n86 2.60559
R3196 avss.n171 avss.n165 2.5835
R3197 avss.n296 avss.n295 2.582
R3198 avss.n303 avss.n121 2.582
R3199 avss.n311 avss.n310 2.5685
R3200 avss.n14 avss.n13 2.5655
R3201 avss.n1829 avss.n113 2.5365
R3202 avss.n1828 avss.n1827 2.5205
R3203 avss.n246 avss.n150 2.5205
R3204 avss.n1843 avss.n1842 2.4755
R3205 avss.n1832 avss.n1831 2.4305
R3206 avss.n1827 avss.n1826 2.4305
R3207 avss.n1788 avss.n68 2.3405
R3208 avss.n1812 avss.n1739 2.3405
R3209 avss.n285 avss.n127 2.31944
R3210 avss.n1751 avss.n1750 2.2855
R3211 avss.n1850 avss.n1849 2.28021
R3212 avss.n287 avss.n286 2.19639
R3213 avss.n278 avss.n277 2.1605
R3214 avss.n278 avss.n130 2.1605
R3215 avss.n284 avss.n130 2.1605
R3216 avss.n263 avss.n126 2.1605
R3217 avss.n268 avss.n263 2.1605
R3218 avss.n42 avss.n232 2.10467
R3219 avss.n1826 avss.n322 1.9355
R3220 avss.n320 avss.n113 1.9175
R3221 avss.n1830 avss.n1829 1.8695
R3222 avss.n102 avss.n101 1.8365
R3223 avss.n91 avss.n102 1.7105
R3224 avss.n106 avss.n103 1.7105
R3225 avss.n107 avss.n106 1.7105
R3226 avss.n107 avss.n99 1.7105
R3227 avss.n1856 avss.n99 1.7105
R3228 avss.n1857 avss.n1856 1.7105
R3229 avss.n311 avss.n308 1.7105
R3230 avss.n1846 avss.n1845 1.7105
R3231 avss.n1845 avss.n1844 1.7105
R3232 avss.n317 avss.n316 1.6655
R3233 avss.n1851 avss.n1850 1.58599
R3234 avss.n283 avss.n131 1.58493
R3235 avss.n1839 avss.n1838 1.5755
R3236 avss.n1873 avss.n1872 1.57121
R3237 avss.n1872 avss.n1868 1.57121
R3238 avss.n1873 avss.n1866 1.57121
R3239 avss.n1868 avss.n1866 1.57121
R3240 avss.n1770 avss.n1769 1.57121
R3241 avss.n1769 avss.n1765 1.57121
R3242 avss.n1770 avss.n1763 1.57121
R3243 avss.n1765 avss.n1763 1.57121
R3244 avss.n1761 avss.n1760 1.57121
R3245 avss.n1760 avss.n1756 1.57121
R3246 avss.n1761 avss.n1754 1.57121
R3247 avss.n1756 avss.n1754 1.57121
R3248 avss.n1747 avss.n1746 1.57121
R3249 avss.n1746 avss.n1742 1.57121
R3250 avss.n1747 avss.n1740 1.57121
R3251 avss.n1742 avss.n1740 1.57121
R3252 avss.n1800 avss.n1799 1.57121
R3253 avss.n1799 avss.n1795 1.57121
R3254 avss.n1800 avss.n1793 1.57121
R3255 avss.n1795 avss.n1793 1.57121
R3256 avss.n1737 avss.n1736 1.57121
R3257 avss.n1736 avss.n1732 1.57121
R3258 avss.n1737 avss.n1730 1.57121
R3259 avss.n1732 avss.n1730 1.57121
R3260 avss.n1821 avss.n1820 1.57121
R3261 avss.n1820 avss.n1816 1.57121
R3262 avss.n1821 avss.n1814 1.57121
R3263 avss.n1816 avss.n1814 1.57121
R3264 avss.n1810 avss.n1809 1.57121
R3265 avss.n1809 avss.n1805 1.57121
R3266 avss.n1810 avss.n1803 1.57121
R3267 avss.n1805 avss.n1803 1.57121
R3268 avss.n1787 avss.n1786 1.57121
R3269 avss.n1786 avss.n1782 1.57121
R3270 avss.n1787 avss.n1780 1.57121
R3271 avss.n1782 avss.n1780 1.57121
R3272 avss.n1779 avss.n1778 1.57121
R3273 avss.n1778 avss.n1774 1.57121
R3274 avss.n1779 avss.n1772 1.57121
R3275 avss.n1774 avss.n1772 1.57121
R3276 avss.n91 avss.n109 1.568
R3277 avss.n271 avss.n270 1.5175
R3278 avss.n167 avss.n164 1.50403
R3279 avss.n1750 avss.n322 1.4855
R3280 avss.n307 avss.n306 1.4855
R3281 avss.n238 avss.n237 1.44692
R3282 avss.n199 avss.n198 1.44692
R3283 avss.n266 avss.n124 1.4441
R3284 avss.n1862 avss.n95 1.4405
R3285 avss.n134 avss.n132 1.4295
R3286 avss.n307 avss.n117 1.42906
R3287 avss.n293 avss.n123 1.4205
R3288 avss.n174 avss.n173 1.3995
R3289 avss.n1792 avss.n6 1.55139
R3290 avss.n1851 avss.n98 1.35881
R3291 avss.n1841 avss.n1840 1.3505
R3292 avss.n12 avss.n1762 1.43433
R3293 avss.n5 avss.n86 1.32569
R3294 avss.n1849 avss.n1848 1.3175
R3295 avss.n275 avss.n274 1.3109
R3296 avss.n137 avss.n133 1.3109
R3297 avss.n292 avss.n291 1.3001
R3298 avss.n1854 avss.n1853 1.2875
R3299 avss.n2 avss.n158 1.287
R3300 avss.n207 avss.n147 1.2855
R3301 avss.n215 avss.n205 1.2815
R3302 avss.n258 avss.n1 1.2655
R3303 avss.n302 avss.n301 1.26187
R3304 avss.n1852 avss.n98 1.2535
R3305 avss.n248 avss.n247 1.25255
R3306 avss.n216 avss.n204 1.25255
R3307 avss.n243 avss.n143 1.25255
R3308 avss.n243 avss.n242 1.2495
R3309 avss.n247 avss.n246 1.2495
R3310 avss.n186 avss.n159 1.24332
R3311 avss.n1860 avss.n95 1.2335
R3312 avss.n167 avss.n166 1.2155
R3313 avss.n140 avss.n123 1.2055
R3314 avss.n294 avss.n293 1.2045
R3315 avss.n245 avss.n244 1.1895
R3316 avss.n275 avss.n135 1.1895
R3317 avss.n183 avss.n160 1.1435
R3318 avss.n179 avss.n178 1.1435
R3319 avss.n175 avss.n174 1.139
R3320 avss.n187 avss.n186 1.139
R3321 avss.n181 avss.n180 1.139
R3322 avss.n9 avss.n10 0.0988684
R3323 avss.n108 avss.n104 1.1255
R3324 avss.n1854 avss.n100 1.1255
R3325 avss.n1859 avss.n1858 1.1255
R3326 avss.n1855 avss.n97 1.1255
R3327 avss.n1862 avss.n1861 1.1255
R3328 avss.n12 avss.n11 0.521833
R3329 avss.n1753 avss.n1752 1.1255
R3330 avss.n1749 avss.n322 1.1255
R3331 avss.n1827 avss.n114 1.1255
R3332 avss.n1829 avss.n1828 1.1255
R3333 avss.n168 avss.n164 1.1255
R3334 avss.n170 avss.n166 1.1255
R3335 avss.n234 avss.n233 1.1255
R3336 avss.n236 avss.n3 1.1255
R3337 avss.n260 avss.n141 1.1255
R3338 avss.n232 avss.n231 1.1255
R3339 avss.n230 avss.n200 1.1255
R3340 avss.n229 avss.n228 1.1255
R3341 avss.n227 avss.n201 1.1255
R3342 avss.n226 avss.n225 1.1255
R3343 avss.n224 avss.n202 1.1255
R3344 avss.n219 avss.n218 1.1255
R3345 avss.n217 avss.n150 1.1255
R3346 avss.n145 avss.n143 1.1255
R3347 avss.n252 avss.n251 1.1255
R3348 avss.n256 avss.n255 1.1255
R3349 avss.n250 avss.n249 1.1255
R3350 avss.n248 avss.n148 1.1255
R3351 avss.n212 avss.n211 1.1255
R3352 avss.n214 avss.n204 1.1255
R3353 avss.n271 avss.n139 1.1255
R3354 avss.n267 avss.n266 1.1255
R3355 avss.n291 avss.n125 1.1255
R3356 avss.n265 avss.n128 1.1255
R3357 avss.n260 avss.n259 1.1255
R3358 avss.n299 avss.n122 1.1255
R3359 avss.n290 avss.n289 1.1255
R3360 avss.n136 avss.n133 1.1255
R3361 avss.n282 avss.n281 1.1255
R3362 avss.n280 avss.n279 1.1255
R3363 avss.n276 avss.n132 1.1255
R3364 avss.n5 avss.n6 0.308041
R3365 avss avss.n108 1.0805
R3366 avss.n304 avss.n303 1.03563
R3367 avss.n289 avss.n126 1.0355
R3368 avss.n92 avss.n318 0.989758
R3369 avss.n93 avss.n87 0.976599
R3370 avss.n293 avss.n292 0.9725
R3371 avss.n7 avss.n8 0.0808518
R3372 avss.n182 avss.n181 0.959871
R3373 avss.n1842 avss.n70 0.953075
R3374 avss.n1750 avss.n112 0.9005
R3375 avss.n308 avss.n116 0.9005
R3376 avss.n10 avss.n104 0.971142
R3377 avss.n11 avss.n1753 0.879611
R3378 avss.n183 avss.n182 0.877722
R3379 avss.n173 avss.n172 0.860991
R3380 avss.n281 avss.n131 0.840059
R3381 avss.n107 avss.n10 4.9561
R3382 avss.n41 avss.n40 0.809375
R3383 avss.n1802 avss.n1801 0.764856
R3384 avss.n252 avss.n146 0.724557
R3385 avss.n207 avss.n206 0.724557
R3386 avss.n283 avss.n282 0.722171
R3387 avss.n109 avss.n103 0.7205
R3388 avss.n211 avss.n203 0.720054
R3389 avss.n72 avss.t81 0.611204
R3390 avss.n73 avss.t123 0.611204
R3391 avss.n74 avss.t120 0.611204
R3392 avss.n75 avss.t117 0.611204
R3393 avss.n76 avss.t114 0.611204
R3394 avss.n77 avss.t108 0.611204
R3395 avss.n78 avss.t111 0.611204
R3396 avss.n79 avss.t84 0.611204
R3397 avss.n80 avss.t87 0.611204
R3398 avss.n81 avss.t78 0.611204
R3399 avss.n1838 avss.n110 0.5855
R3400 avss.n155 avss.n154 0.5585
R3401 avss.n154 avss.n153 0.5585
R3402 avss.n153 avss.n152 0.5585
R3403 avss.n152 avss.n151 0.5585
R3404 avss.n194 avss.n193 0.5585
R3405 avss.n193 avss.n192 0.5585
R3406 avss.n192 avss.n191 0.5585
R3407 avss.n191 avss.n190 0.5585
R3408 avss.n1826 avss.n1825 0.549731
R3409 avss.n300 avss.n122 0.545311
R3410 avss.n3 avss.n157 0.526156
R3411 avss.n1863 avss.n1862 0.4505
R3412 avss.n1752 avss.n112 0.4505
R3413 avss.n1802 avss.n96 0.419824
R3414 avss.n240 avss.n237 0.391602
R3415 avss.n199 avss.n196 0.391602
R3416 avss.n221 avss.n203 0.385844
R3417 avss.n234 avss.n189 0.378172
R3418 avss.n82 avss.t39 0.37587
R3419 avss.n83 avss.t33 0.37587
R3420 avss.n84 avss.t30 0.37587
R3421 avss.n61 avss.t50 0.37587
R3422 avss.n85 avss.t36 0.37587
R3423 avss.n62 avss.t41 0.37587
R3424 avss.n63 avss.t125 0.37587
R3425 avss.n64 avss.t128 0.37587
R3426 avss.n65 avss.t131 0.37587
R3427 avss.n66 avss.t134 0.37587
R3428 avss.n1873 avss.n1867 0.371929
R3429 avss.n1870 avss.n1868 0.371929
R3430 avss.n1770 avss.n1764 0.371929
R3431 avss.n1767 avss.n1765 0.371929
R3432 avss.n1761 avss.n1755 0.371929
R3433 avss.n1758 avss.n1756 0.371929
R3434 avss.n1747 avss.n1741 0.371929
R3435 avss.n1744 avss.n1742 0.371929
R3436 avss.n1800 avss.n1794 0.371929
R3437 avss.n1797 avss.n1795 0.371929
R3438 avss.n1737 avss.n1731 0.371929
R3439 avss.n1734 avss.n1732 0.371929
R3440 avss.n1821 avss.n1815 0.371929
R3441 avss.n1818 avss.n1816 0.371929
R3442 avss.n1810 avss.n1804 0.371929
R3443 avss.n1807 avss.n1805 0.371929
R3444 avss.n1787 avss.n1781 0.371929
R3445 avss.n1784 avss.n1782 0.371929
R3446 avss.n1779 avss.n1773 0.371929
R3447 avss.n1776 avss.n1774 0.371929
R3448 avss.n266 avss.n265 0.347214
R3449 avss.n300 avss.n120 0.344921
R3450 avss.n1825 avss.n323 0.336058
R3451 avss.n312 avss.n118 0.335201
R3452 avss.n257 avss.n256 0.331782
R3453 avss.n224 avss.n223 0.3205
R3454 avss.n17 avss.t75 0.315918
R3455 avss.n18 avss.t90 0.315918
R3456 avss.n19 avss.t93 0.315918
R3457 avss.n20 avss.t96 0.315918
R3458 avss.n21 avss.t99 0.315918
R3459 avss.n22 avss.t102 0.315918
R3460 avss.n23 avss.t105 0.315918
R3461 avss.n24 avss.t69 0.315918
R3462 avss.n25 avss.t66 0.315918
R3463 avss.n26 avss.t63 0.315918
R3464 avss.n27 avss.t60 0.315918
R3465 avss.n28 avss.t57 0.315918
R3466 avss.n29 avss.t54 0.315918
R3467 avss.n30 avss.t72 0.315918
R3468 avss.n297 avss.n294 0.313173
R3469 avss.n157 avss.n156 0.307689
R3470 avss.n1872 avss.n1871 0.306382
R3471 avss.n1869 avss.n1866 0.306382
R3472 avss.n1769 avss.n1768 0.306382
R3473 avss.n1766 avss.n1763 0.306382
R3474 avss.n1760 avss.n1759 0.306382
R3475 avss.n1757 avss.n1754 0.306382
R3476 avss.n1746 avss.n1745 0.306382
R3477 avss.n1743 avss.n1740 0.306382
R3478 avss.n1799 avss.n1798 0.306382
R3479 avss.n1796 avss.n1793 0.306382
R3480 avss.n1736 avss.n1735 0.306382
R3481 avss.n1733 avss.n1730 0.306382
R3482 avss.n1820 avss.n1819 0.306382
R3483 avss.n1817 avss.n1814 0.306382
R3484 avss.n1809 avss.n1808 0.306382
R3485 avss.n1806 avss.n1803 0.306382
R3486 avss.n1786 avss.n1785 0.306382
R3487 avss.n1783 avss.n1780 0.306382
R3488 avss.n1778 avss.n1777 0.306382
R3489 avss.n1775 avss.n1772 0.306382
R3490 avss.n274 avss.n273 0.29517
R3491 avss.n314 avss.n117 0.29404
R3492 avss.n43 avss.t27 0.280745
R3493 avss.n238 avss.t143 0.280745
R3494 avss.n238 avss.t144 0.280745
R3495 avss.n198 avss.t44 0.280745
R3496 avss.n198 avss.t45 0.280745
R3497 avss.n44 avss.t165 0.280745
R3498 avss.n45 avss.t153 0.280745
R3499 avss.n46 avss.t150 0.280745
R3500 avss.n47 avss.t147 0.280745
R3501 avss.n48 avss.t162 0.280745
R3502 avss.n49 avss.t159 0.280745
R3503 avss.n50 avss.t156 0.280745
R3504 avss.n51 avss.t141 0.280745
R3505 avss.n52 avss.t48 0.280745
R3506 avss.n53 avss.t138 0.280745
R3507 avss.n54 avss.t24 0.280745
R3508 avss.n55 avss.t21 0.280745
R3509 avss.n56 avss.t18 0.280745
R3510 avss.n57 avss.t15 0.280745
R3511 avss.n58 avss.t12 0.280745
R3512 avss.n59 avss.t9 0.280745
R3513 avss.n60 avss.t6 0.280745
R3514 avss.n313 avss.n312 0.280356
R3515 avss.n158 avss.n157 0.275689
R3516 avss.n178 avss.n164 0.2723
R3517 avss.n175 avss.n166 0.26555
R3518 avss.n298 avss.n297 0.256513
R3519 avss.n187 avss.n160 0.2565
R3520 avss.n180 avss.n179 0.2565
R3521 avss.n229 avss.n201 0.2565
R3522 avss.n225 avss.n224 0.2565
R3523 avss.n251 avss.n250 0.2565
R3524 avss.n218 avss.n217 0.2565
R3525 avss.n1861 avss.n1860 0.2525
R3526 avss.n286 avss.t179 0.250627
R3527 avss.n286 avss.t180 0.250627
R3528 avss.n31 avss.t168 0.250627
R3529 avss.n32 avss.t183 0.250627
R3530 avss.n33 avss.t177 0.250627
R3531 avss.n34 avss.t174 0.250627
R3532 avss.n35 avss.t171 0.250627
R3533 avss.n36 avss.t186 0.250627
R3534 avss.n37 avss.t189 0.250627
R3535 avss.n38 avss.t192 0.250627
R3536 avss.n39 avss.t195 0.250627
R3537 avss.n272 avss.n271 0.2485
R3538 avss.n189 avss.n188 0.247589
R3539 avss.n189 avss.n158 0.245633
R3540 avss.n323 avss.n114 0.2405
R3541 avss.n1829 avss.n114 0.2405
R3542 avss.n230 avss.n229 0.2405
R3543 avss.n225 avss.n201 0.2405
R3544 avss.n3 avss.n1 0.238451
R3545 avss.n302 avss.n122 0.2384
R3546 avss.n182 avss.n162 0.237236
R3547 avss.n188 avss.n159 0.23592
R3548 avss.n2 avss.n235 0.2345
R3549 avss.n172 avss.n170 0.232862
R3550 avss.n314 avss.n313 0.229861
R3551 avss.n1858 avss.n98 0.22355
R3552 avss.n1855 avss.n1854 0.219425
R3553 avss.n146 avss.n145 0.217929
R3554 avss.n206 avss.n148 0.217929
R3555 avss.n259 avss.n257 0.213178
R3556 avss.n231 avss.n230 0.2085
R3557 avss.n282 avss.n280 0.2085
R3558 avss.n280 avss.n132 0.2085
R3559 avss.n1861 avss.n96 0.2085
R3560 avss.n276 avss.n275 0.203343
R3561 avss.n279 avss.n133 0.203343
R3562 avss.n299 avss.n298 0.202332
R3563 avss.n9 avss.n105 0.201364
R3564 avss.n105 avss.n100 0.200855
R3565 avss.n287 avss.n127 0.200225
R3566 avss.n8 avss.n272 0.377663
R3567 avss.n236 avss.n155 0.1868
R3568 avss.n233 avss.n194 0.1868
R3569 avss.n1790 avss.n1789 0.1805
R3570 avss.n3 avss.n0 0.216538
R3571 avss.n235 avss.n42 0.214333
R3572 avss.n137 avss.n131 0.176073
R3573 avss.n264 avss.n128 0.1685
R3574 avss.n135 avss.n132 0.1685
R3575 avss.n309 avss.n118 0.167972
R3576 avss.n156 avss.t210 0.163872
R3577 avss.n1859 avss.n97 0.1605
R3578 avss.n169 avss.n168 0.1605
R3579 avss.n188 avss.n187 0.1605
R3580 avss.n180 avss.n162 0.1605
R3581 avss.n174 avss.n163 0.1605
R3582 avss.n251 avss.n142 0.1605
R3583 avss.n214 avss.n213 0.1605
R3584 avss.n213 avss.n212 0.1565
R3585 avss.n120 avss.n118 0.153284
R3586 avss.n125 avss.n124 0.1525
R3587 avss.n138 avss.n136 0.1525
R3588 avss.n168 avss.n163 0.1525
R3589 avss.n249 avss.n248 0.151775
R3590 avss.n205 avss.n204 0.151775
R3591 avss.n255 avss.n143 0.151775
R3592 avss.n1751 avss.n1749 0.147611
R3593 avss.n1749 avss.n323 0.147611
R3594 avss.n1748 avss 0.145
R3595 avss.n264 avss.n125 0.1445
R3596 avss.n274 avss.n138 0.1445
R3597 avss.n136 avss.n135 0.1445
R3598 avss.n244 avss.n243 0.1405
R3599 avss.n247 avss.n149 0.1405
R3600 avss.n145 avss.n142 0.1365
R3601 avss.n148 avss.n147 0.1365
R3602 avss.n216 avss.n215 0.1365
R3603 avss.n141 avss.n123 0.1365
R3604 avss.n1789 avss.n1788 0.1355
R3605 avss.n1045 avss.n552 0.1355
R3606 avss.n1813 avss.n1812 0.1355
R3607 avss.n244 avss.n146 0.134402
R3608 avss.n206 avss.n149 0.134402
R3609 avss.n301 avss.n300 0.134119
R3610 avss.n231 avss.n158 0.1285
R3611 avss.n223 avss.n221 0.127445
R3612 avss.n1853 avss.n1851 0.122786
R3613 avss.n1771 avss 0.1225
R3614 avss.n196 avss.n195 0.122
R3615 avss.n1864 avss 0.122
R3616 avss.n1852 avss.n97 0.1205
R3617 avss.n169 avss.n167 0.1205
R3618 avss.n1753 avss.n1751 0.119611
R3619 avss.n72 avss.n71 1.38938
R3620 avss.n1748 avss 0.113389
R3621 avss.n1853 avss.n1852 0.1045
R3622 avss.n218 avss.n216 0.1045
R3623 avss.n236 avss.n40 0.0980375
R3624 avss.n241 avss.n240 0.095
R3625 avss avss.n1865 0.0905
R3626 avss.n269 avss.n139 0.0905
R3627 avss.n1573 avss.n376 0.0905
R3628 avss.n1577 avss.n376 0.0905
R3629 avss.n1578 avss.n1577 0.0905
R3630 avss.n1579 avss.n1578 0.0905
R3631 avss.n1579 avss.n374 0.0905
R3632 avss.n1583 avss.n374 0.0905
R3633 avss.n1584 avss.n1583 0.0905
R3634 avss.n1585 avss.n1584 0.0905
R3635 avss.n1585 avss.n372 0.0905
R3636 avss.n1589 avss.n372 0.0905
R3637 avss.n1590 avss.n1589 0.0905
R3638 avss.n1591 avss.n1590 0.0905
R3639 avss.n1591 avss.n370 0.0905
R3640 avss.n1595 avss.n370 0.0905
R3641 avss.n1596 avss.n1595 0.0905
R3642 avss.n1597 avss.n1596 0.0905
R3643 avss.n1597 avss.n368 0.0905
R3644 avss.n1601 avss.n368 0.0905
R3645 avss.n1602 avss.n1601 0.0905
R3646 avss.n1603 avss.n1602 0.0905
R3647 avss.n1603 avss.n366 0.0905
R3648 avss.n1607 avss.n366 0.0905
R3649 avss.n1608 avss.n1607 0.0905
R3650 avss.n1609 avss.n1608 0.0905
R3651 avss.n1609 avss.n364 0.0905
R3652 avss.n1613 avss.n364 0.0905
R3653 avss.n1614 avss.n1613 0.0905
R3654 avss.n1615 avss.n1614 0.0905
R3655 avss.n1615 avss.n362 0.0905
R3656 avss.n1619 avss.n362 0.0905
R3657 avss.n1620 avss.n1619 0.0905
R3658 avss.n1621 avss.n1620 0.0905
R3659 avss.n1621 avss.n360 0.0905
R3660 avss.n1625 avss.n360 0.0905
R3661 avss.n1626 avss.n1625 0.0905
R3662 avss.n1627 avss.n1626 0.0905
R3663 avss.n1627 avss.n358 0.0905
R3664 avss.n1631 avss.n358 0.0905
R3665 avss.n1632 avss.n1631 0.0905
R3666 avss.n1633 avss.n1632 0.0905
R3667 avss.n1633 avss.n356 0.0905
R3668 avss.n1637 avss.n356 0.0905
R3669 avss.n1638 avss.n1637 0.0905
R3670 avss.n1639 avss.n1638 0.0905
R3671 avss.n1639 avss.n354 0.0905
R3672 avss.n1643 avss.n354 0.0905
R3673 avss.n1644 avss.n1643 0.0905
R3674 avss.n1645 avss.n1644 0.0905
R3675 avss.n1645 avss.n352 0.0905
R3676 avss.n1649 avss.n352 0.0905
R3677 avss.n1650 avss.n1649 0.0905
R3678 avss.n1651 avss.n1650 0.0905
R3679 avss.n1651 avss.n350 0.0905
R3680 avss.n1655 avss.n350 0.0905
R3681 avss.n1656 avss.n1655 0.0905
R3682 avss.n1657 avss.n1656 0.0905
R3683 avss.n1657 avss.n348 0.0905
R3684 avss.n1661 avss.n348 0.0905
R3685 avss.n1662 avss.n1661 0.0905
R3686 avss.n1663 avss.n1662 0.0905
R3687 avss.n1663 avss.n346 0.0905
R3688 avss.n1667 avss.n346 0.0905
R3689 avss.n1668 avss.n1667 0.0905
R3690 avss.n1669 avss.n1668 0.0905
R3691 avss.n1669 avss.n344 0.0905
R3692 avss.n1673 avss.n344 0.0905
R3693 avss.n1674 avss.n1673 0.0905
R3694 avss.n1675 avss.n1674 0.0905
R3695 avss.n1675 avss.n342 0.0905
R3696 avss.n1679 avss.n342 0.0905
R3697 avss.n1680 avss.n1679 0.0905
R3698 avss.n1681 avss.n1680 0.0905
R3699 avss.n1681 avss.n340 0.0905
R3700 avss.n1685 avss.n340 0.0905
R3701 avss.n1686 avss.n1685 0.0905
R3702 avss.n1687 avss.n1686 0.0905
R3703 avss.n1687 avss.n338 0.0905
R3704 avss.n1691 avss.n338 0.0905
R3705 avss.n1692 avss.n1691 0.0905
R3706 avss.n1693 avss.n1692 0.0905
R3707 avss.n1693 avss.n336 0.0905
R3708 avss.n1697 avss.n336 0.0905
R3709 avss.n1698 avss.n1697 0.0905
R3710 avss.n1699 avss.n1698 0.0905
R3711 avss.n1699 avss.n334 0.0905
R3712 avss.n1703 avss.n334 0.0905
R3713 avss.n1704 avss.n1703 0.0905
R3714 avss.n1705 avss.n1704 0.0905
R3715 avss.n1705 avss.n332 0.0905
R3716 avss.n1709 avss.n332 0.0905
R3717 avss.n1710 avss.n1709 0.0905
R3718 avss.n1711 avss.n1710 0.0905
R3719 avss.n1711 avss.n330 0.0905
R3720 avss.n1715 avss.n330 0.0905
R3721 avss.n1716 avss.n1715 0.0905
R3722 avss.n1717 avss.n1716 0.0905
R3723 avss.n1717 avss.n328 0.0905
R3724 avss.n1721 avss.n328 0.0905
R3725 avss.n1722 avss.n1721 0.0905
R3726 avss.n1723 avss.n1722 0.0905
R3727 avss.n1723 avss.n325 0.0905
R3728 avss.n1727 avss.n325 0.0905
R3729 avss.n1572 avss.n1571 0.0905
R3730 avss.n1571 avss.n378 0.0905
R3731 avss.n1567 avss.n378 0.0905
R3732 avss.n1567 avss.n1566 0.0905
R3733 avss.n1566 avss.n1565 0.0905
R3734 avss.n1565 avss.n380 0.0905
R3735 avss.n1561 avss.n380 0.0905
R3736 avss.n1561 avss.n1560 0.0905
R3737 avss.n1560 avss.n1559 0.0905
R3738 avss.n1559 avss.n382 0.0905
R3739 avss.n1555 avss.n382 0.0905
R3740 avss.n1555 avss.n1554 0.0905
R3741 avss.n1554 avss.n1553 0.0905
R3742 avss.n1553 avss.n384 0.0905
R3743 avss.n1549 avss.n384 0.0905
R3744 avss.n1549 avss.n1548 0.0905
R3745 avss.n1548 avss.n1547 0.0905
R3746 avss.n1547 avss.n386 0.0905
R3747 avss.n1543 avss.n386 0.0905
R3748 avss.n1543 avss.n1542 0.0905
R3749 avss.n1542 avss.n1541 0.0905
R3750 avss.n1541 avss.n388 0.0905
R3751 avss.n1537 avss.n388 0.0905
R3752 avss.n1537 avss.n1536 0.0905
R3753 avss.n1536 avss.n1535 0.0905
R3754 avss.n1535 avss.n390 0.0905
R3755 avss.n1531 avss.n390 0.0905
R3756 avss.n1531 avss.n1530 0.0905
R3757 avss.n1530 avss.n1529 0.0905
R3758 avss.n1529 avss.n392 0.0905
R3759 avss.n1525 avss.n392 0.0905
R3760 avss.n1525 avss.n1524 0.0905
R3761 avss.n1524 avss.n1523 0.0905
R3762 avss.n1523 avss.n394 0.0905
R3763 avss.n1519 avss.n394 0.0905
R3764 avss.n1519 avss.n1518 0.0905
R3765 avss.n1518 avss.n1517 0.0905
R3766 avss.n1517 avss.n396 0.0905
R3767 avss.n1513 avss.n396 0.0905
R3768 avss.n1513 avss.n1512 0.0905
R3769 avss.n1512 avss.n1511 0.0905
R3770 avss.n1511 avss.n398 0.0905
R3771 avss.n1507 avss.n398 0.0905
R3772 avss.n1507 avss.n1506 0.0905
R3773 avss.n1506 avss.n1505 0.0905
R3774 avss.n1505 avss.n400 0.0905
R3775 avss.n1501 avss.n400 0.0905
R3776 avss.n1501 avss.n1500 0.0905
R3777 avss.n1500 avss.n1499 0.0905
R3778 avss.n1499 avss.n402 0.0905
R3779 avss.n1495 avss.n402 0.0905
R3780 avss.n1495 avss.n1494 0.0905
R3781 avss.n1494 avss.n1493 0.0905
R3782 avss.n1493 avss.n404 0.0905
R3783 avss.n1489 avss.n404 0.0905
R3784 avss.n1489 avss.n1488 0.0905
R3785 avss.n1488 avss.n1487 0.0905
R3786 avss.n1487 avss.n406 0.0905
R3787 avss.n1483 avss.n406 0.0905
R3788 avss.n1483 avss.n1482 0.0905
R3789 avss.n1482 avss.n1481 0.0905
R3790 avss.n1481 avss.n408 0.0905
R3791 avss.n1477 avss.n408 0.0905
R3792 avss.n1477 avss.n1476 0.0905
R3793 avss.n1476 avss.n1475 0.0905
R3794 avss.n1475 avss.n410 0.0905
R3795 avss.n1471 avss.n410 0.0905
R3796 avss.n1471 avss.n1470 0.0905
R3797 avss.n1470 avss.n1469 0.0905
R3798 avss.n1469 avss.n412 0.0905
R3799 avss.n1465 avss.n412 0.0905
R3800 avss.n1465 avss.n1464 0.0905
R3801 avss.n1464 avss.n1463 0.0905
R3802 avss.n1463 avss.n414 0.0905
R3803 avss.n1459 avss.n414 0.0905
R3804 avss.n1459 avss.n1458 0.0905
R3805 avss.n1458 avss.n1457 0.0905
R3806 avss.n1457 avss.n416 0.0905
R3807 avss.n1453 avss.n416 0.0905
R3808 avss.n1453 avss.n1452 0.0905
R3809 avss.n1452 avss.n1451 0.0905
R3810 avss.n1451 avss.n418 0.0905
R3811 avss.n1447 avss.n418 0.0905
R3812 avss.n1447 avss.n1446 0.0905
R3813 avss.n1446 avss.n1445 0.0905
R3814 avss.n1445 avss.n420 0.0905
R3815 avss.n1441 avss.n420 0.0905
R3816 avss.n1441 avss.n1440 0.0905
R3817 avss.n1440 avss.n1439 0.0905
R3818 avss.n1439 avss.n422 0.0905
R3819 avss.n1435 avss.n422 0.0905
R3820 avss.n1435 avss.n1434 0.0905
R3821 avss.n1434 avss.n1433 0.0905
R3822 avss.n1433 avss.n424 0.0905
R3823 avss.n1429 avss.n424 0.0905
R3824 avss.n1429 avss.n1428 0.0905
R3825 avss.n1428 avss.n1427 0.0905
R3826 avss.n1427 avss.n426 0.0905
R3827 avss.n1423 avss.n426 0.0905
R3828 avss.n1423 avss.n1422 0.0905
R3829 avss.n1422 avss.n1421 0.0905
R3830 avss.n1421 avss.n428 0.0905
R3831 avss.n1417 avss.n428 0.0905
R3832 avss.n1417 avss.n1416 0.0905
R3833 avss.n1416 avss.n1415 0.0905
R3834 avss.n1415 avss.n430 0.0905
R3835 avss.n1411 avss.n430 0.0905
R3836 avss.n1411 avss.n1410 0.0905
R3837 avss.n1410 avss.n1409 0.0905
R3838 avss.n1409 avss.n432 0.0905
R3839 avss.n1405 avss.n432 0.0905
R3840 avss.n1405 avss.n1404 0.0905
R3841 avss.n1404 avss.n1403 0.0905
R3842 avss.n1403 avss.n434 0.0905
R3843 avss.n1399 avss.n434 0.0905
R3844 avss.n1399 avss.n1398 0.0905
R3845 avss.n1398 avss.n1397 0.0905
R3846 avss.n1397 avss.n436 0.0905
R3847 avss.n1393 avss.n436 0.0905
R3848 avss.n1393 avss.n1392 0.0905
R3849 avss.n1392 avss.n1391 0.0905
R3850 avss.n1391 avss.n438 0.0905
R3851 avss.n1387 avss.n438 0.0905
R3852 avss.n1387 avss.n1386 0.0905
R3853 avss.n1386 avss.n1385 0.0905
R3854 avss.n1385 avss.n440 0.0905
R3855 avss.n1381 avss.n440 0.0905
R3856 avss.n1381 avss.n1380 0.0905
R3857 avss.n1380 avss.n1379 0.0905
R3858 avss.n1379 avss.n442 0.0905
R3859 avss.n1375 avss.n442 0.0905
R3860 avss.n1375 avss.n1374 0.0905
R3861 avss.n1374 avss.n1373 0.0905
R3862 avss.n1373 avss.n444 0.0905
R3863 avss.n1369 avss.n444 0.0905
R3864 avss.n1369 avss.n1368 0.0905
R3865 avss.n1368 avss.n1367 0.0905
R3866 avss.n1367 avss.n446 0.0905
R3867 avss.n1363 avss.n446 0.0905
R3868 avss.n1363 avss.n1362 0.0905
R3869 avss.n1362 avss.n1361 0.0905
R3870 avss.n1361 avss.n448 0.0905
R3871 avss.n1357 avss.n448 0.0905
R3872 avss.n1357 avss.n1356 0.0905
R3873 avss.n1356 avss.n1355 0.0905
R3874 avss.n1355 avss.n450 0.0905
R3875 avss.n1351 avss.n450 0.0905
R3876 avss.n1351 avss.n1350 0.0905
R3877 avss.n1350 avss.n1349 0.0905
R3878 avss.n1349 avss.n452 0.0905
R3879 avss.n1345 avss.n452 0.0905
R3880 avss.n1345 avss.n1344 0.0905
R3881 avss.n1344 avss.n1343 0.0905
R3882 avss.n1343 avss.n454 0.0905
R3883 avss.n1339 avss.n454 0.0905
R3884 avss.n1339 avss.n1338 0.0905
R3885 avss.n1338 avss.n1337 0.0905
R3886 avss.n1337 avss.n456 0.0905
R3887 avss.n1333 avss.n456 0.0905
R3888 avss.n1333 avss.n1332 0.0905
R3889 avss.n1332 avss.n1331 0.0905
R3890 avss.n1331 avss.n458 0.0905
R3891 avss.n1327 avss.n458 0.0905
R3892 avss.n1327 avss.n1326 0.0905
R3893 avss.n1326 avss.n1325 0.0905
R3894 avss.n1325 avss.n460 0.0905
R3895 avss.n1321 avss.n460 0.0905
R3896 avss.n1321 avss.n1320 0.0905
R3897 avss.n1320 avss.n1319 0.0905
R3898 avss.n1319 avss.n462 0.0905
R3899 avss.n1315 avss.n462 0.0905
R3900 avss.n1315 avss.n1314 0.0905
R3901 avss.n1314 avss.n1313 0.0905
R3902 avss.n1313 avss.n464 0.0905
R3903 avss.n1309 avss.n464 0.0905
R3904 avss.n1309 avss.n1308 0.0905
R3905 avss.n1308 avss.n1307 0.0905
R3906 avss.n1307 avss.n466 0.0905
R3907 avss.n1303 avss.n466 0.0905
R3908 avss.n1303 avss.n1302 0.0905
R3909 avss.n1302 avss.n1301 0.0905
R3910 avss.n1301 avss.n468 0.0905
R3911 avss.n1297 avss.n468 0.0905
R3912 avss.n1297 avss.n1296 0.0905
R3913 avss.n1296 avss.n1295 0.0905
R3914 avss.n1295 avss.n470 0.0905
R3915 avss.n1291 avss.n470 0.0905
R3916 avss.n1291 avss.n1290 0.0905
R3917 avss.n1290 avss.n1289 0.0905
R3918 avss.n1289 avss.n472 0.0905
R3919 avss.n1285 avss.n472 0.0905
R3920 avss.n1285 avss.n1284 0.0905
R3921 avss.n1284 avss.n1283 0.0905
R3922 avss.n1283 avss.n474 0.0905
R3923 avss.n1279 avss.n474 0.0905
R3924 avss.n1279 avss.n1278 0.0905
R3925 avss.n1278 avss.n1277 0.0905
R3926 avss.n1277 avss.n476 0.0905
R3927 avss.n1273 avss.n476 0.0905
R3928 avss.n1273 avss.n1272 0.0905
R3929 avss.n1272 avss.n1271 0.0905
R3930 avss.n1271 avss.n478 0.0905
R3931 avss.n1267 avss.n478 0.0905
R3932 avss.n1267 avss.n1266 0.0905
R3933 avss.n1266 avss.n1265 0.0905
R3934 avss.n1265 avss.n480 0.0905
R3935 avss.n1261 avss.n480 0.0905
R3936 avss.n1261 avss.n1260 0.0905
R3937 avss.n1260 avss.n1259 0.0905
R3938 avss.n1259 avss.n482 0.0905
R3939 avss.n1255 avss.n482 0.0905
R3940 avss.n1255 avss.n1254 0.0905
R3941 avss.n1254 avss.n1253 0.0905
R3942 avss.n1253 avss.n484 0.0905
R3943 avss.n1249 avss.n484 0.0905
R3944 avss.n1249 avss.n1248 0.0905
R3945 avss.n1248 avss.n1247 0.0905
R3946 avss.n1247 avss.n486 0.0905
R3947 avss.n1243 avss.n486 0.0905
R3948 avss.n1243 avss.n1242 0.0905
R3949 avss.n1242 avss.n1241 0.0905
R3950 avss.n1241 avss.n488 0.0905
R3951 avss.n1237 avss.n488 0.0905
R3952 avss.n1237 avss.n1236 0.0905
R3953 avss.n1236 avss.n1235 0.0905
R3954 avss.n1235 avss.n490 0.0905
R3955 avss.n1231 avss.n490 0.0905
R3956 avss.n1231 avss.n1230 0.0905
R3957 avss.n1230 avss.n1229 0.0905
R3958 avss.n1229 avss.n492 0.0905
R3959 avss.n1225 avss.n492 0.0905
R3960 avss.n1225 avss.n1224 0.0905
R3961 avss.n1224 avss.n1223 0.0905
R3962 avss.n1223 avss.n494 0.0905
R3963 avss.n1219 avss.n494 0.0905
R3964 avss.n1219 avss.n1218 0.0905
R3965 avss.n1218 avss.n1217 0.0905
R3966 avss.n1217 avss.n496 0.0905
R3967 avss.n1213 avss.n496 0.0905
R3968 avss.n1213 avss.n1212 0.0905
R3969 avss.n1212 avss.n1211 0.0905
R3970 avss.n1211 avss.n498 0.0905
R3971 avss.n1207 avss.n498 0.0905
R3972 avss.n1207 avss.n1206 0.0905
R3973 avss.n1206 avss.n1205 0.0905
R3974 avss.n1205 avss.n500 0.0905
R3975 avss.n1201 avss.n500 0.0905
R3976 avss.n1200 avss.n1199 0.0905
R3977 avss.n1199 avss.n502 0.0905
R3978 avss.n1195 avss.n502 0.0905
R3979 avss.n1195 avss.n1194 0.0905
R3980 avss.n1194 avss.n1193 0.0905
R3981 avss.n1193 avss.n504 0.0905
R3982 avss.n1189 avss.n504 0.0905
R3983 avss.n1189 avss.n1188 0.0905
R3984 avss.n1188 avss.n1187 0.0905
R3985 avss.n1187 avss.n506 0.0905
R3986 avss.n1183 avss.n506 0.0905
R3987 avss.n1183 avss.n1182 0.0905
R3988 avss.n1182 avss.n1181 0.0905
R3989 avss.n1181 avss.n508 0.0905
R3990 avss.n1177 avss.n508 0.0905
R3991 avss.n1177 avss.n1176 0.0905
R3992 avss.n1176 avss.n1175 0.0905
R3993 avss.n1175 avss.n510 0.0905
R3994 avss.n1171 avss.n510 0.0905
R3995 avss.n1171 avss.n1170 0.0905
R3996 avss.n1170 avss.n1169 0.0905
R3997 avss.n1169 avss.n512 0.0905
R3998 avss.n1165 avss.n512 0.0905
R3999 avss.n1165 avss.n1164 0.0905
R4000 avss.n1164 avss.n1163 0.0905
R4001 avss.n1163 avss.n514 0.0905
R4002 avss.n1159 avss.n514 0.0905
R4003 avss.n1159 avss.n1158 0.0905
R4004 avss.n1158 avss.n1157 0.0905
R4005 avss.n1157 avss.n516 0.0905
R4006 avss.n1153 avss.n516 0.0905
R4007 avss.n1153 avss.n1152 0.0905
R4008 avss.n1152 avss.n1151 0.0905
R4009 avss.n1151 avss.n518 0.0905
R4010 avss.n1147 avss.n518 0.0905
R4011 avss.n1147 avss.n1146 0.0905
R4012 avss.n1146 avss.n1145 0.0905
R4013 avss.n1145 avss.n520 0.0905
R4014 avss.n1141 avss.n520 0.0905
R4015 avss.n1141 avss.n1140 0.0905
R4016 avss.n1140 avss.n1139 0.0905
R4017 avss.n1139 avss.n522 0.0905
R4018 avss.n1135 avss.n522 0.0905
R4019 avss.n1135 avss.n1134 0.0905
R4020 avss.n1134 avss.n1133 0.0905
R4021 avss.n1133 avss.n524 0.0905
R4022 avss.n1129 avss.n524 0.0905
R4023 avss.n1129 avss.n1128 0.0905
R4024 avss.n1128 avss.n1127 0.0905
R4025 avss.n1127 avss.n526 0.0905
R4026 avss.n1123 avss.n526 0.0905
R4027 avss.n1123 avss.n1122 0.0905
R4028 avss.n1122 avss.n1121 0.0905
R4029 avss.n1121 avss.n528 0.0905
R4030 avss.n1117 avss.n528 0.0905
R4031 avss.n1117 avss.n1116 0.0905
R4032 avss.n1116 avss.n1115 0.0905
R4033 avss.n1115 avss.n530 0.0905
R4034 avss.n1111 avss.n530 0.0905
R4035 avss.n1111 avss.n1110 0.0905
R4036 avss.n1110 avss.n1109 0.0905
R4037 avss.n1109 avss.n532 0.0905
R4038 avss.n1105 avss.n532 0.0905
R4039 avss.n1105 avss.n1104 0.0905
R4040 avss.n1104 avss.n1103 0.0905
R4041 avss.n1103 avss.n534 0.0905
R4042 avss.n1099 avss.n534 0.0905
R4043 avss.n1099 avss.n1098 0.0905
R4044 avss.n1098 avss.n1097 0.0905
R4045 avss.n1097 avss.n536 0.0905
R4046 avss.n1093 avss.n536 0.0905
R4047 avss.n1093 avss.n1092 0.0905
R4048 avss.n1092 avss.n1091 0.0905
R4049 avss.n1091 avss.n538 0.0905
R4050 avss.n1087 avss.n538 0.0905
R4051 avss.n1087 avss.n1086 0.0905
R4052 avss.n1086 avss.n1085 0.0905
R4053 avss.n1085 avss.n540 0.0905
R4054 avss.n1081 avss.n540 0.0905
R4055 avss.n1081 avss.n1080 0.0905
R4056 avss.n1080 avss.n1079 0.0905
R4057 avss.n1079 avss.n542 0.0905
R4058 avss.n1075 avss.n542 0.0905
R4059 avss.n1075 avss.n1074 0.0905
R4060 avss.n1074 avss.n1073 0.0905
R4061 avss.n1073 avss.n544 0.0905
R4062 avss.n1069 avss.n544 0.0905
R4063 avss.n1069 avss.n1068 0.0905
R4064 avss.n1068 avss.n1067 0.0905
R4065 avss.n1067 avss.n546 0.0905
R4066 avss.n1063 avss.n546 0.0905
R4067 avss.n1063 avss.n1062 0.0905
R4068 avss.n1062 avss.n1061 0.0905
R4069 avss.n1061 avss.n548 0.0905
R4070 avss.n1057 avss.n548 0.0905
R4071 avss.n1057 avss.n1056 0.0905
R4072 avss.n1056 avss.n1055 0.0905
R4073 avss.n1055 avss.n550 0.0905
R4074 avss.n1051 avss.n550 0.0905
R4075 avss.n1051 avss.n1050 0.0905
R4076 avss.n1050 avss.n1049 0.0905
R4077 avss.n1049 avss.n552 0.0905
R4078 avss.n677 avss.n324 0.0905
R4079 avss.n678 avss.n677 0.0905
R4080 avss.n679 avss.n678 0.0905
R4081 avss.n679 avss.n674 0.0905
R4082 avss.n683 avss.n674 0.0905
R4083 avss.n684 avss.n683 0.0905
R4084 avss.n685 avss.n684 0.0905
R4085 avss.n685 avss.n672 0.0905
R4086 avss.n689 avss.n672 0.0905
R4087 avss.n690 avss.n689 0.0905
R4088 avss.n691 avss.n690 0.0905
R4089 avss.n691 avss.n670 0.0905
R4090 avss.n695 avss.n670 0.0905
R4091 avss.n696 avss.n695 0.0905
R4092 avss.n697 avss.n696 0.0905
R4093 avss.n697 avss.n668 0.0905
R4094 avss.n701 avss.n668 0.0905
R4095 avss.n702 avss.n701 0.0905
R4096 avss.n703 avss.n702 0.0905
R4097 avss.n703 avss.n666 0.0905
R4098 avss.n707 avss.n666 0.0905
R4099 avss.n708 avss.n707 0.0905
R4100 avss.n709 avss.n708 0.0905
R4101 avss.n709 avss.n664 0.0905
R4102 avss.n713 avss.n664 0.0905
R4103 avss.n714 avss.n713 0.0905
R4104 avss.n715 avss.n714 0.0905
R4105 avss.n715 avss.n662 0.0905
R4106 avss.n719 avss.n662 0.0905
R4107 avss.n720 avss.n719 0.0905
R4108 avss.n721 avss.n720 0.0905
R4109 avss.n721 avss.n660 0.0905
R4110 avss.n725 avss.n660 0.0905
R4111 avss.n726 avss.n725 0.0905
R4112 avss.n727 avss.n726 0.0905
R4113 avss.n727 avss.n658 0.0905
R4114 avss.n731 avss.n658 0.0905
R4115 avss.n732 avss.n731 0.0905
R4116 avss.n733 avss.n732 0.0905
R4117 avss.n733 avss.n656 0.0905
R4118 avss.n737 avss.n656 0.0905
R4119 avss.n738 avss.n737 0.0905
R4120 avss.n739 avss.n738 0.0905
R4121 avss.n739 avss.n654 0.0905
R4122 avss.n743 avss.n654 0.0905
R4123 avss.n744 avss.n743 0.0905
R4124 avss.n745 avss.n744 0.0905
R4125 avss.n745 avss.n652 0.0905
R4126 avss.n749 avss.n652 0.0905
R4127 avss.n750 avss.n749 0.0905
R4128 avss.n751 avss.n750 0.0905
R4129 avss.n751 avss.n650 0.0905
R4130 avss.n755 avss.n650 0.0905
R4131 avss.n756 avss.n755 0.0905
R4132 avss.n757 avss.n756 0.0905
R4133 avss.n757 avss.n648 0.0905
R4134 avss.n761 avss.n648 0.0905
R4135 avss.n762 avss.n761 0.0905
R4136 avss.n763 avss.n762 0.0905
R4137 avss.n763 avss.n646 0.0905
R4138 avss.n767 avss.n646 0.0905
R4139 avss.n768 avss.n767 0.0905
R4140 avss.n769 avss.n768 0.0905
R4141 avss.n769 avss.n644 0.0905
R4142 avss.n773 avss.n644 0.0905
R4143 avss.n774 avss.n773 0.0905
R4144 avss.n775 avss.n774 0.0905
R4145 avss.n775 avss.n642 0.0905
R4146 avss.n779 avss.n642 0.0905
R4147 avss.n780 avss.n779 0.0905
R4148 avss.n781 avss.n780 0.0905
R4149 avss.n781 avss.n640 0.0905
R4150 avss.n785 avss.n640 0.0905
R4151 avss.n786 avss.n785 0.0905
R4152 avss.n787 avss.n786 0.0905
R4153 avss.n787 avss.n638 0.0905
R4154 avss.n791 avss.n638 0.0905
R4155 avss.n792 avss.n791 0.0905
R4156 avss.n793 avss.n792 0.0905
R4157 avss.n793 avss.n636 0.0905
R4158 avss.n797 avss.n636 0.0905
R4159 avss.n798 avss.n797 0.0905
R4160 avss.n799 avss.n798 0.0905
R4161 avss.n799 avss.n634 0.0905
R4162 avss.n803 avss.n634 0.0905
R4163 avss.n804 avss.n803 0.0905
R4164 avss.n805 avss.n804 0.0905
R4165 avss.n805 avss.n632 0.0905
R4166 avss.n809 avss.n632 0.0905
R4167 avss.n810 avss.n809 0.0905
R4168 avss.n811 avss.n810 0.0905
R4169 avss.n811 avss.n630 0.0905
R4170 avss.n815 avss.n630 0.0905
R4171 avss.n816 avss.n815 0.0905
R4172 avss.n817 avss.n816 0.0905
R4173 avss.n817 avss.n628 0.0905
R4174 avss.n821 avss.n628 0.0905
R4175 avss.n822 avss.n821 0.0905
R4176 avss.n823 avss.n822 0.0905
R4177 avss.n823 avss.n626 0.0905
R4178 avss.n827 avss.n626 0.0905
R4179 avss.n828 avss.n827 0.0905
R4180 avss.n829 avss.n828 0.0905
R4181 avss.n829 avss.n624 0.0905
R4182 avss.n833 avss.n624 0.0905
R4183 avss.n834 avss.n833 0.0905
R4184 avss.n835 avss.n834 0.0905
R4185 avss.n835 avss.n622 0.0905
R4186 avss.n839 avss.n622 0.0905
R4187 avss.n840 avss.n839 0.0905
R4188 avss.n841 avss.n840 0.0905
R4189 avss.n841 avss.n620 0.0905
R4190 avss.n845 avss.n620 0.0905
R4191 avss.n846 avss.n845 0.0905
R4192 avss.n847 avss.n846 0.0905
R4193 avss.n847 avss.n618 0.0905
R4194 avss.n851 avss.n618 0.0905
R4195 avss.n852 avss.n851 0.0905
R4196 avss.n853 avss.n852 0.0905
R4197 avss.n853 avss.n616 0.0905
R4198 avss.n857 avss.n616 0.0905
R4199 avss.n858 avss.n857 0.0905
R4200 avss.n859 avss.n858 0.0905
R4201 avss.n859 avss.n614 0.0905
R4202 avss.n863 avss.n614 0.0905
R4203 avss.n864 avss.n863 0.0905
R4204 avss.n865 avss.n864 0.0905
R4205 avss.n865 avss.n612 0.0905
R4206 avss.n869 avss.n612 0.0905
R4207 avss.n870 avss.n869 0.0905
R4208 avss.n871 avss.n870 0.0905
R4209 avss.n871 avss.n610 0.0905
R4210 avss.n875 avss.n610 0.0905
R4211 avss.n876 avss.n875 0.0905
R4212 avss.n877 avss.n876 0.0905
R4213 avss.n877 avss.n608 0.0905
R4214 avss.n881 avss.n608 0.0905
R4215 avss.n882 avss.n881 0.0905
R4216 avss.n883 avss.n882 0.0905
R4217 avss.n883 avss.n606 0.0905
R4218 avss.n887 avss.n606 0.0905
R4219 avss.n888 avss.n887 0.0905
R4220 avss.n889 avss.n888 0.0905
R4221 avss.n889 avss.n604 0.0905
R4222 avss.n893 avss.n604 0.0905
R4223 avss.n894 avss.n893 0.0905
R4224 avss.n895 avss.n894 0.0905
R4225 avss.n895 avss.n602 0.0905
R4226 avss.n899 avss.n602 0.0905
R4227 avss.n900 avss.n899 0.0905
R4228 avss.n901 avss.n900 0.0905
R4229 avss.n901 avss.n600 0.0905
R4230 avss.n905 avss.n600 0.0905
R4231 avss.n906 avss.n905 0.0905
R4232 avss.n907 avss.n906 0.0905
R4233 avss.n907 avss.n598 0.0905
R4234 avss.n911 avss.n598 0.0905
R4235 avss.n912 avss.n911 0.0905
R4236 avss.n913 avss.n912 0.0905
R4237 avss.n913 avss.n596 0.0905
R4238 avss.n917 avss.n596 0.0905
R4239 avss.n918 avss.n917 0.0905
R4240 avss.n919 avss.n918 0.0905
R4241 avss.n919 avss.n594 0.0905
R4242 avss.n923 avss.n594 0.0905
R4243 avss.n924 avss.n923 0.0905
R4244 avss.n925 avss.n924 0.0905
R4245 avss.n925 avss.n592 0.0905
R4246 avss.n929 avss.n592 0.0905
R4247 avss.n930 avss.n929 0.0905
R4248 avss.n931 avss.n930 0.0905
R4249 avss.n931 avss.n590 0.0905
R4250 avss.n935 avss.n590 0.0905
R4251 avss.n936 avss.n935 0.0905
R4252 avss.n937 avss.n936 0.0905
R4253 avss.n937 avss.n588 0.0905
R4254 avss.n941 avss.n588 0.0905
R4255 avss.n942 avss.n941 0.0905
R4256 avss.n943 avss.n942 0.0905
R4257 avss.n943 avss.n586 0.0905
R4258 avss.n947 avss.n586 0.0905
R4259 avss.n948 avss.n947 0.0905
R4260 avss.n949 avss.n948 0.0905
R4261 avss.n949 avss.n584 0.0905
R4262 avss.n953 avss.n584 0.0905
R4263 avss.n954 avss.n953 0.0905
R4264 avss.n955 avss.n954 0.0905
R4265 avss.n955 avss.n582 0.0905
R4266 avss.n959 avss.n582 0.0905
R4267 avss.n960 avss.n959 0.0905
R4268 avss.n961 avss.n960 0.0905
R4269 avss.n961 avss.n580 0.0905
R4270 avss.n965 avss.n580 0.0905
R4271 avss.n966 avss.n965 0.0905
R4272 avss.n967 avss.n966 0.0905
R4273 avss.n967 avss.n578 0.0905
R4274 avss.n971 avss.n578 0.0905
R4275 avss.n972 avss.n971 0.0905
R4276 avss.n973 avss.n972 0.0905
R4277 avss.n973 avss.n576 0.0905
R4278 avss.n977 avss.n576 0.0905
R4279 avss.n978 avss.n977 0.0905
R4280 avss.n979 avss.n978 0.0905
R4281 avss.n979 avss.n574 0.0905
R4282 avss.n983 avss.n574 0.0905
R4283 avss.n984 avss.n983 0.0905
R4284 avss.n985 avss.n984 0.0905
R4285 avss.n985 avss.n572 0.0905
R4286 avss.n989 avss.n572 0.0905
R4287 avss.n990 avss.n989 0.0905
R4288 avss.n991 avss.n990 0.0905
R4289 avss.n991 avss.n570 0.0905
R4290 avss.n995 avss.n570 0.0905
R4291 avss.n996 avss.n995 0.0905
R4292 avss.n997 avss.n996 0.0905
R4293 avss.n997 avss.n568 0.0905
R4294 avss.n1001 avss.n568 0.0905
R4295 avss.n1002 avss.n1001 0.0905
R4296 avss.n1003 avss.n1002 0.0905
R4297 avss.n1003 avss.n566 0.0905
R4298 avss.n1007 avss.n566 0.0905
R4299 avss.n1008 avss.n1007 0.0905
R4300 avss.n1009 avss.n1008 0.0905
R4301 avss.n1009 avss.n564 0.0905
R4302 avss.n1013 avss.n564 0.0905
R4303 avss.n1014 avss.n1013 0.0905
R4304 avss.n1015 avss.n1014 0.0905
R4305 avss.n1015 avss.n562 0.0905
R4306 avss.n1019 avss.n562 0.0905
R4307 avss.n1020 avss.n1019 0.0905
R4308 avss.n1021 avss.n1020 0.0905
R4309 avss.n1021 avss.n560 0.0905
R4310 avss.n1025 avss.n560 0.0905
R4311 avss.n1026 avss.n1025 0.0905
R4312 avss.n1027 avss.n1026 0.0905
R4313 avss.n1027 avss.n558 0.0905
R4314 avss.n1031 avss.n558 0.0905
R4315 avss.n1032 avss.n1031 0.0905
R4316 avss.n1033 avss.n1032 0.0905
R4317 avss.n1033 avss.n556 0.0905
R4318 avss.n1037 avss.n556 0.0905
R4319 avss.n1038 avss.n1037 0.0905
R4320 avss.n1039 avss.n1038 0.0905
R4321 avss.n1039 avss.n554 0.0905
R4322 avss.n1043 avss.n554 0.0905
R4323 avss.n1044 avss.n1043 0.0905
R4324 avss.n1045 avss.n1044 0.0905
R4325 avss.n1801 avss.n1792 0.0905
R4326 avss.n1738 avss 0.0905
R4327 avss avss.n1729 0.0905
R4328 avss.n260 avss.n1 0.0883049
R4329 avss.n261 avss.n260 0.0880854
R4330 avss.n170 avss.n169 0.0805
R4331 avss.n162 avss.n160 0.0805
R4332 avss.n179 avss.n163 0.0805
R4333 avss.n256 avss.n142 0.0805
R4334 avss.n250 avss.n147 0.0805
R4335 avss.n215 avss.n214 0.0805
R4336 avss.n258 avss.n141 0.0805
R4337 avss.n259 avss.n258 0.0805
R4338 avss.n301 avss.n299 0.0805
R4339 avss.n1738 avss 0.077
R4340 avss.n1729 avss 0.077
R4341 avss.n69 avss 0.122167
R4342 avss.n4 avss.n1791 0.0765
R4343 avss.n239 avss.n238 0.0761176
R4344 avss.n198 avss.n197 0.0761176
R4345 avss.n1201 avss.n1200 0.0755
R4346 avss.n273 avss.n272 0.067622
R4347 avss.n213 avss.n203 0.0668984
R4348 avss.n267 avss.n264 0.0645
R4349 avss.n292 avss.n124 0.0645
R4350 avss.n138 avss.n137 0.0645
R4351 avss.n288 avss.n127 0.064087
R4352 avss.n235 avss.n234 0.0638293
R4353 avss.n261 avss.n140 0.062
R4354 avss.n1728 avss.n1727 0.0605
R4355 avss.n4 avss.n96 0.0605
R4356 avss.n286 avss.n285 0.0518875
R4357 avss.n1852 avss.n100 0.0485
R4358 avss.n1771 avss 0.0455588
R4359 avss.n1865 avss.n1864 0.0455
R4360 avss.n12 avss.n1790 0.129333
R4361 avss.n1573 avss.n1572 0.0455
R4362 avss.n1728 avss.n324 0.0455
R4363 avss.n1739 avss.n95 0.0455
R4364 avss.n217 avss.n149 0.0445
R4365 avss.n320 avss.n94 28.139
R4366 avss.n1791 avss.n68 1.4725
R4367 avss.n262 avss.n14 1.3385
R4368 avss.n1838 avss.n89 1.3145
R4369 avss.n90 avss.n284 1.10885
R4370 avss.n15 avss.n91 0.974
R4371 avss.n88 avss.n92 0.92651
R4372 avss.n87 avss.n319 0.723815
R4373 avss.n81 avss.t77 0.625763
R4374 avss.n80 avss.t86 0.625763
R4375 avss.n79 avss.t83 0.625763
R4376 avss.n78 avss.t110 0.625763
R4377 avss.n77 avss.t107 0.625763
R4378 avss.n76 avss.t113 0.625763
R4379 avss.n75 avss.t116 0.625763
R4380 avss.n74 avss.t119 0.625763
R4381 avss.n73 avss.t122 0.625763
R4382 avss.n72 avss.t80 0.625763
R4383 avss.n66 avss.t135 0.391326
R4384 avss.n65 avss.t132 0.391326
R4385 avss.n64 avss.t129 0.391326
R4386 avss.n63 avss.t126 0.391326
R4387 avss.n62 avss.t42 0.391326
R4388 avss.n61 avss.t51 0.391326
R4389 avss.n85 avss.t35 0.389873
R4390 avss.n84 avss.t29 0.389873
R4391 avss.n83 avss.t32 0.389873
R4392 avss.n82 avss.t38 0.389873
R4393 avss.n30 avss.t71 0.341323
R4394 avss.n29 avss.t53 0.341323
R4395 avss.n28 avss.t56 0.341323
R4396 avss.n27 avss.t59 0.341323
R4397 avss.n26 avss.t62 0.341323
R4398 avss.n25 avss.t65 0.341323
R4399 avss.n24 avss.t68 0.341323
R4400 avss.n23 avss.t104 0.341323
R4401 avss.n22 avss.t101 0.341323
R4402 avss.n21 avss.t98 0.341323
R4403 avss.n20 avss.t95 0.341323
R4404 avss.n19 avss.t92 0.341323
R4405 avss.n18 avss.t89 0.341323
R4406 avss.n17 avss.t74 0.341323
R4407 avss.n1842 avss.n15 0.330425
R4408 avss.n60 avss.t5 0.298637
R4409 avss.n59 avss.t8 0.298637
R4410 avss.n58 avss.t11 0.298637
R4411 avss.n57 avss.t14 0.298637
R4412 avss.n56 avss.t17 0.298637
R4413 avss.n55 avss.t20 0.298637
R4414 avss.n54 avss.t23 0.298637
R4415 avss.n53 avss.t137 0.298637
R4416 avss.n52 avss.t47 0.298637
R4417 avss.n51 avss.t140 0.298637
R4418 avss.n50 avss.t155 0.298637
R4419 avss.n49 avss.t158 0.298637
R4420 avss.n48 avss.t161 0.298637
R4421 avss.n47 avss.t146 0.298637
R4422 avss.n46 avss.t149 0.298637
R4423 avss.n45 avss.t152 0.298637
R4424 avss.n44 avss.t164 0.298637
R4425 avss.n43 avss.t26 0.298637
R4426 avss.n319 avss.n88 0.283247
R4427 avss.n39 avss.t194 0.274925
R4428 avss.n38 avss.t191 0.274925
R4429 avss.n37 avss.t188 0.274925
R4430 avss.n36 avss.t185 0.274925
R4431 avss.n35 avss.t170 0.274925
R4432 avss.n34 avss.t173 0.274925
R4433 avss.n33 avss.t176 0.274925
R4434 avss.n32 avss.t182 0.274925
R4435 avss.n31 avss.t167 0.274925
R4436 avss.n16 avss.n236 0.272413
R4437 avss.n233 avss.n41 0.267913
R4438 avss.n7 avss.n267 0.180399
R4439 avss.n3 avss.n2 0.179841
R4440 avss.n108 avss.n9 0.1765
R4441 avss.n1791 avss.n11 0.1725
R4442 avss.n5 avss.n4 0.1205
R4443 psrg_mf1_protected psrg_mf1_protected.t0 34.4979
R4444 psrg_mf1_protected psrg_mf1_protected.t1 4.75063
R4445 y1.n10 y1.t0 36.3143
R4446 y1.n6 y1.t7 36.1922
R4447 y1.n1 y1.t13 36.1574
R4448 y1.n7 y1.t9 34.3923
R4449 y1.n9 y1.t11 34.3923
R4450 y1.n2 y1.t15 34.3574
R4451 y1.n4 y1.t17 34.3574
R4452 y1.n6 y1.t8 34.3472
R4453 y1.n8 y1.t10 34.3472
R4454 y1.n10 y1.t12 34.3472
R4455 y1.n1 y1.t14 34.2865
R4456 y1.n3 y1.t16 34.2865
R4457 y1.n5 y1.t18 34.2865
R4458 y1.n12 y1.n11 25.6505
R4459 y1.n0 y1.t3 21.1316
R4460 y1.n14 y1.t2 13.894
R4461 y1.n13 y1.t1 13.7842
R4462 y1.n12 y1.t6 13.759
R4463 y1.n15 y1.n14 10.6205
R4464 y1.n0 y1.t4 9.21558
R4465 y1.n13 y1.n12 8.6405
R4466 y1 y1.n15 7.394
R4467 y1.n11 y1.n10 5.9405
R4468 y1.n15 y1.n0 5.8505
R4469 y1 y1.t5 4.69308
R4470 y1.n14 y1.n13 2.7905
R4471 y1.n9 y1.n8 1.9805
R4472 y1.n7 y1.n6 1.9805
R4473 y1.n4 y1.n3 1.9805
R4474 y1.n2 y1.n1 1.9805
R4475 y1.n10 y1.n9 1.8005
R4476 y1.n8 y1.n7 1.8005
R4477 y1.n5 y1.n4 1.8005
R4478 y1.n3 y1.n2 1.8005
R4479 y1.n11 y1.n5 0.1805
R4480 pm1.n5 pm1.n4 41.324
R4481 pm1.n6 pm1.n5 22.0055
R4482 pm1 pm1.n8 20.849
R4483 pm1.n0 pm1.t3 19.4457
R4484 pm1.n2 pm1.t2 17.6349
R4485 pm1.n0 pm1.t5 15.7557
R4486 pm1.n8 pm1.n7 14.8955
R4487 pm1.n2 pm1.n0 14.4905
R4488 pm1.n0 pm1.t4 13.8909
R4489 pm1.n4 pm1.t0 13.7649
R4490 pm1.n7 pm1.t7 13.759
R4491 pm1.n3 pm1.t1 13.7197
R4492 pm1.n1 pm1.t8 12.3566
R4493 pm1.n8 pm1.n1 10.1705
R4494 pm1.n6 pm1.t6 9.28421
R4495 pm1.n1 pm1.t9 9.21558
R4496 pm1.n7 pm1.n6 7.5605
R4497 pm1.n5 pm1.t11 4.75058
R4498 pm1 pm1.t10 4.69308
R4499 pm1.n4 pm1.n3 1.9805
R4500 pm1.n3 pm1.n2 1.8905
R4501 pm2.n7 pm2.n6 38.0705
R4502 pm2.n0 pm2.t7 26.7442
R4503 pm2.n4 pm2.t5 19.5609
R4504 pm2 pm2.n9 16.6692
R4505 pm2.n2 pm2.t2 15.6997
R4506 pm2.n3 pm2.n2 14.7155
R4507 pm2.n3 pm2.t0 13.8997
R4508 pm2.n4 pm2.t4 13.7757
R4509 pm2.n2 pm2.t1 13.7649
R4510 pm2.n7 pm2.t8 13.7156
R4511 pm2.n1 pm2.n0 12.1055
R4512 pm2.n8 pm2.n1 10.8905
R4513 pm2.n9 pm2.n8 10.6205
R4514 pm2.n6 pm2.n3 9.3155
R4515 pm2.n5 pm2.t3 9.30085
R4516 pm2.n1 pm2.t11 9.28421
R4517 pm2.n0 pm2.t6 9.25904
R4518 pm2.n9 pm2.t9 9.25158
R4519 pm2.n5 pm2.n4 6.4805
R4520 pm2.n6 pm2.n5 6.1205
R4521 pm2 pm2.t10 4.69308
R4522 pm2.n8 pm2.n7 2.5205
R4523 iref_gate.n0 iref_gate.t3 155.671
R4524 iref_gate.n1 iref_gate.t0 38.5561
R4525 iref_gate.n0 iref_gate.t1 13.6303
R4526 iref_gate.n1 iref_gate.n0 5.9855
R4527 iref_gate iref_gate.t2 4.55384
R4528 iref_gate iref_gate.n1 4.50383
R4529 vbn.n0 vbn.t3 130.732
R4530 vbn.n1 vbn.t2 26.3118
R4531 vbn.n1 vbn.t0 17.7886
R4532 vbn.n0 vbn.t4 17.7886
R4533 vbn vbn.n2 10.4394
R4534 vbn.n2 vbn.n0 6.3005
R4535 vbn vbn.t1 5.1112
R4536 vbn.n2 vbn.n1 4.5005
R4537 psrg_m3_protected.n1 psrg_m3_protected.t3 33.6292
R4538 psrg_m3_protected.n0 psrg_m3_protected.t2 20.4823
R4539 psrg_m3_protected.n1 psrg_m3_protected.n0 11.2505
R4540 psrg_m3_protected.n0 psrg_m3_protected.t1 9.52742
R4541 psrg_m3_protected psrg_m3_protected.t0 4.81592
R4542 psrg_m3_protected psrg_m3_protected.n1 4.559
R4543 psrg_vnc.n0 psrg_vnc.t9 122.335
R4544 psrg_vnc.n9 psrg_vnc.n8 31.8605
R4545 psrg_vnc.n9 psrg_vnc.t10 28.7364
R4546 psrg_vnc psrg_vnc.t11 19.6464
R4547 psrg_vnc.n7 psrg_vnc.t1 17.666
R4548 psrg_vnc.n1 psrg_vnc.t8 15.9186
R4549 psrg_vnc.n8 psrg_vnc.t0 14.1938
R4550 psrg_vnc.n3 psrg_vnc.t2 13.8021
R4551 psrg_vnc.n1 psrg_vnc.t6 13.8021
R4552 psrg_vnc.n4 psrg_vnc.t3 13.7586
R4553 psrg_vnc.n2 psrg_vnc.t7 13.7586
R4554 psrg_vnc.n7 psrg_vnc.n6 13.0955
R4555 psrg_vnc psrg_vnc.n9 10.8376
R4556 psrg_vnc.n6 psrg_vnc.n5 9.4955
R4557 psrg_vnc.n6 psrg_vnc.t5 9.30213
R4558 psrg_vnc.n0 psrg_vnc.t4 9.30213
R4559 psrg_vnc.n8 psrg_vnc.n7 6.9305
R4560 psrg_vnc.n5 psrg_vnc.n0 4.6355
R4561 psrg_vnc.n3 psrg_vnc.n2 2.1605
R4562 psrg_vnc.n5 psrg_vnc.n4 2.0705
R4563 psrg_vnc.n4 psrg_vnc.n3 1.9805
R4564 psrg_vnc.n2 psrg_vnc.n1 1.9805
R4565 vbp_cas.n29 vbp_cas.n28 68.5805
R4566 vbp_cas.n13 vbp_cas.t20 31.3027
R4567 vbp_cas.n4 vbp_cas.t27 27.3674
R4568 vbp_cas.n0 vbp_cas.t21 27.3528
R4569 vbp_cas.n10 vbp_cas.t12 25.8124
R4570 vbp_cas.n21 vbp_cas.t10 25.5874
R4571 vbp_cas.n23 vbp_cas.t8 25.5874
R4572 vbp_cas.n25 vbp_cas.t2 25.5874
R4573 vbp_cas.n27 vbp_cas.t4 25.5874
R4574 vbp_cas.n5 vbp_cas.t29 24.6674
R4575 vbp_cas.n7 vbp_cas.t31 24.6674
R4576 vbp_cas.n3 vbp_cas.t25 24.6528
R4577 vbp_cas.n4 vbp_cas.t28 24.6224
R4578 vbp_cas.n6 vbp_cas.t30 24.6224
R4579 vbp_cas.n8 vbp_cas.t32 24.6224
R4580 vbp_cas.n0 vbp_cas.t22 24.5751
R4581 vbp_cas.n2 vbp_cas.t24 24.5751
R4582 vbp_cas.n17 vbp_cas.t0 24.0124
R4583 vbp_cas.n13 vbp_cas.t16 23.1124
R4584 vbp_cas.n14 vbp_cas.t14 23.1124
R4585 vbp_cas.n10 vbp_cas.t18 23.1124
R4586 vbp_cas.n18 vbp_cas.t6 23.1124
R4587 vbp_cas.n1 vbp_cas.t23 20.1528
R4588 vbp_cas.n9 vbp_cas.t13 16.8665
R4589 vbp_cas.n19 vbp_cas.t1 15.6333
R4590 vbp_cas vbp_cas.t26 15.5628
R4591 vbp_cas.n16 vbp_cas.t17 13.9041
R4592 vbp_cas.n12 vbp_cas.t15 13.8065
R4593 vbp_cas.n28 vbp_cas.t5 13.8031
R4594 vbp_cas.n24 vbp_cas.t9 13.8031
R4595 vbp_cas.n20 vbp_cas.t7 13.8031
R4596 vbp_cas.n9 vbp_cas.t19 13.7691
R4597 vbp_cas.n26 vbp_cas.t3 13.7433
R4598 vbp_cas.n22 vbp_cas.t11 13.7433
R4599 vbp_cas.n15 vbp_cas.n14 11.2955
R4600 vbp_cas.n11 vbp_cas.n10 11.2955
R4601 vbp_cas.n29 vbp_cas.n8 10.8005
R4602 vbp_cas.n1 vbp_cas.n0 7.3805
R4603 vbp_cas.n29 vbp_cas.n3 7.2005
R4604 vbp_cas.n2 vbp_cas.n1 7.2005
R4605 vbp_cas vbp_cas.n29 4.51287
R4606 vbp_cas.n3 vbp_cas.n2 2.8805
R4607 vbp_cas.n7 vbp_cas.n6 2.8805
R4608 vbp_cas.n5 vbp_cas.n4 2.8805
R4609 vbp_cas.n17 vbp_cas.n16 2.7905
R4610 vbp_cas.n14 vbp_cas.n13 2.7005
R4611 vbp_cas.n8 vbp_cas.n7 2.7005
R4612 vbp_cas.n6 vbp_cas.n5 2.7005
R4613 vbp_cas.n19 vbp_cas.n18 2.4305
R4614 vbp_cas.n12 vbp_cas.n11 1.9805
R4615 vbp_cas.n16 vbp_cas.n15 1.8905
R4616 vbp_cas.n21 vbp_cas.n20 1.8905
R4617 vbp_cas.n23 vbp_cas.n22 1.8905
R4618 vbp_cas.n25 vbp_cas.n24 1.8905
R4619 vbp_cas.n27 vbp_cas.n26 1.8905
R4620 vbp_cas.n18 vbp_cas.n17 1.8005
R4621 vbp_cas.n20 vbp_cas.n19 1.1705
R4622 vbp_cas.n24 vbp_cas.n23 1.1705
R4623 vbp_cas.n28 vbp_cas.n27 1.1705
R4624 vbp_cas.n15 vbp_cas.n12 1.0805
R4625 vbp_cas.n22 vbp_cas.n21 0.9905
R4626 vbp_cas.n26 vbp_cas.n25 0.9905
R4627 vbp_cas.n11 vbp_cas.n9 0.9005
R4628 xf1.n5 xf1.t5 42.9365
R4629 xf1.n5 xf1.n4 41.1755
R4630 xf1.n6 xf1.n5 36.0108
R4631 xf1.n8 xf1.n7 25.1105
R4632 xf1.n1 xf1.t2 21.2642
R4633 xf1.n0 xf1.t0 16.6724
R4634 xf1.n2 xf1.t4 13.8392
R4635 xf1.n0 xf1.t11 13.8392
R4636 xf1.n1 xf1.t3 13.8024
R4637 xf1.n9 xf1.t9 13.6715
R4638 xf1.n7 xf1.t6 13.6463
R4639 xf1 xf1.n9 13.0989
R4640 xf1.n7 xf1.n6 11.0115
R4641 xf1.n3 xf1.n2 10.1705
R4642 xf1.n4 xf1.t1 9.30241
R4643 xf1.n8 xf1.t8 9.14631
R4644 xf1.n3 xf1.n0 9.0905
R4645 xf1.n9 xf1.n8 6.6605
R4646 xf1 xf1.t7 4.5781
R4647 xf1.n6 xf1.t10 4.5781
R4648 xf1.n2 xf1.n1 2.8805
R4649 xf1.n4 xf1.n3 2.7905
R4650 xf2.n5 xf2.t2 44.4215
R4651 xf2.n6 xf2.n5 39.4205
R4652 xf2.n5 xf2.n4 33.3905
R4653 xf2.n4 xf2.t10 30.2624
R4654 xf2.n9 xf2.n8 29.6105
R4655 xf2 xf2.n9 22.1187
R4656 xf2.n0 xf2.t0 16.6724
R4657 xf2.n1 xf2.t11 15.0092
R4658 xf2.n0 xf2.t1 13.8392
R4659 xf2.n3 xf2.t3 13.8392
R4660 xf2.n8 xf2.t8 13.6463
R4661 xf2.n2 xf2.t4 9.30241
R4662 xf2.n7 xf2.t5 9.17148
R4663 xf2.n6 xf2.t7 9.14631
R4664 xf2.n1 xf2.n0 9.0905
R4665 xf2.n3 xf2.n2 7.3805
R4666 xf2.n8 xf2.n7 6.4805
R4667 xf2.n7 xf2.n6 5.9405
R4668 xf2.n4 xf2.n3 4.9505
R4669 xf2.n9 xf2.t6 4.64631
R4670 xf2 xf2.t9 4.5781
R4671 xf2.n2 xf2.n1 2.7905
R4672 vgn2.n1 vgn2.t10 49.7719
R4673 vgn2.n2 vgn2.n1 46.3055
R4674 vgn2.n8 vgn2.t8 33.1543
R4675 vgn2.n8 vgn2.n7 22.1072
R4676 vgn2.n7 vgn2.t1 20.3042
R4677 vgn2 vgn2.t9 19.6464
R4678 vgn2.n0 vgn2.t3 19.0975
R4679 vgn2.n2 vgn2.t0 18.6825
R4680 vgn2.n0 vgn2.t2 18.2924
R4681 vgn2.n5 vgn2.t5 18.2516
R4682 vgn2.n6 vgn2.t4 18.2489
R4683 vgn2.n3 vgn2.t6 18.2156
R4684 vgn2.n1 vgn2.t7 16.4921
R4685 vgn2 vgn2.n8 15.3438
R4686 vgn2.n3 vgn2.n2 4.5605
R4687 vgn2.n4 vgn2.n0 1.78717
R4688 vgn2.n4 vgn2.n3 1.7205
R4689 vgn2.n7 vgn2.n6 1.02717
R4690 vgn2.n6 vgn2.n5 0.813833
R4691 vgn2.n5 vgn2.n4 0.813833
R4692 vsp.n5 vsp.n4 37.1705
R4693 vsp.n10 vsp.n9 16.8305
R4694 vsp.n0 vsp.t15 16.2006
R4695 vsp.n4 vsp.t12 13.8156
R4696 vsp.n1 vsp.t0 13.7139
R4697 vsp.n2 vsp.t2 13.7139
R4698 vsp.n0 vsp.t13 13.686
R4699 vsp.n3 vsp.t11 13.686
R4700 vsp.n6 vsp.t7 13.6715
R4701 vsp.n13 vsp.t3 13.6715
R4702 vsp.n11 vsp.t4 13.6715
R4703 vsp.n8 vsp.t1 13.6715
R4704 vsp.n12 vsp.t8 13.6463
R4705 vsp.n10 vsp.t5 13.6463
R4706 vsp.n9 vsp.t10 13.6463
R4707 vsp.n7 vsp.t6 13.6463
R4708 vsp.n5 vsp.t9 13.6463
R4709 vsp vsp.n13 11.2737
R4710 vsp vsp.t14 4.5781
R4711 vsp.n3 vsp.n2 2.5205
R4712 vsp.n1 vsp.n0 2.5205
R4713 vsp.n4 vsp.n3 2.4305
R4714 vsp.n2 vsp.n1 2.3405
R4715 vsp.n7 vsp.n6 2.1605
R4716 vsp.n9 vsp.n8 2.1605
R4717 vsp.n12 vsp.n11 2.1605
R4718 vsp.n8 vsp.n7 1.9805
R4719 vsp.n11 vsp.n10 1.9805
R4720 vsp.n13 vsp.n12 1.9805
R4721 vsp.n6 vsp.n5 1.9805
R4722 v2.n4 v2.t4 65.501
R4723 v2.n5 v2.t3 65.4526
R4724 v2.n3 v2.t5 65.4526
R4725 v2.n2 v2.t6 60.9526
R4726 v2.n1 v2.t7 60.9526
R4727 v2.n1 v2.n0 54.8555
R4728 v2.n7 v2.n0 19.4405
R4729 v2.n0 v2.t2 15.4715
R4730 v2.n6 v2.t1 13.8293
R4731 v2.n2 v2.n1 13.0505
R4732 v2.n3 v2.n2 12.2855
R4733 v2.n6 v2.n5 9.32707
R4734 v2.n7 v2.n6 9.0455
R4735 v2.n5 v2.n4 5.8505
R4736 v2 v2.n7 5.774
R4737 v2 v2.t0 4.81592
R4738 v2.n4 v2.n3 1.8005
R4739 vaux.n0 vaux.t0 60.1892
R4740 vaux vaux.n0 19.7091
R4741 vaux.n0 vaux.t1 4.97375
R4742 vaux vaux.t2 4.93012
R4743 vx3 vx3.n4 34.3187
R4744 vx3.n5 vx3.t5 31.1652
R4745 vx3 vx3.n7 19.6205
R4746 vx3.n6 vx3.n5 18.4205
R4747 vx3.n7 vx3.t8 13.8364
R4748 vx3.n0 vx3.t4 13.3392
R4749 vx3.n0 vx3.t1 13.0962
R4750 vx3.n1 vx3.t10 11.7192
R4751 vx3.n1 vx3.t3 11.4762
R4752 vx3.n3 vx3.t0 10.6392
R4753 vx3.n3 vx3.t2 10.3962
R4754 vx3.n2 vx3.n0 9.61925
R4755 vx3.n6 vx3.t7 9.33641
R4756 vx3.n7 vx3.n6 9.3155
R4757 vx3 vx3.t9 4.76969
R4758 vx3.n5 vx3.t6 4.75991
R4759 vx3.n4 vx3.n2 4.57925
R4760 vx3.n2 vx3.n1 4.5005
R4761 vx3.n4 vx3.n3 4.5005
R4762 psrg_m3_feed.n1 psrg_m3_feed.n0 129.106
R4763 psrg_m3_feed.n7 psrg_m3_feed.t15 49.1087
R4764 psrg_m3_feed.n1 psrg_m3_feed.t9 47.7002
R4765 psrg_m3_feed.n2 psrg_m3_feed.t10 47.7002
R4766 psrg_m3_feed.n3 psrg_m3_feed.t11 47.7002
R4767 psrg_m3_feed.n5 psrg_m3_feed.t13 47.7002
R4768 psrg_m3_feed.n6 psrg_m3_feed.t14 47.7002
R4769 psrg_m3_feed.n13 psrg_m3_feed.t21 47.6777
R4770 psrg_m3_feed.n14 psrg_m3_feed.t22 47.6777
R4771 psrg_m3_feed.n15 psrg_m3_feed.t23 47.6777
R4772 psrg_m3_feed.n16 psrg_m3_feed.t24 47.6777
R4773 psrg_m3_feed.n17 psrg_m3_feed.t25 47.6777
R4774 psrg_m3_feed.n21 psrg_m3_feed.t26 47.6777
R4775 psrg_m3_feed.n7 psrg_m3_feed.t16 47.6688
R4776 psrg_m3_feed.n8 psrg_m3_feed.t17 47.6688
R4777 psrg_m3_feed.n10 psrg_m3_feed.t19 47.6688
R4778 psrg_m3_feed.n11 psrg_m3_feed.t20 47.6688
R4779 psrg_m3_feed.n4 psrg_m3_feed.t12 43.2002
R4780 psrg_m3_feed.n9 psrg_m3_feed.t18 43.1688
R4781 psrg_m3_feed.n18 psrg_m3_feed.t28 36.691
R4782 psrg_m3_feed.n18 psrg_m3_feed.t27 35.431
R4783 psrg_m3_feed.n0 psrg_m3_feed.t8 29.1043
R4784 psrg_m3_feed.n19 psrg_m3_feed.t6 26.7064
R4785 psrg_m3_feed psrg_m3_feed.n24 18.437
R4786 psrg_m3_feed.n23 psrg_m3_feed.t3 16.3114
R4787 psrg_m3_feed.n12 psrg_m3_feed.t1 15.8724
R4788 psrg_m3_feed.n20 psrg_m3_feed.n19 15.3905
R4789 psrg_m3_feed.n23 psrg_m3_feed.n22 15.3005
R4790 psrg_m3_feed.n13 psrg_m3_feed.n12 14.7605
R4791 psrg_m3_feed.n12 psrg_m3_feed.t0 13.8673
R4792 psrg_m3_feed.n0 psrg_m3_feed.t7 11.305
R4793 psrg_m3_feed.n24 psrg_m3_feed.n23 10.3505
R4794 psrg_m3_feed.n19 psrg_m3_feed.t2 9.33641
R4795 psrg_m3_feed.n24 psrg_m3_feed.t4 9.33641
R4796 psrg_m3_feed.n21 psrg_m3_feed.n20 8.8205
R4797 psrg_m3_feed.n10 psrg_m3_feed.n9 5.9405
R4798 psrg_m3_feed.n9 psrg_m3_feed.n8 5.9405
R4799 psrg_m3_feed.n5 psrg_m3_feed.n4 5.9405
R4800 psrg_m3_feed.n4 psrg_m3_feed.n3 5.9405
R4801 psrg_m3_feed.n22 psrg_m3_feed.n6 5.0405
R4802 psrg_m3_feed.n22 psrg_m3_feed.n21 4.8605
R4803 psrg_m3_feed psrg_m3_feed.t5 4.75991
R4804 psrg_m3_feed.n21 psrg_m3_feed.n17 1.4405
R4805 psrg_m3_feed.n17 psrg_m3_feed.n16 1.4405
R4806 psrg_m3_feed.n16 psrg_m3_feed.n15 1.4405
R4807 psrg_m3_feed.n15 psrg_m3_feed.n14 1.4405
R4808 psrg_m3_feed.n14 psrg_m3_feed.n13 1.4405
R4809 psrg_m3_feed.n11 psrg_m3_feed.n10 1.4405
R4810 psrg_m3_feed.n8 psrg_m3_feed.n7 1.4405
R4811 psrg_m3_feed.n6 psrg_m3_feed.n5 1.4405
R4812 psrg_m3_feed.n3 psrg_m3_feed.n2 1.4405
R4813 psrg_m3_feed.n2 psrg_m3_feed.n1 1.4405
R4814 psrg_m3_feed.n20 psrg_m3_feed.n18 1.1705
R4815 psrg_m3_feed.n22 psrg_m3_feed.n11 0.1805
R4816 vx2.n0 vx2.t6 39.3003
R4817 vx2.n8 vx2.n7 34.1431
R4818 vx2.n0 vx2.t7 19.4964
R4819 vx2.n2 vx2.n1 17.3255
R4820 vx2.n8 vx2.n2 13.8605
R4821 vx2.n6 vx2.t5 13.2762
R4822 vx2.n6 vx2.t4 12.7992
R4823 vx2.n3 vx2.t1 12.1962
R4824 vx2.n3 vx2.t0 11.7192
R4825 vx2.n1 vx2.n0 10.8905
R4826 vx2.n4 vx2.t3 10.5762
R4827 vx2.n4 vx2.t2 10.0992
R4828 vx2.n5 vx2.n3 9.61925
R4829 vx2.n1 vx2.t8 9.27752
R4830 vx2.n2 vx2.t9 9.27361
R4831 vx2.n7 vx2.n5 5.11925
R4832 vx2 vx2.t10 4.75991
R4833 vx2 vx2.n8 4.51028
R4834 vx2.n7 vx2.n6 4.5005
R4835 vx2.n5 vx2.n4 4.5005
R4836 vgn1.n3 vgn1.t9 119.844
R4837 vgn1.n7 vgn1.n6 46.8905
R4838 vgn1.n5 vgn1.t2 29.9964
R4839 vgn1.n6 vgn1.t0 28.6542
R4840 vgn1.n0 vgn1.t7 23.9614
R4841 vgn1 vgn1.n7 14.8603
R4842 vgn1.n4 vgn1.t1 13.9643
R4843 vgn1.n3 vgn1.t3 13.8744
R4844 vgn1.n0 vgn1.t8 13.7814
R4845 vgn1.n1 vgn1.t4 13.7775
R4846 vgn1.n2 vgn1.t5 13.7736
R4847 vgn1.n5 vgn1.n4 10.5755
R4848 vgn1.n2 vgn1.n1 4.8605
R4849 vgn1.n1 vgn1.n0 4.8155
R4850 vgn1 vgn1.t6 4.75991
R4851 vgn1.n7 vgn1.n2 2.4755
R4852 vgn1.n4 vgn1.n3 1.8905
R4853 vgn1.n6 vgn1.n5 0.5405
R4854 vx1.n8 vx1.n7 46.0231
R4855 vx1.n0 vx1.t6 37.6353
R4856 vx1.n1 vx1.n0 13.8605
R4857 vx1.n2 vx1.t9 13.8364
R4858 vx1.n4 vx1.t3 13.4562
R4859 vx1.n4 vx1.t2 13.3392
R4860 vx1 vx1.n8 12.137
R4861 vx1.n6 vx1.t5 11.8362
R4862 vx1.n6 vx1.t4 11.7192
R4863 vx1.n2 vx1.n1 10.6655
R4864 vx1.n3 vx1.t1 10.2162
R4865 vx1.n3 vx1.t0 10.0992
R4866 vx1.n0 vx1.t7 9.33641
R4867 vx1.n1 vx1.t8 9.33641
R4868 vx1.n5 vx1.n3 9.07925
R4869 vx1.n8 vx1.n2 5.5805
R4870 vx1.n7 vx1.n5 5.11925
R4871 vx1 vx1.t10 4.75991
R4872 vx1.n7 vx1.n6 4.5005
R4873 vx1.n5 vx1.n4 4.5005
R4874 su_state.n0 su_state.t1 133.34
R4875 su_state.n0 su_state.t2 72.447
R4876 su_state su_state.t0 5.6975
R4877 su_state su_state.n0 2.69913
R4878 vbp_tail.n11 vbp_tail.n10 76.0955
R4879 vbp_tail.n4 vbp_tail.t13 36.0436
R4880 vbp_tail.n0 vbp_tail.t7 34.687
R4881 vbp_tail.n6 vbp_tail.t0 34.6554
R4882 vbp_tail.n2 vbp_tail.t10 32.3785
R4883 vbp_tail.n1 vbp_tail.t9 32.3515
R4884 vbp_tail.n0 vbp_tail.t8 32.3436
R4885 vbp_tail.n3 vbp_tail.t11 32.3337
R4886 vbp_tail.n10 vbp_tail.t5 23.8189
R4887 vbp_tail vbp_tail.t12 23.284
R4888 vbp_tail.n4 vbp_tail.t1 23.1246
R4889 vbp_tail.n5 vbp_tail.t3 23.1102
R4890 vbp_tail.n6 vbp_tail.t2 15.0643
R4891 vbp_tail.n9 vbp_tail.t6 13.9935
R4892 vbp_tail.n8 vbp_tail.t4 13.8613
R4893 vbp_tail vbp_tail.n11 9.05298
R4894 vbp_tail.n9 vbp_tail.n8 2.4305
R4895 vbp_tail.n5 vbp_tail.n4 2.3405
R4896 vbp_tail.n11 vbp_tail.n3 2.3405
R4897 vbp_tail.n3 vbp_tail.n2 2.3405
R4898 vbp_tail.n1 vbp_tail.n0 2.3405
R4899 vbp_tail.n2 vbp_tail.n1 2.1605
R4900 vbp_tail.n7 vbp_tail.n5 1.7105
R4901 vbp_tail.n10 vbp_tail.n9 1.3505
R4902 vbp_tail.n8 vbp_tail.n7 0.8105
R4903 vbp_tail.n7 vbp_tail.n6 0.5405
R4904 vbp_bias.n12 vbp_bias.t10 25.8965
R4905 vbp_bias.n4 vbp_bias.t22 25.8785
R4906 vbp_bias.n0 vbp_bias.t9 25.7583
R4907 vbp_bias.n7 vbp_bias.t24 25.5095
R4908 vbp_bias.n5 vbp_bias.t26 25.469
R4909 vbp_bias.n13 vbp_bias.t14 25.4377
R4910 vbp_bias.n17 vbp_bias.t16 24.0965
R4911 vbp_bias.n4 vbp_bias.t20 23.1627
R4912 vbp_bias.n18 vbp_bias.t18 23.1573
R4913 vbp_bias.n12 vbp_bias.t12 23.1403
R4914 vbp_bias.n3 vbp_bias.t3 16.8291
R4915 vbp_bias.n21 vbp_bias.t0 15.8765
R4916 vbp_bias.n21 vbp_bias.n20 14.7155
R4917 vbp_bias.n13 vbp_bias.t15 14.6957
R4918 vbp_bias.n5 vbp_bias.t27 14.652
R4919 vbp_bias.n24 vbp_bias.n23 14.2205
R4920 vbp_bias.n2 vbp_bias.t6 13.9381
R4921 vbp_bias.n0 vbp_bias.t8 13.9381
R4922 vbp_bias.n20 vbp_bias.t17 13.887
R4923 vbp_bias.n1 vbp_bias.t7 13.8783
R4924 vbp_bias.n25 vbp_bias.t5 13.8783
R4925 vbp_bias.n16 vbp_bias.t11 13.867
R4926 vbp_bias.n3 vbp_bias.t2 13.8065
R4927 vbp_bias.n8 vbp_bias.t23 13.7957
R4928 vbp_bias.n9 vbp_bias.t21 13.7957
R4929 vbp_bias.n6 vbp_bias.t25 13.7481
R4930 vbp_bias.n11 vbp_bias.t19 13.7481
R4931 vbp_bias.n14 vbp_bias.t13 13.7311
R4932 vbp_bias vbp_bias.n25 12.047
R4933 vbp_bias.n2 vbp_bias.n1 11.8805
R4934 vbp_bias.n1 vbp_bias.n0 11.7005
R4935 vbp_bias.n23 vbp_bias.t1 9.26915
R4936 vbp_bias.n24 vbp_bias.n2 7.2005
R4937 vbp_bias vbp_bias.t4 4.72664
R4938 vbp_bias.n23 vbp_bias.n22 4.6355
R4939 vbp_bias.n25 vbp_bias.n24 4.5005
R4940 vbp_bias.n9 vbp_bias.n8 3.0605
R4941 vbp_bias.n17 vbp_bias.n16 2.7905
R4942 vbp_bias.n22 vbp_bias.n3 2.7905
R4943 vbp_bias.n19 vbp_bias.n18 2.2505
R4944 vbp_bias.n10 vbp_bias.n4 2.2505
R4945 vbp_bias.n15 vbp_bias.n12 2.2505
R4946 vbp_bias.n11 vbp_bias.n10 1.9805
R4947 vbp_bias.n8 vbp_bias.n7 1.9805
R4948 vbp_bias.n6 vbp_bias.n5 1.9805
R4949 vbp_bias.n14 vbp_bias.n13 1.9805
R4950 vbp_bias.n16 vbp_bias.n15 1.8905
R4951 vbp_bias.n20 vbp_bias.n19 1.8905
R4952 vbp_bias.n18 vbp_bias.n17 1.8005
R4953 vbp_bias.n15 vbp_bias.n14 0.9005
R4954 vbp_bias.n19 vbp_bias.n11 0.9005
R4955 vbp_bias.n22 vbp_bias.n21 0.9005
R4956 vbp_bias.n10 vbp_bias.n9 0.9005
R4957 vbp_bias.n7 vbp_bias.n6 0.9005
R4958 vbn_sink.n28 vbn_sink.n27 47.3855
R4959 vbn_sink.n24 vbn_sink.n23 46.8905
R4960 vbn_sink.n0 vbn_sink.t21 24.8377
R4961 vbn_sink.n4 vbn_sink.t27 24.8242
R4962 vbn_sink.n0 vbn_sink.t22 22.0027
R4963 vbn_sink.n2 vbn_sink.t24 22.0027
R4964 vbn_sink.n4 vbn_sink.t28 21.9892
R4965 vbn_sink.n6 vbn_sink.t30 21.9892
R4966 vbn_sink.n1 vbn_sink.t23 21.9577
R4967 vbn_sink.n3 vbn_sink.t25 21.9577
R4968 vbn_sink.n5 vbn_sink.t29 21.9442
R4969 vbn_sink.n7 vbn_sink.t31 21.9442
R4970 vbn_sink.n26 vbn_sink.t19 20.1359
R4971 vbn_sink.n24 vbn_sink.t17 20.0583
R4972 vbn_sink.n28 vbn_sink.t32 17.4892
R4973 vbn_sink.n12 vbn_sink.t5 16.863
R4974 vbn_sink.n8 vbn_sink.t16 16.6468
R4975 vbn_sink.n25 vbn_sink.t18 15.5285
R4976 vbn_sink.n27 vbn_sink.t20 15.5033
R4977 vbn_sink.n15 vbn_sink.t3 13.938
R4978 vbn_sink.n23 vbn_sink.t10 13.9355
R4979 vbn_sink.n22 vbn_sink.t6 13.8379
R4980 vbn_sink.n20 vbn_sink.t11 13.8379
R4981 vbn_sink.n8 vbn_sink.t8 13.8042
R4982 vbn_sink.n10 vbn_sink.t13 13.8042
R4983 vbn_sink.n13 vbn_sink.t1 13.803
R4984 vbn_sink.n21 vbn_sink.t7 13.8005
R4985 vbn_sink.n19 vbn_sink.t12 13.8005
R4986 vbn_sink.n9 vbn_sink.t9 13.7668
R4987 vbn_sink.n11 vbn_sink.t14 13.7668
R4988 vbn_sink.n12 vbn_sink.t0 13.7373
R4989 vbn_sink.n14 vbn_sink.t2 13.7373
R4990 vbn_sink vbn_sink.t26 12.8857
R4991 vbn_sink.n16 vbn_sink.n15 9.6755
R4992 vbn_sink.n18 vbn_sink.n17 9.6755
R4993 vbn_sink.n18 vbn_sink.t15 9.33792
R4994 vbn_sink.n16 vbn_sink.t4 9.30417
R4995 vbn_sink vbn_sink.n30 9.2975
R4996 vbn_sink.n19 vbn_sink.n18 7.3805
R4997 vbn_sink.n30 vbn_sink.n29 4.8605
R4998 vbn_sink.n17 vbn_sink.n16 4.6355
R4999 vbn_sink.n29 vbn_sink.n28 4.5005
R5000 vbn_sink.n14 vbn_sink.n13 3.0605
R5001 vbn_sink.n11 vbn_sink.n10 3.0605
R5002 vbn_sink.n9 vbn_sink.n8 3.0605
R5003 vbn_sink.n20 vbn_sink.n19 3.0605
R5004 vbn_sink.n22 vbn_sink.n21 3.0605
R5005 vbn_sink.n13 vbn_sink.n12 2.8805
R5006 vbn_sink.n10 vbn_sink.n9 2.8805
R5007 vbn_sink.n21 vbn_sink.n20 2.8805
R5008 vbn_sink.n29 vbn_sink.n7 2.8805
R5009 vbn_sink.n6 vbn_sink.n5 2.8805
R5010 vbn_sink.n2 vbn_sink.n1 2.8805
R5011 vbn_sink.n15 vbn_sink.n14 2.7905
R5012 vbn_sink.n17 vbn_sink.n11 2.7905
R5013 vbn_sink.n23 vbn_sink.n22 2.7905
R5014 vbn_sink.n7 vbn_sink.n6 2.7005
R5015 vbn_sink.n5 vbn_sink.n4 2.7005
R5016 vbn_sink.n30 vbn_sink.n3 2.7005
R5017 vbn_sink.n3 vbn_sink.n2 2.7005
R5018 vbn_sink.n1 vbn_sink.n0 2.7005
R5019 vbn_sink.n26 vbn_sink.n25 1.8005
R5020 vbn_sink.n27 vbn_sink.n26 1.0805
R5021 vbn_sink.n25 vbn_sink.n24 0.9005
R5022 b3_b b3_b.t2 413.057
R5023 b3_b.n0 b3_b.t1 29.9251
R5024 b3_b.n0 b3_b.t0 18.2995
R5025 b3_b b3_b.n0 11.9367
R5026 b1_b.n1 b1_b.t2 552.784
R5027 b1_b.n2 b1_b.t3 552.491
R5028 b1_b b1_b.t4 543.413
R5029 b1_b.n0 b1_b.t0 19.0513
R5030 b1_b.n0 b1_b.t1 17.9371
R5031 b1_b b1_b.n2 9.91021
R5032 b1_b.n1 b1_b.n0 7.6505
R5033 b1_b.n2 b1_b.n1 0.7205
R5034 b6_b b6_b.t2 70.8681
R5035 b6_b.n0 b6_b.t1 33.2506
R5036 b6_b.n0 b6_b.t0 26.6113
R5037 b6_b b6_b.n0 9.06575
R5038 b4_b b4_b.t2 217.519
R5039 b4_b.n0 b4_b.t0 38.4035
R5040 b4_b.n0 b4_b.t1 20.5606
R5041 b4_b b4_b.n0 19.2897
R5042 b0_b.n1 b0_b.t2 552.495
R5043 b0_b.n3 b0_b.t4 552.482
R5044 b0_b.n2 b0_b.t3 552.424
R5045 b0_b.n4 b0_b.t5 547.922
R5046 b0_b.n5 b0_b.t6 547.922
R5047 b0_b b0_b.t7 543.413
R5048 b0_b.n0 b0_b.t1 21.7749
R5049 b0_b.n0 b0_b.t0 18.3369
R5050 b0_b b0_b.n5 14.4612
R5051 b0_b.n5 b0_b.n4 10.0805
R5052 b0_b.n1 b0_b.n0 5.8055
R5053 b0_b.n4 b0_b.n3 5.4005
R5054 b0_b.n3 b0_b.n2 1.0805
R5055 b0_b.n2 b0_b.n1 1.0805
R5056 rbit0top.n1 rbit0top.t6 47.8149
R5057 rbit0top.n1 rbit0top.t7 27.35
R5058 rbit0top.n2 rbit0top.n1 24.7955
R5059 rbit0top.n0 rbit0top.t9 14.9729
R5060 rbit0top.n3 rbit0top.t0 13.6904
R5061 rbit0top.n0 rbit0top.t8 13.6898
R5062 rbit0top.n5 rbit0top.t4 13.6634
R5063 rbit0top.n7 rbit0top.t3 13.6544
R5064 rbit0top.n4 rbit0top.t1 13.6145
R5065 rbit0top rbit0top.n7 10.3573
R5066 rbit0top.n2 rbit0top.t2 9.11555
R5067 rbit0top.n3 rbit0top.n2 5.7605
R5068 rbit0top rbit0top.t5 4.60718
R5069 rbit0top.n6 rbit0top.n0 2.93954
R5070 rbit0top.n5 rbit0top.n4 1.2605
R5071 rbit0top.n4 rbit0top.n3 1.0805
R5072 rbit0top.n6 rbit0top.n5 0.6755
R5073 rbit0top.n7 rbit0top.n6 0.1355
R5074 rbit1top.n2 rbit1top.n1 31.5783
R5075 rbit1top.n1 rbit1top.t7 22.274
R5076 rbit1top.n0 rbit1top.t9 14.8598
R5077 rbit1top.n7 rbit1top.t4 13.8254
R5078 rbit1top.n9 rbit1top.t2 13.7984
R5079 rbit1top.n10 rbit1top.t1 13.7894
R5080 rbit1top.n2 rbit1top.t13 13.7888
R5081 rbit1top.n0 rbit1top.t8 13.7579
R5082 rbit1top.n8 rbit1top.t3 13.7495
R5083 rbit1top.n3 rbit1top.t10 13.6949
R5084 rbit1top.n5 rbit1top.t12 13.6724
R5085 rbit1top.n6 rbit1top.t5 13.6155
R5086 rbit1top.n4 rbit1top.t11 13.6152
R5087 rbit1top.n11 rbit1top.n0 10.3055
R5088 rbit1top.n1 rbit1top.t6 10.142
R5089 rbit1top rbit1top.n11 9.00729
R5090 rbit1top rbit1top.t0 4.60718
R5091 rbit1top.n3 rbit1top.n2 1.5305
R5092 rbit1top.n5 rbit1top.n4 1.2605
R5093 rbit1top.n4 rbit1top.n3 1.2605
R5094 rbit1top.n11 rbit1top.n10 1.2155
R5095 rbit1top.n7 rbit1top.n6 1.1705
R5096 rbit1top.n6 rbit1top.n5 1.0805
R5097 rbit1top.n9 rbit1top.n8 1.0805
R5098 rbit1top.n10 rbit1top.n9 0.9005
R5099 rbit1top.n8 rbit1top.n7 0.9005
R5100 rbit2top.n1 rbit2top.n0 34.9521
R5101 rbit2top.n0 rbit2top.t2 25.739
R5102 rbit2top.n4 rbit2top.t3 15.0003
R5103 rbit2top.n5 rbit2top.t4 13.9426
R5104 rbit2top.n4 rbit2top.t1 13.9336
R5105 rbit2top.n6 rbit2top.t8 13.8011
R5106 rbit2top.n3 rbit2top.t6 13.7502
R5107 rbit2top.n2 rbit2top.t7 13.6949
R5108 rbit2top.n7 rbit2top.n6 11.9255
R5109 rbit2top.n6 rbit2top.n5 10.6655
R5110 rbit2top.n0 rbit2top.t0 10.106
R5111 rbit2top rbit2top.n7 9.20075
R5112 rbit2top.n1 rbit2top.t9 9.11557
R5113 rbit2top.n2 rbit2top.n1 5.5805
R5114 rbit2top rbit2top.t5 4.60718
R5115 rbit2top.n3 rbit2top.n2 1.1705
R5116 rbit2top.n7 rbit2top.n3 1.0805
R5117 rbit2top.n5 rbit2top.n4 0.9005
R5118 b2_b.n1 b2_b.t2 291.709
R5119 b2_b.n2 b2_b.t3 291.709
R5120 b2_b b2_b.t4 282.7
R5121 b2_b.n0 b2_b.t1 29.7878
R5122 b2_b.n1 b2_b.n0 29.7455
R5123 b2_b b2_b.n2 9.96125
R5124 b2_b.n0 b2_b.t0 9.37191
R5125 b2_b.n2 b2_b.n1 1.0805
R5126 rbit6top.n2 rbit6top.t2 20.1082
R5127 rbit6top rbit6top.n3 16.4243
R5128 rbit6top.n2 rbit6top.t1 16.2905
R5129 rbit6top.n3 rbit6top.n0 11.2267
R5130 rbit6top.n3 rbit6top.t4 10.197
R5131 rbit6top.n1 rbit6top.n2 9.5405
R5132 rbit6top.n1 rbit6top.t3 9.02203
R5133 rbit6top.n1 rbit6top.n0 4.4644
R5134 rbit6top rbit6top.t0 5.06817
R5135 rbit6top.n0 rbit6top.t5 17.5032
R5136 rbit5top.n2 rbit5top.n1 30.1505
R5137 rbit5top rbit5top.t5 29.2375
R5138 rbit5top.n1 rbit5top.t1 28.961
R5139 rbit5top rbit5top.n2 16.7383
R5140 rbit5top.n2 rbit5top.n0 12.9155
R5141 rbit5top.n0 rbit5top.t0 11.3205
R5142 rbit5top.n0 rbit5top.t2 9.9581
R5143 rbit5top.n1 rbit5top.t3 5.59703
R5144 rbit5top rbit5top.t4 4.78433
R5145 b5_b b5_b.t2 119.752
R5146 b5_b b5_b.n0 34.8211
R5147 b5_b.n0 b5_b.t1 31.9875
R5148 b5_b.n0 b5_b.t0 9.33465
R5149 rbit3top.n3 rbit3top.n0 34.6597
R5150 rbit3top.n0 rbit3top.t1 20.9348
R5151 rbit3top.n1 rbit3top.t3 18.735
R5152 rbit3top.n0 rbit3top.t2 15.7332
R5153 rbit3top.n5 rbit3top.n4 15.2105
R5154 rbit3top.n1 rbit3top.t4 13.9653
R5155 rbit3top.n4 rbit3top.t6 13.8076
R5156 rbit3top.n2 rbit3top.t5 13.7986
R5157 rbit3top rbit3top.n5 12.5895
R5158 rbit3top.n5 rbit3top.t7 9.43613
R5159 rbit3top rbit3top.t0 4.64242
R5160 rbit3top.n2 rbit3top.n1 1.0805
R5161 rbit3top.n3 rbit3top.n2 0.9905
R5162 rbit3top.n4 rbit3top.n3 0.1355
R5163 rbit4top.n2 rbit4top.t1 31.67
R5164 rbit4top.n3 rbit4top.n2 20.2505
R5165 rbit4top.n0 rbit4top.t2 17.61
R5166 rbit4top.n1 rbit4top.n0 17.0555
R5167 rbit4top.n0 rbit4top.t3 14.5188
R5168 rbit4top.n1 rbit4top.t5 13.9981
R5169 rbit4top.n3 rbit4top.n1 12.2405
R5170 rbit4top.n2 rbit4top.t4 10.097
R5171 rbit4top rbit4top.t0 4.64242
R5172 rbit4top rbit4top.n3 4.53446
R5173 vbn_fold.n13 vbn_fold.n12 129.555
R5174 vbn_fold.n1 vbn_fold.n0 53.9105
R5175 vbn_fold.n1 vbn_fold.t14 25.9901
R5176 vbn_fold.n0 vbn_fold.t8 17.6066
R5177 vbn_fold vbn_fold.t15 16.9451
R5178 vbn_fold.n2 vbn_fold.t0 16.6249
R5179 vbn_fold.n0 vbn_fold.t9 16.0915
R5180 vbn_fold.n6 vbn_fold.t5 13.9378
R5181 vbn_fold.n12 vbn_fold.t10 13.8799
R5182 vbn_fold.n11 vbn_fold.t11 13.8028
R5183 vbn_fold.n9 vbn_fold.t7 13.8028
R5184 vbn_fold.n4 vbn_fold.t3 13.8028
R5185 vbn_fold.n2 vbn_fold.t1 13.8028
R5186 vbn_fold.n10 vbn_fold.t6 13.7449
R5187 vbn_fold.n8 vbn_fold.t12 13.7449
R5188 vbn_fold.n5 vbn_fold.t4 13.7449
R5189 vbn_fold.n3 vbn_fold.t2 13.7449
R5190 vbn_fold.n7 vbn_fold.n6 9.6755
R5191 vbn_fold.n7 vbn_fold.t13 9.30284
R5192 vbn_fold vbn_fold.n13 9.0455
R5193 vbn_fold.n8 vbn_fold.n7 7.3805
R5194 vbn_fold.n3 vbn_fold.n2 3.0605
R5195 vbn_fold.n5 vbn_fold.n4 3.0605
R5196 vbn_fold.n9 vbn_fold.n8 3.0605
R5197 vbn_fold.n11 vbn_fold.n10 3.0605
R5198 vbn_fold.n4 vbn_fold.n3 2.8805
R5199 vbn_fold.n10 vbn_fold.n9 2.8805
R5200 vbn_fold.n6 vbn_fold.n5 2.7905
R5201 vbn_fold.n12 vbn_fold.n11 2.7905
R5202 vbn_fold.n13 vbn_fold.n1 2.3405
R5203 vbn_i.n1 vbn_i.n0 128.25
R5204 vbn_i.n6 vbn_i.n5 61.5605
R5205 vbn_i.n0 vbn_i.t3 25.027
R5206 vbn_i.n4 vbn_i.t10 18.7019
R5207 vbn_i.n0 vbn_i.t8 18.4407
R5208 vbn_i.n2 vbn_i.t6 18.0635
R5209 vbn_i.n3 vbn_i.t9 16.3752
R5210 vbn_i.n9 vbn_i.n8 16.2005
R5211 vbn_i vbn_i.n9 14.8944
R5212 vbn_i.n8 vbn_i.t1 13.8164
R5213 vbn_i.n9 vbn_i.t2 13.8164
R5214 vbn_i.n7 vbn_i.t5 13.7791
R5215 vbn_i.n7 vbn_i.n6 13.1405
R5216 vbn_i.n2 vbn_i.n1 11.0705
R5217 vbn_i.n5 vbn_i.t11 10.307
R5218 vbn_i.n3 vbn_i.n2 9.6755
R5219 vbn_i.n6 vbn_i.t4 9.31644
R5220 vbn_i.n4 vbn_i.n3 8.8205
R5221 vbn_i.n5 vbn_i.n4 7.0205
R5222 vbn_i.n1 vbn_i.t7 5.16057
R5223 vbn_i vbn_i.t0 4.72757
R5224 vbn_i.n8 vbn_i.n7 2.8805
R5225 vbp_i.n0 vbp_i.t11 313.841
R5226 vbp_i.n0 vbp_i.t12 312.521
R5227 vbp_i.n7 vbp_i.t19 31.7827
R5228 vbp_i.n2 vbp_i.t14 31.6027
R5229 vbp_i.n4 vbp_i.t16 31.6027
R5230 vbp_i.n6 vbp_i.t18 31.6027
R5231 vbp_i.n1 vbp_i.t13 31.5532
R5232 vbp_i.n3 vbp_i.t15 31.5532
R5233 vbp_i.n5 vbp_i.t17 31.5532
R5234 vbp_i.n12 vbp_i.t23 26.033
R5235 vbp_i.n16 vbp_i.t29 26.0263
R5236 vbp_i.n23 vbp_i.t40 26.0198
R5237 vbp_i.n27 vbp_i.t46 26.0198
R5238 vbp_i.n32 vbp_i.t56 25.9418
R5239 vbp_i.n20 vbp_i.t35 25.8215
R5240 vbp_i.n54 vbp_i.n11 23.6705
R5241 vbp_i.n12 vbp_i.t24 23.153
R5242 vbp_i.n13 vbp_i.t25 23.153
R5243 vbp_i.n14 vbp_i.t26 23.153
R5244 vbp_i.n15 vbp_i.t27 23.153
R5245 vbp_i.n16 vbp_i.t30 23.1463
R5246 vbp_i.n17 vbp_i.t31 23.1463
R5247 vbp_i.n18 vbp_i.t32 23.1463
R5248 vbp_i.n19 vbp_i.t33 23.1463
R5249 vbp_i.n52 vbp_i.t34 23.1463
R5250 vbp_i.n23 vbp_i.t41 23.1398
R5251 vbp_i.n24 vbp_i.t42 23.1398
R5252 vbp_i.n25 vbp_i.t43 23.1398
R5253 vbp_i.n26 vbp_i.t44 23.1398
R5254 vbp_i.n48 vbp_i.t45 23.1398
R5255 vbp_i.n28 vbp_i.t48 23.1398
R5256 vbp_i.n30 vbp_i.t50 23.1398
R5257 vbp_i.n27 vbp_i.t47 23.1398
R5258 vbp_i.n29 vbp_i.t49 23.1398
R5259 vbp_i.n31 vbp_i.t51 23.1398
R5260 vbp_i.n20 vbp_i.t36 23.1215
R5261 vbp_i.n21 vbp_i.t37 23.1215
R5262 vbp_i.n22 vbp_i.t38 23.1215
R5263 vbp_i.n50 vbp_i.t39 23.1215
R5264 vbp_i.n37 vbp_i.t4 23.0618
R5265 vbp_i.n35 vbp_i.t2 23.0618
R5266 vbp_i.n34 vbp_i.t55 23.0618
R5267 vbp_i.n32 vbp_i.t0 23.0618
R5268 vbp_i.n45 vbp_i.t52 23.0618
R5269 vbp_i.n42 vbp_i.t8 23.0618
R5270 vbp_i.n41 vbp_i.t6 23.0618
R5271 vbp_i.n40 vbp_i.t53 23.0618
R5272 vbp_i.n39 vbp_i.t54 23.0618
R5273 vbp_i.n10 vbp_i.n9 21.3755
R5274 vbp_i.n11 vbp_i.n10 21.3305
R5275 vbp_i.n49 vbp_i.n48 18.0005
R5276 vbp_i.n1 vbp_i.n0 17.0105
R5277 vbp_i.n43 vbp_i.t7 16.6064
R5278 vbp_i.n38 vbp_i.t5 15.9314
R5279 vbp_i.n36 vbp_i.t3 15.8941
R5280 vbp_i.n33 vbp_i.t1 15.8941
R5281 vbp_i.n11 vbp_i.t22 14.9342
R5282 vbp_i vbp_i.t28 14.0765
R5283 vbp_i.n10 vbp_i.t10 14.0571
R5284 vbp_i.n9 vbp_i.t21 14.0084
R5285 vbp_i.n43 vbp_i.t9 13.9141
R5286 vbp_i.n8 vbp_i.t20 13.8092
R5287 vbp_i.n46 vbp_i.n45 13.7705
R5288 vbp_i vbp_i.n54 9.077
R5289 vbp_i.n53 vbp_i.n52 5.5805
R5290 vbp_i.n51 vbp_i.n50 5.4005
R5291 vbp_i.n7 vbp_i.n6 5.2205
R5292 vbp_i.n39 vbp_i.n38 4.8605
R5293 vbp_i.n46 vbp_i.n31 4.4105
R5294 vbp_i.n40 vbp_i.n39 2.8805
R5295 vbp_i.n42 vbp_i.n41 2.8805
R5296 vbp_i.n35 vbp_i.n34 2.8805
R5297 vbp_i.n25 vbp_i.n24 2.8805
R5298 vbp_i.n21 vbp_i.n20 2.8805
R5299 vbp_i.n18 vbp_i.n17 2.8805
R5300 vbp_i.n14 vbp_i.n13 2.8805
R5301 vbp_i.n31 vbp_i.n30 2.8805
R5302 vbp_i.n29 vbp_i.n28 2.8805
R5303 vbp_i.n41 vbp_i.n40 2.7005
R5304 vbp_i.n47 vbp_i.n26 2.7005
R5305 vbp_i.n26 vbp_i.n25 2.7005
R5306 vbp_i.n24 vbp_i.n23 2.7005
R5307 vbp_i.n22 vbp_i.n21 2.7005
R5308 vbp_i.n51 vbp_i.n19 2.7005
R5309 vbp_i.n19 vbp_i.n18 2.7005
R5310 vbp_i.n17 vbp_i.n16 2.7005
R5311 vbp_i.n53 vbp_i.n15 2.7005
R5312 vbp_i.n15 vbp_i.n14 2.7005
R5313 vbp_i.n13 vbp_i.n12 2.7005
R5314 vbp_i.n30 vbp_i.n29 2.7005
R5315 vbp_i.n28 vbp_i.n27 2.7005
R5316 vbp_i.n8 vbp_i.n7 2.2055
R5317 vbp_i.n6 vbp_i.n5 1.9805
R5318 vbp_i.n4 vbp_i.n3 1.9805
R5319 vbp_i.n2 vbp_i.n1 1.9805
R5320 vbp_i.n44 vbp_i.n43 1.8905
R5321 vbp_i.n45 vbp_i.n44 1.8005
R5322 vbp_i.n34 vbp_i.n33 1.8005
R5323 vbp_i.n37 vbp_i.n36 1.8005
R5324 vbp_i.n49 vbp_i.n22 1.8005
R5325 vbp_i.n5 vbp_i.n4 1.8005
R5326 vbp_i.n3 vbp_i.n2 1.8005
R5327 vbp_i.n9 vbp_i.n8 1.6655
R5328 vbp_i.n38 vbp_i.n37 1.0805
R5329 vbp_i.n50 vbp_i.n49 1.0805
R5330 vbp_i.n47 vbp_i.n46 0.9905
R5331 vbp_i.n44 vbp_i.n42 0.9005
R5332 vbp_i.n33 vbp_i.n32 0.9005
R5333 vbp_i.n36 vbp_i.n35 0.9005
R5334 vbp_i.n48 vbp_i.n47 0.1805
R5335 vbp_i.n52 vbp_i.n51 0.1805
R5336 vbp_i.n54 vbp_i.n53 0.1805
Cconserve0 avdd aux_gate 1.13113e-14
Cconserve1 bgsu1 aux_gate 1.1782e-16
Cconserve2 iref_gate aux_gate 9.00756e-15
Cconserve3 pm2 aux_gate 1.75448e-15
Cconserve4 psrg_m3_feed aux_gate 2.8976e-16
Cconserve5 aux_gate su_state 6.4858e-16
Cconserve6 vbn aux_gate 1.3675e-16
Cconserve7 aux_gate vbn_fold 9.8337e-15
Cconserve8 aux_gate vbn_i 5.6758e-16
Cconserve9 aux_gate vbp_bias 1.29161e-15
Cconserve10 aux_gate vgn1 1.1923e-16
Cconserve11 vgn2 aux_gate 8.2162e-16
Cconserve12 vref aux_gate 4.9479e-16
Cconserve13 vsu aux_gate 1.8683e-16
Cconserve14 xf1 aux_gate 4.7934e-16
Cconserve15 xf2 aux_gate 2.5748e-15
Cconserve16 y1 aux_gate 3.7334e-16
Cconserve17 auxsu2 auxsu1 2.0281e-16
Cconserve18 auxsu1 avdd 1.24504e-15
Cconserve19 auxsu1 bgsu1 4.12461e-15
Cconserve20 auxsu1 bgsu2 2.998e-16
Cconserve21 psrg_m3_feed auxsu1 4.0763e-16
Cconserve22 psrg_vnc auxsu1 2.1772e-16
Cconserve23 auxsu1 rb_mid 1.5762e-16
Cconserve24 auxsu1 vbn 1.29803e-14
Cconserve25 auxsu1 vcasp 4.5799e-16
Cconserve26 auxsu1 vgn1 1.1695e-16
Cconserve27 vgn2 auxsu1 1.2252e-16
Cconserve28 vnx_bias auxsu1 8.71994e-15
Cconserve29 auxsu1 vsu2 3.4171e-16
Cconserve30 auxsu1 vsua 1.1093e-16
Cconserve31 auxsu2 vsu2 3.506e-16
Cconserve32 avdd avss 3.1763216941226e-14
Cconserve33 avdd.n0 avss 4.3123948461118e-18
Cconserve34 avdd.n1 avss 1.2234545240921e-18
Cconserve35 avdd.n2 avss 3.5250331967674e-18
Cconserve36 avdd.n3 avss 3.5250331967674e-18
Cconserve37 avdd.n4 avss 3.5250331967674e-18
Cconserve38 avdd.n5 avss 3.5250331967674e-18
Cconserve39 avdd.n6 avss 3.5250331967674e-18
Cconserve40 avdd.n7 avss 3.1258070940566e-18
Cconserve41 avdd.n8 avss 3.7300897779406e-18
Cconserve42 avdd.n9 avss 3.1255696815412e-18
Cconserve43 avdd.n10 avss 3.5235748056013e-18
Cconserve44 avdd.n11 avss 3.1267228280446e-18
Cconserve45 avdd.n12 avss 3.1255696815412e-18
Cconserve46 avdd.n13 avss 3.5235748056013e-18
Cconserve47 avdd.n14 avss 3.5235748056013e-18
Cconserve48 avdd.n15 avss 3.5235748056013e-18
Cconserve49 avdd.n16 avss 3.1233312206815e-18
Cconserve50 avdd.n17 avss 5.0808652424437e-18
Cconserve51 avdd.n18 avss 3.1232633885343e-18
Cconserve52 avdd.n19 avss 5.5950668347637e-18
Cconserve53 avdd.n20 avss 5.5936423596712e-18
Cconserve54 avdd.n21 avss 3.1232633885343e-18
Cconserve55 avdd.n22 avss 3.1258070940566e-18
Cconserve56 avdd.n23 avss 3.1258070940566e-18
Cconserve57 avdd.n24 avss 1.1265766513725e-17
Cconserve58 avdd.n25 avss 1.1126744527911e-17
Cconserve59 avdd.n26 avss 6.7680881573665e-18
Cconserve60 avdd.n27 avss 5.8352943842923e-18
Cconserve61 avdd.n28 avss 5.8352943842923e-18
Cconserve62 avdd.n29 avss 5.8352943842923e-18
Cconserve63 avdd.n30 avss 5.8352943842923e-18
Cconserve64 avdd.n31 avss 5.8352943842923e-18
Cconserve65 avdd.n32 avss 5.8352943842923e-18
Cconserve66 avdd.n33 avss 5.8352943842923e-18
Cconserve67 avdd.n34 avss 5.8352943842923e-18
Cconserve68 avdd.n35 avss 6.7680881573665e-18
Cconserve69 avdd.n36 avss 5.8352943842923e-18
Cconserve70 avdd.n37 avss 5.8352943842923e-18
Cconserve71 avdd.n38 avss 5.8352943842923e-18
Cconserve72 avdd.n39 avss 5.8352943842923e-18
Cconserve73 avdd.n40 avss 5.8352943842923e-18
Cconserve74 avdd.n41 avss 5.8352943842923e-18
Cconserve75 avdd.n42 avss 1.1900302335288e-17
Cconserve76 avdd.n43 avss 8.6932662448846e-18
Cconserve77 avdd.n44 avss 4.3012364578872e-18
Cconserve78 avdd.n45 avss 4.737329332635e-18
Cconserve79 avdd.n46 avss 4.737329332635e-18
Cconserve80 avdd.n47 avss 4.737329332635e-18
Cconserve81 avdd.n48 avss 4.737329332635e-18
Cconserve82 avdd.n49 avss 4.737329332635e-18
Cconserve83 avdd.n50 avss 4.737329332635e-18
Cconserve84 avdd.n51 avss 4.737329332635e-18
Cconserve85 avdd.n52 avss 4.737329332635e-18
Cconserve86 avdd.n53 avss 4.737329332635e-18
Cconserve87 avdd.n54 avss 4.7394321292001e-18
Cconserve88 avdd.n55 avss 4.737329332635e-18
Cconserve89 avdd.n56 avss 4.737329332635e-18
Cconserve90 avdd.n57 avss 4.737329332635e-18
Cconserve91 avdd.n58 avss 4.737329332635e-18
Cconserve92 avdd.n59 avss 4.737329332635e-18
Cconserve93 avdd.n60 avss 4.737329332635e-18
Cconserve94 avdd.n61 avss 4.737329332635e-18
Cconserve95 avdd.n62 avss 4.737329332635e-18
Cconserve96 avdd.n63 avss 4.737329332635e-18
Cconserve97 avdd.n64 avss 5.4771745628222e-18
Cconserve98 avdd.n65 avss 4.737329332635e-18
Cconserve99 avdd.n66 avss 4.737329332635e-18
Cconserve100 avdd.n67 avss 4.737329332635e-18
Cconserve101 avdd.n68 avss 4.737329332635e-18
Cconserve102 avdd.n69 avss 4.737329332635e-18
Cconserve103 avdd.n70 avss 4.7514384192655e-18
Cconserve104 avdd.n71 avss 4.737329332635e-18
Cconserve105 avdd.n72 avss 4.737329332635e-18
Cconserve106 avdd.n73 avss 4.7506244334983e-18
Cconserve107 avdd.n74 avss 4.737329332635e-18
Cconserve108 avdd.n75 avss 4.737329332635e-18
Cconserve109 avdd.n76 avss 4.737329332635e-18
Cconserve110 avdd.n77 avss 4.737329332635e-18
Cconserve111 avdd.n78 avss 6.9164370634286e-18
Cconserve112 avdd.n79 avss 8.3233097137173e-18
Cconserve113 avdd.n80 avss 6.9164370634286e-18
Cconserve114 avdd.n81 avss 4.340138194342e-18
Cconserve115 avdd.n82 avss 3.1146147897583e-18
Cconserve116 avdd.n83 avss 5.3460889382383e-18
Cconserve117 avdd.n84 avss 3.7273764920502e-18
Cconserve118 avdd.n85 avss 4.0871921172017e-18
Cconserve119 avdd.n86 avss 2.876015211764e-18
Cconserve120 avdd.n87 avss 1.3274852967406e-17
Cconserve121 avdd.n88 avss 1.0591209725277e-17
Cconserve122 avdd.n89 avss 1.0591209725277e-17
Cconserve123 avdd.n90 avss 1.0591209725277e-17
Cconserve124 avdd.n91 avss 1.0591209725277e-17
Cconserve125 avdd.n92 avss 1.0591209725277e-17
Cconserve126 avdd.n93 avss 1.0591209725277e-17
Cconserve127 avdd.n94 avss 1.0618986989581e-17
Cconserve128 avdd.n95 avss 1.0591209725277e-17
Cconserve129 avdd.n96 avss 1.0591209725277e-17
Cconserve130 avdd.n97 avss 2.0541473491075e-17
Cconserve131 avdd.n98 avss 1.0591209725277e-17
Cconserve132 avdd.n99 avss 1.3293506807903e-17
Cconserve133 avdd.n100 avss 1.0591209725277e-17
Cconserve134 avdd.n101 avss 1.0591209725277e-17
Cconserve135 avdd.n102 avss 1.0591209725277e-17
Cconserve136 avdd.n103 avss 1.0591209725277e-17
Cconserve137 avdd.n104 avss 1.0591209725277e-17
Cconserve138 avdd.n105 avss 1.0591209725277e-17
Cconserve139 avdd.n106 avss 1.0591209725277e-17
Cconserve140 avdd.n107 avss 3.9704529917637e-18
Cconserve141 avdd.n108 avss 3.3419542313071e-18
Cconserve142 avdd.n109 avss 9.1888139967076e-18
Cconserve143 avdd.n110 avss 9.1888139967076e-18
Cconserve144 avdd.n111 avss 9.1888139967076e-18
Cconserve145 avdd.n112 avss 9.1888139967076e-18
Cconserve146 avdd.n113 avss 9.1888139967076e-18
Cconserve147 avdd.n114 avss 9.1888139967076e-18
Cconserve148 avdd.n115 avss 9.1888139967076e-18
Cconserve149 avdd.n116 avss 9.1888139967076e-18
Cconserve150 avdd.n117 avss 9.1888139967076e-18
Cconserve151 avdd.n118 avss 9.1888139967076e-18
Cconserve152 avdd.n119 avss 9.1888139967076e-18
Cconserve153 avdd.n120 avss 9.1888139967076e-18
Cconserve154 avdd.n121 avss 9.1888139967076e-18
Cconserve155 avdd.n122 avss 9.1888139967076e-18
Cconserve156 avdd.n123 avss 9.1888139967076e-18
Cconserve157 avdd.n124 avss 9.1888139967076e-18
Cconserve158 avdd.n125 avss 9.1888139967076e-18
Cconserve159 avdd.n126 avss 9.1888139967076e-18
Cconserve160 avdd.n127 avss 9.1888139967076e-18
Cconserve161 avdd.n128 avss 1.1683510792638e-17
Cconserve162 avdd.n129 avss 1.2534600744335e-17
Cconserve163 avdd.n130 avss 9.1715507152294e-18
Cconserve164 avdd.n131 avss 1.6765156104775e-17
Cconserve165 avdd.n132 avss 1.2495936420396e-17
Cconserve166 avdd.n133 avss 9.1715507152294e-18
Cconserve167 avdd.n134 avss 9.1715507152294e-18
Cconserve168 avdd.n135 avss 9.1715507152294e-18
Cconserve169 avdd.n136 avss 9.1715507152294e-18
Cconserve170 avdd.n137 avss 9.1715507152294e-18
Cconserve171 avdd.n138 avss 9.1715507152294e-18
Cconserve172 avdd.n139 avss 9.1715507152294e-18
Cconserve173 avdd.n140 avss 9.195122386403e-18
Cconserve174 avdd.n141 avss 1.6768038971034e-17
Cconserve175 avdd.n142 avss 1.7276101754027e-17
Cconserve176 avdd.n143 avss 1.2534600744335e-17
Cconserve177 avdd.n144 avss 9.1715507152294e-18
Cconserve178 avdd.n145 avss 9.1715507152294e-18
Cconserve179 avdd.n146 avss 9.1715507152294e-18
Cconserve180 avdd.n147 avss 9.1715507152294e-18
Cconserve181 avdd.n148 avss 9.1715507152294e-18
Cconserve182 avdd.n149 avss 9.1715507152294e-18
Cconserve183 avdd.n150 avss 9.1810811319197e-18
Cconserve184 avdd.n151 avss 1.2395103933491e-17
Cconserve185 avdd.n152 avss 9.0851325596175e-18
Cconserve186 avdd.n153 avss 9.0851325596175e-18
Cconserve187 avdd.n154 avss 9.0851325596175e-18
Cconserve188 avdd.n155 avss 9.0851325596175e-18
Cconserve189 avdd.n156 avss 1.1548355239218e-17
Cconserve190 avdd.n157 avss 1.5319788710915e-17
Cconserve191 avdd.n158 avss 9.0851325596175e-18
Cconserve192 avdd.n159 avss 9.0851325596175e-18
Cconserve193 avdd.n160 avss 9.0851325596175e-18
Cconserve194 avdd.n161 avss 9.0851325596175e-18
Cconserve195 avdd.n162 avss 9.0851325596175e-18
Cconserve196 avdd.n163 avss 9.0851325596175e-18
Cconserve197 avdd.n164 avss 9.0851325596175e-18
Cconserve198 avdd.n165 avss 1.5985561236292e-17
Cconserve199 avdd.n166 avss 9.0950360531178e-18
Cconserve200 avdd.n167 avss 1.2413520361472e-17
Cconserve201 avdd.n168 avss 9.0851325596175e-18
Cconserve202 avdd.n169 avss 9.0851325596175e-18
Cconserve203 avdd.n170 avss 9.0851325596175e-18
Cconserve204 avdd.n171 avss 9.0851325596175e-18
Cconserve205 avdd.n172 avss 9.0851325596175e-18
Cconserve206 avdd.n173 avss 9.0851325596175e-18
Cconserve207 avdd.n174 avss 9.0851325596175e-18
Cconserve208 avdd.n175 avss 9.0851325596175e-18
Cconserve209 avdd.n176 avss 9.0851325596175e-18
Cconserve210 avdd.n177 avss 9.0851325596175e-18
Cconserve211 avdd.n178 avss 3.3419542313071e-18
Cconserve212 avdd.n179 avss 3.3419542313071e-18
Cconserve213 avdd.n180 avss 6.2408967088458e-18
Cconserve214 avdd.n181 avss 5.8549657069983e-18
Cconserve215 avdd.n182 avss 5.9254093919299e-18
Cconserve216 avdd.n183 avss 1.0917109276798e-17
Cconserve217 avdd.n184 avss 1.1002645614495e-17
Cconserve218 avdd.n185 avss 1.1010208898915e-17
Cconserve219 avdd.n186 avss 8.0829464998942e-18
Cconserve220 avdd.n187 avss 8.0816237730226e-18
Cconserve221 avdd.n188 avss 2.8778805958138e-18
Cconserve222 avdd.n189 avss 6.6272007875032e-19
Cconserve223 avdd.n190 avss 3.4368853214004e-18
Cconserve224 avdd.n193 avss 1.3675435713062e-17
Cconserve225 avdd.n194 avss 2.5736194992698e-18
Cconserve226 avdd.n195 avss 2.9660623872544e-18
Cconserve227 avdd.n196 avss 8.3618722894358e-18
Cconserve228 avdd.t128 avss 1.4598495573004e-18
Cconserve229 avdd.t129 avss 1.4598495573004e-18
Cconserve230 avdd.t567 avss 8.6960134468487e-18
Cconserve231 avdd.t568 avss 8.6818026119973e-18
Cconserve232 avdd.t590 avss 8.6815651994819e-18
Cconserve233 avdd.t577 avss 8.6958099504069e-18
Cconserve234 avdd.t588 avss 8.6827861781326e-18
Cconserve235 avdd.t191 avss 1.4568310267472e-18
Cconserve236 avdd.t192 avss 1.4568310267472e-18
Cconserve237 avdd.t585 avss 8.8538927696012e-18
Cconserve238 avdd.t576 avss 8.6827861781326e-18
Cconserve239 avdd.n198 avss 6.0089107652095e-18
Cconserve240 avdd.t188 avss 1.4568310267472e-18
Cconserve241 avdd.t189 avss 1.4568310267472e-18
Cconserve242 avdd.t194 avss 1.4568310267472e-18
Cconserve243 avdd.t195 avss 1.4568310267472e-18
Cconserve244 avdd.t614 avss 1.2798535629332e-17
Cconserve245 avdd.t657 avss 1.2646354206949e-17
Cconserve246 avdd.t618 avss 1.2714864675684e-17
Cconserve247 avdd.t611 avss 4.0429655571869e-18
Cconserve248 avdd.t444 avss 7.791675259551e-18
Cconserve249 avdd.n199 avss 1.1163679132095e-17
Cconserve250 avdd.n200 avss 1.0791280643626e-17
Cconserve251 avdd.t644 avss 4.8003453974414e-18
Cconserve252 avdd.t665 avss 4.804517074498e-18
Cconserve253 avdd.n202 avss 2.4091604582329e-18
Cconserve254 avdd.t414 avss 7.791675259551e-18
Cconserve255 avdd.n203 avss 1.6528286246536e-17
Cconserve256 avdd.t466 avss 7.791675259551e-18
Cconserve257 avdd.n204 avss 1.1163679132095e-17
Cconserve258 avdd.t464 avss 7.791675259551e-18
Cconserve259 avdd.n205 avss 1.1163679132095e-17
Cconserve260 avdd.t462 avss 7.791675259551e-18
Cconserve261 avdd.n206 avss 1.1163679132095e-17
Cconserve262 avdd.t460 avss 7.791675259551e-18
Cconserve263 avdd.n207 avss 1.1163679132095e-17
Cconserve264 avdd.t458 avss 7.791675259551e-18
Cconserve265 avdd.n208 avss 1.1163679132095e-17
Cconserve266 avdd.t456 avss 7.791675259551e-18
Cconserve267 avdd.n209 avss 1.1163679132095e-17
Cconserve268 avdd.t454 avss 7.791675259551e-18
Cconserve269 avdd.n210 avss 1.1163679132095e-17
Cconserve270 avdd.t452 avss 7.791675259551e-18
Cconserve271 avdd.n211 avss 1.1163679132095e-17
Cconserve272 avdd.t450 avss 7.791675259551e-18
Cconserve273 avdd.n212 avss 1.1163679132095e-17
Cconserve274 avdd.t448 avss 7.791675259551e-18
Cconserve275 avdd.n213 avss 1.1163679132095e-17
Cconserve276 avdd.t446 avss 7.791675259551e-18
Cconserve277 avdd.n214 avss 1.1163679132095e-17
Cconserve278 avdd.n215 avss 1.0791280643626e-17
Cconserve279 avdd.n216 avss 1.0791280643626e-17
Cconserve280 avdd.n217 avss 1.0791280643626e-17
Cconserve281 avdd.n218 avss 1.0791280643626e-17
Cconserve282 avdd.n219 avss 1.0791280643626e-17
Cconserve283 avdd.n220 avss 1.0791280643626e-17
Cconserve284 avdd.n221 avss 1.0791280643626e-17
Cconserve285 avdd.n222 avss 1.0791280643626e-17
Cconserve286 avdd.n223 avss 1.0791280643626e-17
Cconserve287 avdd.n224 avss 1.0791280643626e-17
Cconserve288 avdd.t439 avss 1.6969568280549e-18
Cconserve289 avdd.t440 avss 1.6969568280549e-18
Cconserve290 avdd.t436 avss 1.6969568280549e-18
Cconserve291 avdd.t437 avss 1.6969568280549e-18
Cconserve292 avdd.n225 avss 1.4882915766474e-17
Cconserve293 avdd.t433 avss 1.6969568280549e-18
Cconserve294 avdd.t434 avss 1.6969568280549e-18
Cconserve295 avdd.n226 avss 8.8081060701993e-18
Cconserve296 avdd.t430 avss 1.6969568280549e-18
Cconserve297 avdd.t431 avss 1.6969568280549e-18
Cconserve298 avdd.n227 avss 8.8081060701993e-18
Cconserve299 avdd.t427 avss 1.6969568280549e-18
Cconserve300 avdd.t428 avss 1.6969568280549e-18
Cconserve301 avdd.n228 avss 8.8081060701993e-18
Cconserve302 avdd.t424 avss 1.6969568280549e-18
Cconserve303 avdd.t425 avss 1.6969568280549e-18
Cconserve304 avdd.n229 avss 8.8081060701993e-18
Cconserve305 avdd.t421 avss 1.6969568280549e-18
Cconserve306 avdd.t422 avss 1.6969568280549e-18
Cconserve307 avdd.n230 avss 8.8070885879904e-18
Cconserve308 avdd.t418 avss 1.6969568280549e-18
Cconserve309 avdd.t419 avss 1.6969568280549e-18
Cconserve310 avdd.n231 avss 9.5152222893326e-18
Cconserve311 avdd.t642 avss 4.2247217957756e-18
Cconserve312 avdd.n232 avss 3.6887121681108e-19
Cconserve313 avdd.t537 avss 8.662165205365e-19
Cconserve314 avdd.t538 avss 8.662165205365e-19
Cconserve315 avdd.t0 avss 1.412638382806e-18
Cconserve316 avdd.n233 avss 5.8813863283568e-19
Cconserve317 avdd.t540 avss 8.662165205365e-19
Cconserve318 avdd.t541 avss 8.662165205365e-19
Cconserve319 avdd.n234 avss 2.2992045475211e-18
Cconserve320 avdd.t561 avss 8.662165205365e-19
Cconserve321 avdd.t562 avss 8.662165205365e-19
Cconserve322 avdd.t558 avss 8.662165205365e-19
Cconserve323 avdd.t559 avss 8.662165205365e-19
Cconserve324 avdd.n235 avss 7.4062529988079e-18
Cconserve325 avdd.t555 avss 8.662165205365e-19
Cconserve326 avdd.t556 avss 8.662165205365e-19
Cconserve327 avdd.n236 avss 4.1854469825108e-18
Cconserve328 avdd.t552 avss 8.662165205365e-19
Cconserve329 avdd.t553 avss 8.662165205365e-19
Cconserve330 avdd.n237 avss 4.1854469825108e-18
Cconserve331 avdd.t549 avss 8.662165205365e-19
Cconserve332 avdd.t550 avss 8.662165205365e-19
Cconserve333 avdd.n238 avss 4.1854469825108e-18
Cconserve334 avdd.t546 avss 8.662165205365e-19
Cconserve335 avdd.t547 avss 8.662165205365e-19
Cconserve336 avdd.n239 avss 4.1850739057009e-18
Cconserve337 avdd.t543 avss 8.662165205365e-19
Cconserve338 avdd.t544 avss 8.662165205365e-19
Cconserve339 avdd.n240 avss 4.1889064220212e-18
Cconserve340 avdd.n241 avss 4.0848519081212e-19
Cconserve341 avdd.n242 avss 2.4677335173937e-18
Cconserve342 avdd.n243 avss 1.3933740529836e-18
Cconserve343 avdd.t534 avss 8.6197701133262e-19
Cconserve344 avdd.t507 avss 8.662165205365e-19
Cconserve345 avdd.t508 avss 8.662165205365e-19
Cconserve346 avdd.n244 avss 3.6666667202506e-19
Cconserve347 avdd.n245 avss 4.677026553719e-19
Cconserve348 avdd.n246 avss 1.3933740529836e-18
Cconserve349 avdd.t504 avss 8.6197701133262e-19
Cconserve350 avdd.t495 avss 8.662165205365e-19
Cconserve351 avdd.t496 avss 8.662165205365e-19
Cconserve352 avdd.t492 avss 8.662165205365e-19
Cconserve353 avdd.t493 avss 8.662165205365e-19
Cconserve354 avdd.n247 avss 7.4062529988079e-18
Cconserve355 avdd.t489 avss 8.662165205365e-19
Cconserve356 avdd.t490 avss 8.662165205365e-19
Cconserve357 avdd.n248 avss 4.1854469825108e-18
Cconserve358 avdd.t486 avss 8.662165205365e-19
Cconserve359 avdd.t487 avss 8.662165205365e-19
Cconserve360 avdd.n249 avss 4.1854469825108e-18
Cconserve361 avdd.t483 avss 8.662165205365e-19
Cconserve362 avdd.t484 avss 8.662165205365e-19
Cconserve363 avdd.n250 avss 4.1854469825108e-18
Cconserve364 avdd.t480 avss 8.662165205365e-19
Cconserve365 avdd.t481 avss 8.662165205365e-19
Cconserve366 avdd.n251 avss 4.1854469825108e-18
Cconserve367 avdd.t477 avss 8.662165205365e-19
Cconserve368 avdd.t478 avss 8.662165205365e-19
Cconserve369 avdd.n252 avss 4.1929085187097e-18
Cconserve370 avdd.t474 avss 8.662165205365e-19
Cconserve371 avdd.t475 avss 8.662165205365e-19
Cconserve372 avdd.n253 avss 4.15610957882e-18
Cconserve373 avdd.n254 avss 3.6107051987594e-19
Cconserve374 avdd.n255 avss 1.0568248543429e-18
Cconserve375 avdd.t505 avss 8.6197701133262e-19
Cconserve376 avdd.n256 avss 2.902401917049e-18
Cconserve377 avdd.t624 avss 8.0995653759734e-18
Cconserve378 avdd.t625 avss 8.0028706500514e-18
Cconserve379 avdd.n258 avss 6.257515584925e-19
Cconserve380 avdd.t626 avss 8.0101286898084e-18
Cconserve381 avdd.n259 avss 3.8837295914892e-19
Cconserve382 avdd.t627 avss 8.0028706500514e-18
Cconserve383 avdd.n260 avss 3.8837295914892e-19
Cconserve384 avdd.t660 avss 8.0101286898084e-18
Cconserve385 avdd.n261 avss 3.8837295914892e-19
Cconserve386 avdd.t661 avss 8.0028706500514e-18
Cconserve387 avdd.n263 avss 1.8506983898244e-18
Cconserve388 avdd.t570 avss 8.1041779619873e-18
Cconserve389 avdd.t629 avss 8.0082972218323e-18
Cconserve390 avdd.n264 avss 6.257515584925e-19
Cconserve391 avdd.t628 avss 8.0145038633068e-18
Cconserve392 avdd.n265 avss 3.8837295914892e-19
Cconserve393 avdd.t630 avss 8.0082972218323e-18
Cconserve394 avdd.n266 avss 3.8837295914892e-19
Cconserve395 avdd.t631 avss 8.0145038633068e-18
Cconserve396 avdd.n267 avss 3.8837295914892e-19
Cconserve397 avdd.t641 avss 8.0082972218323e-18
Cconserve398 avdd.n269 avss 1.6641260687801e-18
Cconserve399 avdd.n270 avss 1.3128572941835e-18
Cconserve400 avdd.n271 avss 2.2276416321597e-18
Cconserve401 avdd.n272 avss 6.7340364194409e-19
Cconserve402 avdd.t535 avss 8.6197701133262e-19
Cconserve403 avdd.n273 avss 2.9029784903007e-18
Cconserve404 avdd.n275 avss 3.7473869754925e-19
Cconserve405 avdd.n276 avss 7.1915642527235e-19
Cconserve406 avdd.t643 avss 2.8525825964924e-17
Cconserve407 avdd.n277 avss 8.1880184960032e-19
Cconserve408 avdd.t471 avss 1.6969568280549e-18
Cconserve409 avdd.t472 avss 1.6969568280549e-18
Cconserve410 avdd.n278 avss 1.2484472787508e-17
Cconserve411 avdd.t468 avss 1.6969568280549e-18
Cconserve412 avdd.t469 avss 1.6969568280549e-18
Cconserve413 avdd.t501 avss 1.6969568280549e-18
Cconserve414 avdd.t502 avss 1.6969568280549e-18
Cconserve415 avdd.t498 avss 1.6969568280549e-18
Cconserve416 avdd.t499 avss 1.6969568280549e-18
Cconserve417 avdd.t531 avss 1.6969568280549e-18
Cconserve418 avdd.t532 avss 1.6969568280549e-18
Cconserve419 avdd.t528 avss 1.6969568280549e-18
Cconserve420 avdd.t529 avss 1.6969568280549e-18
Cconserve421 avdd.n279 avss 1.4864228009903e-17
Cconserve422 avdd.t525 avss 1.6969568280549e-18
Cconserve423 avdd.t526 avss 1.6969568280549e-18
Cconserve424 avdd.n280 avss 8.8081060701993e-18
Cconserve425 avdd.t522 avss 1.6969568280549e-18
Cconserve426 avdd.t523 avss 1.6969568280549e-18
Cconserve427 avdd.n281 avss 8.8081060701993e-18
Cconserve428 avdd.t519 avss 1.6969568280549e-18
Cconserve429 avdd.t520 avss 1.6969568280549e-18
Cconserve430 avdd.n282 avss 8.8081060701993e-18
Cconserve431 avdd.t516 avss 1.6969568280549e-18
Cconserve432 avdd.t517 avss 1.6969568280549e-18
Cconserve433 avdd.n283 avss 8.8081060701993e-18
Cconserve434 avdd.t513 avss 1.6969568280549e-18
Cconserve435 avdd.t514 avss 1.6969568280549e-18
Cconserve436 avdd.n284 avss 8.8210620103263e-18
Cconserve437 avdd.t510 avss 1.6969568280549e-18
Cconserve438 avdd.t511 avss 1.6969568280549e-18
Cconserve439 avdd.n285 avss 2.8083526448701e-18
Cconserve440 avdd.t416 avss 7.791675259551e-18
Cconserve441 avdd.n286 avss 1.1163679132095e-17
Cconserve442 avdd.n287 avss 1.6002892349918e-17
Cconserve443 avdd.n288 avss 1.2850223725545e-17
Cconserve444 avdd.t412 avss 7.791675259551e-18
Cconserve445 avdd.n289 avss 1.1163679132095e-17
Cconserve446 avdd.n290 avss 1.5741399422223e-17
Cconserve447 avdd.n291 avss 5.177627800513e-19
Cconserve448 avdd.n292 avss 3.3197052870052e-18
Cconserve449 avdd.t442 avss 1.14825241403e-17
Cconserve450 avdd.n293 avss 2.1056794313825e-18
Cconserve451 avdd.n294 avss 1.4518657135677e-17
Cconserve452 avdd.t595 avss 4.0352666084726e-18
Cconserve453 avdd.t666 avss 4.0448648573102e-18
Cconserve454 avdd.t663 avss 4.0429655571869e-18
Cconserve455 avdd.t664 avss 4.0385903836885e-18
Cconserve456 avdd.t594 avss 4.0429655571869e-18
Cconserve457 avdd.n299 avss 4.9666359064543e-18
Cconserve458 avdd.t610 avss 4.0429655571869e-18
Cconserve459 avdd.n301 avss 7.3184442841772e-18
Cconserve460 avdd.t619 avss 1.2648965744619e-17
Cconserve461 avdd.t654 avss 1.2647439521305e-17
Cconserve462 avdd.t587 avss 1.2804606606512e-17
Cconserve463 avdd.t632 avss 1.2815629330442e-17
Cconserve464 avdd.t650 avss 1.2789140876936e-17
Cconserve465 avdd.t649 avss 1.1534653145471e-17
Cconserve466 avdd.n302 avss 6.1520705120061e-18
Cconserve467 avdd.t607 avss 1.1537569927804e-17
Cconserve468 avdd.t613 avss 1.1541436360198e-17
Cconserve469 avdd.t621 avss 1.1532279020317e-17
Cconserve470 avdd.t622 avss 1.0798097774426e-17
Cconserve471 avdd.n306 avss 5.9401968000331e-18
Cconserve472 avdd.t311 avss 7.791675259551e-18
Cconserve473 avdd.n307 avss 1.1163679132095e-17
Cconserve474 avdd.n308 avss 1.2384963027475e-17
Cconserve475 avdd.t309 avss 7.791675259551e-18
Cconserve476 avdd.n309 avss 1.1163679132095e-17
Cconserve477 avdd.n310 avss 1.0791280643626e-17
Cconserve478 avdd.t307 avss 7.791675259551e-18
Cconserve479 avdd.n311 avss 1.1163679132095e-17
Cconserve480 avdd.n312 avss 1.0791280643626e-17
Cconserve481 avdd.t305 avss 7.791675259551e-18
Cconserve482 avdd.n313 avss 1.1163679132095e-17
Cconserve483 avdd.n314 avss 1.0791280643626e-17
Cconserve484 avdd.t303 avss 7.791675259551e-18
Cconserve485 avdd.n315 avss 1.1163679132095e-17
Cconserve486 avdd.n316 avss 1.0791280643626e-17
Cconserve487 avdd.t301 avss 7.791675259551e-18
Cconserve488 avdd.n317 avss 1.1163679132095e-17
Cconserve489 avdd.n318 avss 1.0791280643626e-17
Cconserve490 avdd.t299 avss 7.791675259551e-18
Cconserve491 avdd.n319 avss 1.1163679132095e-17
Cconserve492 avdd.n320 avss 1.0791280643626e-17
Cconserve493 avdd.t297 avss 7.791675259551e-18
Cconserve494 avdd.n321 avss 1.1163679132095e-17
Cconserve495 avdd.n322 avss 1.0791280643626e-17
Cconserve496 avdd.t295 avss 7.791675259551e-18
Cconserve497 avdd.n323 avss 1.1163679132095e-17
Cconserve498 avdd.n324 avss 1.0791280643626e-17
Cconserve499 avdd.t293 avss 7.791675259551e-18
Cconserve500 avdd.n325 avss 1.1163679132095e-17
Cconserve501 avdd.n326 avss 1.0791280643626e-17
Cconserve502 avdd.t291 avss 7.791675259551e-18
Cconserve503 avdd.n327 avss 1.1163679132095e-17
Cconserve504 avdd.n328 avss 1.0791280643626e-17
Cconserve505 avdd.t289 avss 7.791675259551e-18
Cconserve506 avdd.n329 avss 1.1163679132095e-17
Cconserve507 avdd.n330 avss 1.083418447677e-17
Cconserve508 avdd.t287 avss 7.791675259551e-18
Cconserve509 avdd.n331 avss 1.1163679132095e-17
Cconserve510 avdd.n332 avss 1.161805277053e-17
Cconserve511 avdd.n333 avss 1.4186076117651e-18
Cconserve512 avdd.t586 avss 1.2829941913514e-17
Cconserve513 avdd.n338 avss 8.237942956388e-18
Cconserve514 avdd.t620 avss 5.9769957399227e-18
Cconserve515 avdd.t655 avss 5.9638363033539e-18
Cconserve516 avdd.t284 avss 4.0980791768373e-19
Cconserve517 avdd.t285 avss 4.0980791768373e-19
Cconserve518 avdd.t263 avss 4.0980791768373e-19
Cconserve519 avdd.t264 avss 4.0980791768373e-19
Cconserve520 avdd.t260 avss 6.9137916096854e-19
Cconserve521 avdd.t261 avss 6.9137916096854e-19
Cconserve522 avdd.t257 avss 6.9137916096854e-19
Cconserve523 avdd.t258 avss 6.9137916096854e-19
Cconserve524 avdd.t227 avss 6.9137916096854e-19
Cconserve525 avdd.t228 avss 6.9137916096854e-19
Cconserve526 avdd.t224 avss 6.9137916096854e-19
Cconserve527 avdd.t225 avss 6.9137916096854e-19
Cconserve528 avdd.t221 avss 6.9137916096854e-19
Cconserve529 avdd.t222 avss 6.9137916096854e-19
Cconserve530 avdd.t218 avss 6.9137916096854e-19
Cconserve531 avdd.t219 avss 6.9137916096854e-19
Cconserve532 avdd.n341 avss 5.9182531003938e-18
Cconserve533 avdd.n342 avss 3.3450066779339e-18
Cconserve534 avdd.t647 avss 3.5936793297966e-18
Cconserve535 avdd.t623 avss 2.2174328939967e-18
Cconserve536 avdd.n343 avss 7.5972004933506e-19
Cconserve537 avdd.t648 avss 3.6265779212187e-18
Cconserve538 avdd.n344 avss 1.4551352230657e-18
Cconserve539 avdd.n345 avss 1.3169611390929e-18
Cconserve540 avdd.t233 avss 6.9137916096854e-19
Cconserve541 avdd.t234 avss 6.9137916096854e-19
Cconserve542 avdd.t230 avss 6.9137916096854e-19
Cconserve543 avdd.t231 avss 6.9137916096854e-19
Cconserve544 avdd.n346 avss 3.3445996850504e-18
Cconserve545 avdd.n347 avss 3.3439213635777e-18
Cconserve546 avdd.t236 avss 6.9137916096854e-19
Cconserve547 avdd.t237 avss 6.9137916096854e-19
Cconserve548 avdd.n348 avss 3.3070885076144e-18
Cconserve549 avdd.n350 avss 5.152529906026e-19
Cconserve550 avdd.n351 avss 1.1488391621039e-18
Cconserve551 avdd.t248 avss 6.879536375318e-19
Cconserve552 avdd.t249 avss 6.879536375318e-19
Cconserve553 avdd.n352 avss 2.3702587217781e-18
Cconserve554 avdd.n353 avss 9.7966578683229e-19
Cconserve555 avdd.n354 avss 9.9608116646971e-19
Cconserve556 avdd.t245 avss 6.9137916096854e-19
Cconserve557 avdd.t246 avss 6.9137916096854e-19
Cconserve558 avdd.n355 avss 4.0520889809936e-18
Cconserve559 avdd.n356 avss 9.2095706337698e-19
Cconserve560 avdd.t242 avss 6.9137916096854e-19
Cconserve561 avdd.t243 avss 6.9137916096854e-19
Cconserve562 avdd.n357 avss 3.732260406653e-18
Cconserve563 avdd.t239 avss 6.9137916096854e-19
Cconserve564 avdd.t240 avss 6.9137916096854e-19
Cconserve565 avdd.n358 avss 4.0844449152376e-18
Cconserve566 avdd.t251 avss 6.9137916096854e-19
Cconserve567 avdd.t252 avss 6.9137916096854e-19
Cconserve568 avdd.t313 avss 6.9137916096854e-19
Cconserve569 avdd.t314 avss 6.9137916096854e-19
Cconserve570 avdd.t316 avss 6.9137916096854e-19
Cconserve571 avdd.t317 avss 6.9137916096854e-19
Cconserve572 avdd.n359 avss 3.7751642397963e-18
Cconserve573 avdd.t331 avss 6.9137916096854e-19
Cconserve574 avdd.t332 avss 6.9137916096854e-19
Cconserve575 avdd.t334 avss 6.9137916096854e-19
Cconserve576 avdd.t335 avss 6.9137916096854e-19
Cconserve577 avdd.n360 avss 4.269999754073e-18
Cconserve578 avdd.t349 avss 6.9137916096854e-19
Cconserve579 avdd.t350 avss 6.9137916096854e-19
Cconserve580 avdd.t352 avss 6.9137916096854e-19
Cconserve581 avdd.t353 avss 6.9137916096854e-19
Cconserve582 avdd.n361 avss 3.6909845450441e-18
Cconserve583 avdd.t367 avss 6.9137916096854e-19
Cconserve584 avdd.t368 avss 6.9137916096854e-19
Cconserve585 avdd.t409 avss 4.0980791768373e-19
Cconserve586 avdd.t410 avss 4.0980791768373e-19
Cconserve587 avdd.t406 avss 4.0980791768373e-19
Cconserve588 avdd.t407 avss 4.0980791768373e-19
Cconserve589 avdd.n362 avss 1.32384610204e-18
Cconserve590 avdd.t403 avss 4.0980791768373e-19
Cconserve591 avdd.t404 avss 4.0980791768373e-19
Cconserve592 avdd.n363 avss 6.3555330377186e-19
Cconserve593 avdd.t400 avss 4.0980791768373e-19
Cconserve594 avdd.t401 avss 4.0980791768373e-19
Cconserve595 avdd.n364 avss 9.677612449878e-19
Cconserve596 avdd.t397 avss 4.0980791768373e-19
Cconserve597 avdd.t398 avss 4.0980791768373e-19
Cconserve598 avdd.n365 avss 9.6152068743969e-19
Cconserve599 avdd.t394 avss 4.0980791768373e-19
Cconserve600 avdd.t395 avss 4.0980791768373e-19
Cconserve601 avdd.n366 avss 6.1282953443907e-19
Cconserve602 avdd.t391 avss 4.0980791768373e-19
Cconserve603 avdd.t392 avss 4.0980791768373e-19
Cconserve604 avdd.n367 avss 5.8556101123973e-19
Cconserve605 avdd.t358 avss 6.9137916096854e-19
Cconserve606 avdd.t359 avss 6.9137916096854e-19
Cconserve607 avdd.t355 avss 6.9137916096854e-19
Cconserve608 avdd.t356 avss 6.9137916096854e-19
Cconserve609 avdd.n368 avss 4.3026609329797e-18
Cconserve610 avdd.n369 avss 3.5293066220449e-18
Cconserve611 avdd.t364 avss 4.0980791768373e-19
Cconserve612 avdd.t365 avss 4.0980791768373e-19
Cconserve613 avdd.t340 avss 6.9137916096854e-19
Cconserve614 avdd.t341 avss 6.9137916096854e-19
Cconserve615 avdd.t337 avss 6.9137916096854e-19
Cconserve616 avdd.t338 avss 6.9137916096854e-19
Cconserve617 avdd.n370 avss 4.7100947255092e-18
Cconserve618 avdd.n371 avss 2.5949527095837e-18
Cconserve619 avdd.t322 avss 6.9137916096854e-19
Cconserve620 avdd.t323 avss 6.9137916096854e-19
Cconserve621 avdd.t319 avss 6.9137916096854e-19
Cconserve622 avdd.t320 avss 6.9137916096854e-19
Cconserve623 avdd.n372 avss 3.9832732675963e-18
Cconserve624 avdd.n373 avss 3.7972775198037e-18
Cconserve625 avdd.t598 avss 5.6174514433602e-18
Cconserve626 avdd.t599 avss 5.6116857108429e-18
Cconserve627 avdd.n374 avss 4.9639565366375e-19
Cconserve628 avdd.t600 avss 5.6116857108429e-18
Cconserve629 avdd.t635 avss 5.6116857108429e-18
Cconserve630 avdd.t636 avss 5.6116857108429e-18
Cconserve631 avdd.t637 avss 5.6116857108429e-18
Cconserve632 avdd.n378 avss 4.8991768360022e-19
Cconserve633 avdd.t328 avss 4.0980791768373e-19
Cconserve634 avdd.t329 avss 4.0980791768373e-19
Cconserve635 avdd.t325 avss 4.0980791768373e-19
Cconserve636 avdd.t326 avss 4.0980791768373e-19
Cconserve637 avdd.n379 avss 1.4949187774349e-18
Cconserve638 avdd.n380 avss 3.5442296944426e-19
Cconserve639 avdd.t346 avss 4.0980791768373e-19
Cconserve640 avdd.t347 avss 4.0980791768373e-19
Cconserve641 avdd.t615 avss 5.6602196122089e-18
Cconserve642 avdd.t616 avss 5.609650746425e-18
Cconserve643 avdd.n381 avss 4.9639565366375e-19
Cconserve644 avdd.t617 avss 5.609650746425e-18
Cconserve645 avdd.t651 avss 5.4763266609815e-18
Cconserve646 avdd.t652 avss 5.609650746425e-18
Cconserve647 avdd.t653 avss 5.609650746425e-18
Cconserve648 avdd.n386 avss 7.5215676491534e-19
Cconserve649 avdd.t343 avss 4.0980791768373e-19
Cconserve650 avdd.t344 avss 4.0980791768373e-19
Cconserve651 avdd.n388 avss 1.1304905662695e-18
Cconserve652 avdd.n389 avss 3.5442296944426e-19
Cconserve653 avdd.t612 avss 5.6194185756308e-18
Cconserve654 avdd.t583 avss 5.6136528431135e-18
Cconserve655 avdd.n390 avss 4.9639565366375e-19
Cconserve656 avdd.t608 avss 5.6136528431135e-18
Cconserve657 avdd.t572 avss 5.4791077790192e-18
Cconserve658 avdd.t605 avss 5.6136528431135e-18
Cconserve659 avdd.t606 avss 5.6136528431135e-18
Cconserve660 avdd.n395 avss 7.5164802381088e-19
Cconserve661 avdd.t361 avss 4.0980791768373e-19
Cconserve662 avdd.t362 avss 4.0980791768373e-19
Cconserve663 avdd.n397 avss 3.3999168011426e-18
Cconserve664 avdd.n398 avss 1.2889464622736e-18
Cconserve665 avdd.t388 avss 4.0980791768373e-19
Cconserve666 avdd.t389 avss 4.0980791768373e-19
Cconserve667 avdd.n399 avss 1.188351387884e-18
Cconserve668 avdd.t385 avss 6.9137916096854e-19
Cconserve669 avdd.t386 avss 6.9137916096854e-19
Cconserve670 avdd.n400 avss 3.4007647029833e-18
Cconserve671 avdd.t382 avss 6.9137916096854e-19
Cconserve672 avdd.t383 avss 6.9137916096854e-19
Cconserve673 avdd.n401 avss 3.3452101743757e-18
Cconserve674 avdd.t379 avss 6.9137916096854e-19
Cconserve675 avdd.t380 avss 6.9137916096854e-19
Cconserve676 avdd.n402 avss 3.3631517773265e-18
Cconserve677 avdd.t376 avss 6.9137916096854e-19
Cconserve678 avdd.t377 avss 6.9137916096854e-19
Cconserve679 avdd.n403 avss 3.3339500379302e-18
Cconserve680 avdd.t373 avss 6.9137916096854e-19
Cconserve681 avdd.t374 avss 6.9137916096854e-19
Cconserve682 avdd.n404 avss 3.3450066779339e-18
Cconserve683 avdd.t370 avss 6.9137916096854e-19
Cconserve684 avdd.t371 avss 6.9137916096854e-19
Cconserve685 avdd.n405 avss 3.3443961886086e-18
Cconserve686 avdd.n406 avss 2.9376407175516e-18
Cconserve687 avdd.t254 avss 6.9137916096854e-19
Cconserve688 avdd.t255 avss 6.9137916096854e-19
Cconserve689 avdd.n407 avss 4.6194709767671e-18
Cconserve690 avdd.n408 avss 3.7137422304505e-18
Cconserve691 avdd.n409 avss 3.0928067544136e-18
Cconserve692 avdd.n410 avss 1.3339191759084e-18
Cconserve693 avdd.t266 avss 4.0980791768373e-19
Cconserve694 avdd.t267 avss 4.0980791768373e-19
Cconserve695 avdd.n411 avss 9.614189392188e-19
Cconserve696 avdd.t269 avss 4.0980791768373e-19
Cconserve697 avdd.t270 avss 4.0980791768373e-19
Cconserve698 avdd.n412 avss 6.1137114327294e-19
Cconserve699 avdd.t272 avss 4.0980791768373e-19
Cconserve700 avdd.t273 avss 4.0980791768373e-19
Cconserve701 avdd.n413 avss 5.8854562571926e-19
Cconserve702 avdd.t275 avss 4.0980791768373e-19
Cconserve703 avdd.t276 avss 4.0980791768373e-19
Cconserve704 avdd.n414 avss 5.8854562571926e-19
Cconserve705 avdd.t278 avss 4.0980791768373e-19
Cconserve706 avdd.t279 avss 4.0980791768373e-19
Cconserve707 avdd.n415 avss 5.8854562571926e-19
Cconserve708 avdd.t281 avss 4.0980791768373e-19
Cconserve709 avdd.t282 avss 4.0980791768373e-19
Cconserve710 avdd.n416 avss 6.1137114327294e-19
Cconserve711 avdd.n417 avss 1.4982425526507e-18
Cconserve712 avdd.n418 avss 2.2496870800198e-18
Cconserve713 avdd.t571 avss 5.9894768550189e-18
Cconserve714 avdd.n420 avss 3.9393519522441e-19
Cconserve715 avdd.t656 avss 1.2867385258803e-17
Cconserve716 avdd.n421 avss 1.7554620550685e-18
Cconserve717 avdd.n422 avss 1.6344495043529e-18
Cconserve718 avdd.t215 avss 1.4568310267472e-18
Cconserve719 avdd.t216 avss 1.4568310267472e-18
Cconserve720 avdd.t212 avss 1.4568310267472e-18
Cconserve721 avdd.t213 avss 1.4568310267472e-18
Cconserve722 avdd.n424 avss 1.8502303480083e-17
Cconserve723 avdd.t209 avss 1.4568310267472e-18
Cconserve724 avdd.t210 avss 1.4568310267472e-18
Cconserve725 avdd.n425 avss 1.0938171158522e-17
Cconserve726 avdd.t206 avss 1.4568310267472e-18
Cconserve727 avdd.t207 avss 1.4568310267472e-18
Cconserve728 avdd.n426 avss 1.0938171158522e-17
Cconserve729 avdd.t203 avss 1.4568310267472e-18
Cconserve730 avdd.t204 avss 1.4568310267472e-18
Cconserve731 avdd.n427 avss 1.0937798081713e-17
Cconserve732 avdd.t200 avss 1.4568310267472e-18
Cconserve733 avdd.t201 avss 1.4568310267472e-18
Cconserve734 avdd.t197 avss 1.4568310267472e-18
Cconserve735 avdd.t198 avss 1.4568310267472e-18
Cconserve736 avdd.n428 avss 1.0937187592387e-17
Cconserve737 avdd.n429 avss 1.0137412660094e-17
Cconserve738 avdd.n430 avss 1.2283418303024e-17
Cconserve739 avdd.t589 avss 8.6842445692988e-18
Cconserve740 avdd.t601 avss 8.0601209823406e-18
Cconserve741 avdd.n432 avss 9.2302594386847e-19
Cconserve742 avdd.n433 avss 1.4750100422135e-18
Cconserve743 avdd.t185 avss 1.4568310267472e-18
Cconserve744 avdd.t186 avss 1.4568310267472e-18
Cconserve745 avdd.t602 avss 8.8522647980669e-18
Cconserve746 avdd.t581 avss 8.6815651994819e-18
Cconserve747 avdd.n437 avss 5.8042272608463e-18
Cconserve748 avdd.n438 avss 1.3472142767718e-18
Cconserve749 avdd.t182 avss 1.4568310267472e-18
Cconserve750 avdd.t183 avss 1.4568310267472e-18
Cconserve751 avdd.n439 avss 4.7396356256419e-18
Cconserve752 avdd.t582 avss 8.6978788308984e-18
Cconserve753 avdd.t591 avss 8.6866865266002e-18
Cconserve754 avdd.t574 avss 8.7143281266095e-18
Cconserve755 avdd.t179 avss 1.4568310267472e-18
Cconserve756 avdd.t180 avss 1.4568310267472e-18
Cconserve757 avdd.t176 avss 1.4568310267472e-18
Cconserve758 avdd.t177 avss 1.4568310267472e-18
Cconserve759 avdd.n444 avss 1.9060731632418e-17
Cconserve760 avdd.t575 avss 8.8362903273867e-18
Cconserve761 avdd.n445 avss 1.2189776023728e-18
Cconserve762 avdd.t565 avss 8.7207043484521e-18
Cconserve763 avdd.t566 avss 8.6784788367815e-18
Cconserve764 avdd.n447 avss 1.1384269274991e-18
Cconserve765 avdd.n448 avss 6.1866309910361e-19
Cconserve766 avdd.t173 avss 1.4568310267472e-18
Cconserve767 avdd.t174 avss 1.4568310267472e-18
Cconserve768 avdd.n449 avss 9.7293683782389e-18
Cconserve769 avdd.t170 avss 1.4568310267472e-18
Cconserve770 avdd.t171 avss 1.4568310267472e-18
Cconserve771 avdd.t167 avss 1.4568310267472e-18
Cconserve772 avdd.t168 avss 1.4568310267472e-18
Cconserve773 avdd.n452 avss 1.8463673072217e-17
Cconserve774 avdd.t164 avss 1.4568310267472e-18
Cconserve775 avdd.t165 avss 1.4568310267472e-18
Cconserve776 avdd.n453 avss 1.0938171158522e-17
Cconserve777 avdd.t161 avss 1.4568310267472e-18
Cconserve778 avdd.t162 avss 1.4568310267472e-18
Cconserve779 avdd.n454 avss 1.0938171158522e-17
Cconserve780 avdd.t158 avss 1.4568310267472e-18
Cconserve781 avdd.t159 avss 1.4568310267472e-18
Cconserve782 avdd.n455 avss 1.0938171158522e-17
Cconserve783 avdd.t155 avss 1.4568310267472e-18
Cconserve784 avdd.t156 avss 1.4568310267472e-18
Cconserve785 avdd.n456 avss 1.0938171158522e-17
Cconserve786 avdd.t152 avss 1.4568310267472e-18
Cconserve787 avdd.t153 avss 1.4568310267472e-18
Cconserve788 avdd.t149 avss 1.4568310267472e-18
Cconserve789 avdd.t150 avss 1.4568310267472e-18
Cconserve790 avdd.n457 avss 1.0572250640117e-17
Cconserve791 avdd.t125 avss 1.4598495573004e-18
Cconserve792 avdd.t126 avss 1.4598495573004e-18
Cconserve793 avdd.n458 avss 5.6758888382264e-18
Cconserve794 avdd.n459 avss 1.1402923115488e-18
Cconserve795 avdd.t119 avss 1.4598495573004e-18
Cconserve796 avdd.t120 avss 1.4598495573004e-18
Cconserve797 avdd.t579 avss 8.7358987494388e-18
Cconserve798 avdd.t580 avss 8.6935714895473e-18
Cconserve799 avdd.n463 avss 5.4933864460179e-19
Cconserve800 avdd.n464 avss 4.141491751085e-19
Cconserve801 avdd.t62 avss 1.4598495573004e-18
Cconserve802 avdd.t63 avss 1.4598495573004e-18
Cconserve803 avdd.n465 avss 5.8692443739969e-18
Cconserve804 avdd.t59 avss 1.4598495573004e-18
Cconserve805 avdd.t60 avss 1.4598495573004e-18
Cconserve806 avdd.t56 avss 1.4598495573004e-18
Cconserve807 avdd.t57 avss 1.4598495573004e-18
Cconserve808 avdd.t53 avss 1.4598495573004e-18
Cconserve809 avdd.t54 avss 1.4598495573004e-18
Cconserve810 avdd.n466 avss 5.8614436770618e-18
Cconserve811 avdd.n467 avss 8.4257362560831e-18
Cconserve812 avdd.n468 avss 3.1161070969981e-18
Cconserve813 avdd.t50 avss 1.4598495573004e-18
Cconserve814 avdd.t51 avss 1.4598495573004e-18
Cconserve815 avdd.n469 avss 5.8729412260227e-18
Cconserve816 avdd.t47 avss 1.4598495573004e-18
Cconserve817 avdd.t48 avss 1.4598495573004e-18
Cconserve818 avdd.t44 avss 1.4598495573004e-18
Cconserve819 avdd.t45 avss 1.4598495573004e-18
Cconserve820 avdd.t592 avss 8.7112078478354e-18
Cconserve821 avdd.t593 avss 8.6969630969104e-18
Cconserve822 avdd.t41 avss 1.4598495573004e-18
Cconserve823 avdd.t42 avss 1.4598495573004e-18
Cconserve824 avdd.n472 avss 5.93643211586e-18
Cconserve825 avdd.n473 avss 3.2714766303019e-18
Cconserve826 avdd.n474 avss 5.4598434491968e-18
Cconserve827 avdd.n475 avss 2.9638578424684e-18
Cconserve828 avdd.n476 avss 2.8404711665987e-18
Cconserve829 avdd.n477 avss 3.1959116182519e-18
Cconserve830 avdd.n478 avss 5.8549657069983e-18
Cconserve831 avdd.n479 avss 5.8549317909246e-18
Cconserve832 avdd.t77 avss 1.4598495573004e-18
Cconserve833 avdd.t78 avss 1.4598495573004e-18
Cconserve834 avdd.n480 avss 6.3819875751508e-18
Cconserve835 avdd.n481 avss 4.9971264566486e-18
Cconserve836 avdd.t122 avss 1.4598495573004e-18
Cconserve837 avdd.t123 avss 1.4598495573004e-18
Cconserve838 avdd.t645 avss 8.8659668918138e-18
Cconserve839 avdd.t646 avss 8.6951316289343e-18
Cconserve840 avdd.n483 avss 1.9474948639674e-18
Cconserve841 avdd.n484 avss 6.5933186299458e-18
Cconserve842 avdd.n485 avss 4.7678537989029e-18
Cconserve843 avdd.n486 avss 1.6606666292697e-18
Cconserve844 avdd.n487 avss 4.4631857094753e-18
Cconserve845 avdd.t146 avss 1.4598495573004e-18
Cconserve846 avdd.t147 avss 1.4598495573004e-18
Cconserve847 avdd.n488 avss 5.8410940328832e-18
Cconserve848 avdd.t143 avss 1.4598495573004e-18
Cconserve849 avdd.t144 avss 1.4598495573004e-18
Cconserve850 avdd.t140 avss 1.4598495573004e-18
Cconserve851 avdd.t141 avss 1.4598495573004e-18
Cconserve852 avdd.t137 avss 1.4598495573004e-18
Cconserve853 avdd.t138 avss 1.4598495573004e-18
Cconserve854 avdd.t134 avss 1.4598495573004e-18
Cconserve855 avdd.t135 avss 1.4598495573004e-18
Cconserve856 avdd.n489 avss 5.8888478645557e-18
Cconserve857 avdd.n490 avss 5.1107792193862e-18
Cconserve858 avdd.n491 avss 5.0642463663644e-18
Cconserve859 avdd.n492 avss 5.8892209413656e-18
Cconserve860 avdd.n493 avss 5.8837265374374e-18
Cconserve861 avdd.n494 avss 5.8832856284802e-18
Cconserve862 avdd.n495 avss 4.4703759170851e-18
Cconserve863 avdd.n496 avss 1.2183331969738e-18
Cconserve864 avdd.n497 avss 7.2448124883242e-19
Cconserve865 avdd.n498 avss 4.1030648396611e-18
Cconserve866 avdd.n499 avss 1.6701631298864e-18
Cconserve867 avdd.n500 avss 5.8834212927747e-19
Cconserve868 avdd.n501 avss 5.4933864460179e-19
Cconserve869 avdd.n502 avss 9.3808468056065e-19
Cconserve870 avdd.t563 avss 8.8639997595432e-18
Cconserve871 avdd.t564 avss 8.6935714895473e-18
Cconserve872 avdd.n505 avss 9.5599236743783e-19
Cconserve873 avdd.t596 avss 8.7077144922514e-18
Cconserve874 avdd.t597 avss 8.6951316289343e-18
Cconserve875 avdd.n508 avss 1.0113773156773e-18
Cconserve876 avdd.n509 avss 8.0496409155886e-19
Cconserve877 avdd.n510 avss 6.2666729248053e-19
Cconserve878 avdd.n511 avss 1.3552863022959e-18
Cconserve879 avdd.t74 avss 1.4598495573004e-18
Cconserve880 avdd.t75 avss 1.4598495573004e-18
Cconserve881 avdd.n512 avss 5.7891006920068e-18
Cconserve882 avdd.n513 avss 6.6800081141467e-18
Cconserve883 avdd.n514 avss 4.2986927523648e-18
Cconserve884 avdd.n515 avss 2.7569358772455e-18
Cconserve885 avdd.t659 avss 8.6984893202238e-18
Cconserve886 avdd.t658 avss 8.7126323229279e-18
Cconserve887 avdd.t71 avss 1.4417722900551e-18
Cconserve888 avdd.t72 avss 1.4417722900551e-18
Cconserve889 avdd.t68 avss 1.4417722900551e-18
Cconserve890 avdd.t69 avss 1.4417722900551e-18
Cconserve891 avdd.t603 avss 8.6058984392111e-18
Cconserve892 avdd.t38 avss 1.4417722900551e-18
Cconserve893 avdd.t39 avss 1.4417722900551e-18
Cconserve894 avdd.t35 avss 1.4417722900551e-18
Cconserve895 avdd.t36 avss 1.4417722900551e-18
Cconserve896 avdd.n516 avss 1.8290870677067e-17
Cconserve897 avdd.t32 avss 1.4417722900551e-18
Cconserve898 avdd.t33 avss 1.4417722900551e-18
Cconserve899 avdd.n517 avss 1.0825230633331e-17
Cconserve900 avdd.t29 avss 1.4417722900551e-18
Cconserve901 avdd.t30 avss 1.4417722900551e-18
Cconserve902 avdd.n518 avss 1.0825230633331e-17
Cconserve903 avdd.t26 avss 1.4417722900551e-18
Cconserve904 avdd.t27 avss 1.4417722900551e-18
Cconserve905 avdd.n519 avss 1.0825230633331e-17
Cconserve906 avdd.t23 avss 1.4417722900551e-18
Cconserve907 avdd.t24 avss 1.4417722900551e-18
Cconserve908 avdd.t20 avss 1.4417722900551e-18
Cconserve909 avdd.t21 avss 1.4417722900551e-18
Cconserve910 avdd.t17 avss 1.4417722900551e-18
Cconserve911 avdd.t18 avss 1.4417722900551e-18
Cconserve912 avdd.t14 avss 1.4417722900551e-18
Cconserve913 avdd.t15 avss 1.4417722900551e-18
Cconserve914 avdd.t11 avss 1.4417722900551e-18
Cconserve915 avdd.t12 avss 1.4417722900551e-18
Cconserve916 avdd.t8 avss 1.4417722900551e-18
Cconserve917 avdd.t9 avss 1.4417722900551e-18
Cconserve918 avdd.t5 avss 1.4417722900551e-18
Cconserve919 avdd.t6 avss 1.4417722900551e-18
Cconserve920 avdd.t2 avss 1.4417722900551e-18
Cconserve921 avdd.t3 avss 1.4417722900551e-18
Cconserve922 avdd.t573 avss 8.7312522473514e-18
Cconserve923 avdd.t609 avss 9.6324701558751e-18
Cconserve924 avdd.t578 avss 8.6435791970152e-18
Cconserve925 avdd.t604 avss 8.6008788603137e-18
Cconserve926 avdd.n521 avss 2.4725156837757e-18
Cconserve927 avdd.t65 avss 1.4417722900551e-18
Cconserve928 avdd.t66 avss 1.4417722900551e-18
Cconserve929 avdd.n522 avss 5.8954954149874e-18
Cconserve930 avdd.t667 avss 8.6118676681701e-18
Cconserve931 avdd.n525 avss 8.3673666933641e-18
Cconserve932 avdd.n526 avss 1.0790297077491e-17
Cconserve933 avdd.n527 avss 1.0825230633331e-17
Cconserve934 avdd.n528 avss 1.0825230633331e-17
Cconserve935 avdd.n529 avss 1.0825230633331e-17
Cconserve936 avdd.n530 avss 1.0825230633331e-17
Cconserve937 avdd.n531 avss 1.0824857556521e-17
Cconserve938 avdd.t634 avss 8.6020998389644e-18
Cconserve939 avdd.n534 avss 5.4332532474701e-18
Cconserve940 avdd.t584 avss 8.6417477290391e-18
Cconserve941 avdd.n535 avss 1.0533654148325e-18
Cconserve942 avdd.t569 avss 8.643409616647e-18
Cconserve943 avdd.n536 avss 9.8451578536153e-19
Cconserve944 avdd.t633 avss 8.6417477290391e-18
Cconserve945 avdd.n537 avss 3.8201030373574e-18
Cconserve946 avdd.n538 avss 8.3261586639024e-18
Cconserve947 avdd.t116 avss 1.4404495631835e-18
Cconserve948 avdd.t117 avss 1.4404495631835e-18
Cconserve949 avdd.t110 avss 1.4417722900551e-18
Cconserve950 avdd.t111 avss 1.4417722900551e-18
Cconserve951 avdd.t107 avss 1.4417722900551e-18
Cconserve952 avdd.t108 avss 1.4417722900551e-18
Cconserve953 avdd.t104 avss 1.4417722900551e-18
Cconserve954 avdd.t105 avss 1.4417722900551e-18
Cconserve955 avdd.t101 avss 1.4417722900551e-18
Cconserve956 avdd.t102 avss 1.4417722900551e-18
Cconserve957 avdd.t98 avss 1.4417722900551e-18
Cconserve958 avdd.t99 avss 1.4417722900551e-18
Cconserve959 avdd.t95 avss 1.4417722900551e-18
Cconserve960 avdd.t96 avss 1.4417722900551e-18
Cconserve961 avdd.t92 avss 1.4417722900551e-18
Cconserve962 avdd.t93 avss 1.4417722900551e-18
Cconserve963 avdd.t89 avss 1.4417722900551e-18
Cconserve964 avdd.t90 avss 1.4417722900551e-18
Cconserve965 avdd.t86 avss 1.4417722900551e-18
Cconserve966 avdd.t87 avss 1.4417722900551e-18
Cconserve967 avdd.t83 avss 1.4417722900551e-18
Cconserve968 avdd.t84 avss 1.4417722900551e-18
Cconserve969 avdd.t80 avss 1.4417722900551e-18
Cconserve970 avdd.t81 avss 1.4417722900551e-18
Cconserve971 avdd.n539 avss 1.8272454249085e-17
Cconserve972 avdd.n540 avss 1.0825230633331e-17
Cconserve973 avdd.n541 avss 1.0825230633331e-17
Cconserve974 avdd.n542 avss 1.0825230633331e-17
Cconserve975 avdd.n543 avss 1.0825230633331e-17
Cconserve976 avdd.n544 avss 1.0825230633331e-17
Cconserve977 avdd.n545 avss 1.0825230633331e-17
Cconserve978 avdd.n546 avss 1.0825230633331e-17
Cconserve979 avdd.n547 avss 1.0825230633331e-17
Cconserve980 avdd.n548 avss 1.5503783410364e-17
Cconserve981 avdd.t113 avss 1.4404495631835e-18
Cconserve982 avdd.t114 avss 1.4404495631835e-18
Cconserve983 avdd.n549 avss 8.7151421123766e-18
Cconserve984 avdd.n550 avss 3.1493109330829e-18
Cconserve985 avdd.n553 avss 1.3720747587433e-18
Cconserve986 avdd.n554 avss 5.5873339699758e-19
Cconserve987 avdd.t131 avss 1.4585268304288e-18
Cconserve988 avdd.t132 avss 1.4585268304288e-18
Cconserve989 avdd.n555 avss 2.6222551488567e-18
Cconserve990 avdd.n556 avss 7.17901530548e-19
Cconserve991 avdd.n557 avss 5.8921377236979e-18
Cconserve992 bgsu1 avdd 1.40615e-15
Cconserve993 iref_gate avdd 2.04793e-14
Cconserve994 avdd net3 2.5941e-15
Cconserve995 avdd net4 1.14374e-15
Cconserve996 pm1 avdd 3.1763e-14
Cconserve997 pm2 avdd 3.47474e-14
Cconserve998 psrg_m3_feed avdd 5.47634e-14
Cconserve999 psrg_vnc avdd 1.632234e-14
Cconserve1000 avdd rb_mid 9.0172e-16
Cconserve1001 avdd su_state 5.65378e-15
Cconserve1002 avdd v1 2.074693e-14
Cconserve1003 v2 avdd 1.93659e-14
Cconserve1004 vaux avdd 4.17403e-15
Cconserve1005 vbn avdd 2.01557e-15
Cconserve1006 avdd vbn_fold 4.09953e-14
Cconserve1007 avdd vbn_i 1.7854e-14
Cconserve1008 avdd vbn_sink 4.12053e-14
Cconserve1009 avdd vbp_bias 7.13574e-14
Cconserve1010 vbp_cas avdd 8.86687e-14
Cconserve1011 avdd vbp_i 2.0616e-13
Cconserve1012 avdd vbp_tail 3.77707e-14
Cconserve1013 avdd vcasp 4.68557e-14
Cconserve1014 avdd vgn1 1.98017e-14
Cconserve1015 vgn2 avdd 1.98076e-14
Cconserve1016 vnx_bias avdd 7.4378e-16
Cconserve1017 avdd vq3 1.62509e-14
Cconserve1018 avdd vref 2.81537e-14
Cconserve1019 vsp avdd 7.36319e-14
Cconserve1020 vsu avdd 3.72251e-15
Cconserve1021 avdd vsu1 5.4885e-16
Cconserve1022 avdd vsu2 6.3463e-16
Cconserve1023 vsua avdd 8.6767e-16
Cconserve1024 avdd vx1 2.54361e-14
Cconserve1025 avdd vx2 2.6654e-14
Cconserve1026 vx3 avdd 2.58418e-14
Cconserve1027 xf1 avdd 3.40549e-14
Cconserve1028 xf2 avdd 3.0956e-14
Cconserve1029 y1 avdd 5.01922e-14
Cconserve1030 b1_b avss 3.4355326968217e-16
Cconserve1031 b1_b.t0 avss 5.1028567504375e-17
Cconserve1032 b1_b.t1 avss 1.3411939967018e-16
Cconserve1033 b1_b.n0 avss 4.99704848528e-16
Cconserve1034 b1_b.n1 avss 4.1798706197146e-16
Cconserve1035 b1_b.n2 avss 2.1113685264381e-16
Cconserve1036 b2_b avss 2.4601685485368e-16
Cconserve1037 b2_b.t0 avss 1.9595545535857e-17
Cconserve1038 b2_b.t1 avss 9.5682295847814e-17
Cconserve1039 b2_b.n0 avss 3.3352235088336e-16
Cconserve1040 b2_b.n1 avss 3.1145829665786e-16
Cconserve1041 b2_b.n2 avss 8.3404656221429e-17
Cconserve1042 b5_b avss 5.3117627798863e-16
Cconserve1043 b5_b.t0 avss 3.3646053578554e-17
Cconserve1044 b5_b.t1 avss 7.2339188573535e-17
Cconserve1045 b5_b.n0 avss 3.3175847985928e-16
Cconserve1046 dvdd avss 1.5972879746251e-13
Cconserve1047 dvdd.n0 avss 3.1593605734338e-15
Cconserve1048 dvdd.n1 avss 3.8029255864986e-14
Cconserve1049 dvdd.n2 avss 4.7014134722921e-16
Cconserve1050 dvdd.t1 avss 2.1705428366592e-16
Cconserve1051 dvdd.t4 avss 2.3123825448086e-16
Cconserve1052 dvdd.t0 avss 2.4869854165314e-16
Cconserve1053 dvdd.t3 avss 2.4680243218662e-16
Cconserve1054 dvdd.n3 avss 8.7746318082552e-16
Cconserve1055 dvdd.t5 avss 2.5147905553515e-16
Cconserve1056 dvdd.n4 avss 6.3704923053405e-15
Cconserve1057 dvdd.t2 avss 2.2917464417807e-16
Cconserve1058 dvdd.n5 avss 1.7465647199047e-16
Cconserve1059 dvdd.t6 avss 3.175078851909e-16
Cconserve1060 dvdd.n6 avss 2.6505935333619e-15
Cconserve1061 dvdd.n7 avss 5.8641640774446e-15
Cconserve1062 dvdd.n8 avss 8.3846898614298e-16
Cconserve1063 dvdd.n9 avss 7.1638767663943e-16
Cconserve1064 dvdd.n10 avss 1.0177484812144e-15
Cconserve1065 dvdd.n11 avss 2.4572975683118e-15
Cconserve1066 dvdd.n12 avss 1.2493217373678e-14
Cconserve1067 dvss avss 3.087531218116e-14
Cconserve1068 dvss.t3 avss 6.0739317767594e-17
Cconserve1069 dvss.t0 avss 3.8295622014754e-16
Cconserve1070 dvss.t5 avss 2.6577868374414e-16
Cconserve1071 dvss.t6 avss 1.5164319006945e-16
Cconserve1072 dvss.n0 avss 5.0198578790513e-16
Cconserve1073 dvss.t2 avss 5.618031514679e-16
Cconserve1074 dvss.n1 avss 1.8357367274583e-15
Cconserve1075 dvss.n2 avss 1.0465398666509e-15
Cconserve1076 dvss.t4 avss 5.3704847799458e-17
Cconserve1077 dvss.n3 avss 3.6098365517778e-16
Cconserve1078 dvss.n4 avss 3.8253382703167e-16
Cconserve1079 dvss.t1 avss 5.4346560417798e-17
Cconserve1080 dvss.n5 avss 1.2508359832024e-15
Cconserve1081 net3.t0 avss 5.4629319785811e-15
Cconserve1082 net3 avss 1.7227708021419e-14
Cconserve1083 net4.t0 avss 9.5920145235727e-16
Cconserve1084 net4 avss 5.0189854764273e-16
Cconserve1085 pm1 avss 2.0896645992105e-15
Cconserve1086 pm1.n0 avss 6.1184477289125e-16
Cconserve1087 pm1.t8 avss 1.0471969022667e-15
Cconserve1088 pm1.t9 avss 1.0033926605181e-15
Cconserve1089 pm1.n1 avss 2.7971057197592e-16
Cconserve1090 pm1.t11 avss 1.0179303206807e-15
Cconserve1091 pm1.t1 avss 8.5712110054005e-16
Cconserve1092 pm1.t2 avss 8.9027786399399e-16
Cconserve1093 pm1.t3 avss 9.1155838577108e-16
Cconserve1094 pm1.t5 avss 8.6849934119855e-16
Cconserve1095 pm1.t4 avss 8.6108165211719e-16
Cconserve1096 pm1.n2 avss 3.9891866356882e-16
Cconserve1097 pm1.n3 avss 1.2430538462498e-16
Cconserve1098 pm1.t0 avss 8.585104512072e-16
Cconserve1099 pm1.n4 avss 9.5946752721802e-16
Cconserve1100 pm1.n5 avss 1.1429177501787e-15
Cconserve1101 pm1.t6 avss 1.0211077837e-15
Cconserve1102 pm1.n6 avss 4.237663882926e-16
Cconserve1103 pm1.t7 avss 1.0259777284411e-15
Cconserve1104 pm1.n7 avss 3.8614746354015e-16
Cconserve1105 pm1.n8 avss 4.734889030129e-16
Cconserve1106 pm1.t10 avss 9.686137850515e-16
Cconserve1107 pm2 avss 3.8130096279616e-15
Cconserve1108 pm2.t6 avss 1.8449966203307e-15
Cconserve1109 pm2.t7 avss 2.0276778403638e-15
Cconserve1110 pm2.n0 avss 9.1269047998276e-16
Cconserve1111 pm2.t11 avss 1.845824056167e-15
Cconserve1112 pm2.n1 avss 7.4784225932403e-16
Cconserve1113 pm2.t8 avss 1.8650882959068e-15
Cconserve1114 pm2.t0 avss 1.5536146113846e-15
Cconserve1115 pm2.t2 avss 1.5691505977618e-15
Cconserve1116 pm2.t1 avss 1.555739108802e-15
Cconserve1117 pm2.n2 avss 5.9560684438547e-16
Cconserve1118 pm2.n3 avss 6.0449778620898e-16
Cconserve1119 pm2.t3 avss 1.5501738839883e-15
Cconserve1120 pm2.t4 avss 1.5580552901969e-15
Cconserve1121 pm2.t5 avss 1.6665612003995e-15
Cconserve1122 pm2.n4 avss 7.4908820517785e-16
Cconserve1123 pm2.n5 avss 3.8931335305608e-16
Cconserve1124 pm2.n6 avss 2.4302940614591e-15
Cconserve1125 pm2.n7 avss 1.8554657602357e-15
Cconserve1126 pm2.n8 avss 5.8917265220704e-16
Cconserve1127 pm2.t9 avss 1.8429456017714e-15
Cconserve1128 pm2.n9 avss 5.3495164443534e-16
Cconserve1129 pm2.t10 avss 1.8248602184933e-15
Cconserve1130 psrg_m3_protected avss 2.4813068171297e-15
Cconserve1131 psrg_m3_protected.t3 avss 5.3122639842968e-16
Cconserve1132 psrg_m3_protected.t1 avss 1.37838331135e-15
Cconserve1133 psrg_m3_protected.t2 avss 1.3278363627855e-15
Cconserve1134 psrg_m3_protected.n0 avss 4.6684965556263e-16
Cconserve1135 psrg_m3_protected.n1 avss 5.7585467847119e-16
Cconserve1136 psrg_m3_protected.t0 avss 3.6682277627121e-16
Cconserve1137 psrg_mf1_protected avss 1.9938197296276e-15
Cconserve1138 psrg_mf1_protected.t0 avss 2.9722002794711e-15
Cconserve1139 psrg_mf1_protected.t1 avss 1.5753799909013e-15
Cconserve1140 rbit0top avss 5.9760203697014e-15
Cconserve1141 rbit0top.t3 avss 1.0949109411122e-15
Cconserve1142 rbit0top.t9 avss 1.1241300072094e-15
Cconserve1143 rbit0top.t8 avss 1.1193970203123e-15
Cconserve1144 rbit0top.n0 avss 1.1107864055959e-15
Cconserve1145 rbit0top.t4 avss 1.0963850099229e-15
Cconserve1146 rbit0top.t1 avss 1.0955153948605e-15
Cconserve1147 rbit0top.t2 avss 1.0901494422458e-15
Cconserve1148 rbit0top.t6 avss 8.9623668811457e-16
Cconserve1149 rbit0top.t7 avss 3.0633259772483e-16
Cconserve1150 rbit0top.n1 avss 2.2525824289585e-15
Cconserve1151 rbit0top.n2 avss 7.8135055918006e-16
Cconserve1152 rbit0top.t0 avss 1.0980215969584e-15
Cconserve1153 rbit0top.n3 avss 1.2834092722811e-16
Cconserve1154 rbit0top.n4 avss 9.2182047813119e-17
Cconserve1155 rbit0top.n5 avss 7.9134970679939e-17
Cconserve1156 rbit0top.n6 avss 2.6890892735349e-15
Cconserve1157 rbit0top.n7 avss 8.4455304143775e-17
Cconserve1158 rbit0top.t5 avss 1.0800790147034e-15
Cconserve1159 rbit1top avss 1.6758521389202e-15
Cconserve1160 rbit1top.t0 avss 7.4023169849409e-16
Cconserve1161 rbit1top.t8 avss 7.6373385890437e-16
Cconserve1162 rbit1top.t9 avss 7.6603409636405e-16
Cconserve1163 rbit1top.n0 avss 3.0451934332467e-16
Cconserve1164 rbit1top.t1 avss 7.5162436960668e-16
Cconserve1165 rbit1top.t2 avss 7.5097174409486e-16
Cconserve1166 rbit1top.t3 avss 7.5115668012982e-16
Cconserve1167 rbit1top.t4 avss 7.5167327831014e-16
Cconserve1168 rbit1top.t13 avss 7.6325394225165e-16
Cconserve1169 rbit1top.t6 avss 1.3490090292593e-16
Cconserve1170 rbit1top.t7 avss 1.7596892986383e-16
Cconserve1171 rbit1top.n1 avss 8.2832544381031e-16
Cconserve1172 rbit1top.n2 avss 7.8101085840217e-16
Cconserve1173 rbit1top.t10 avss 7.5419666172936e-16
Cconserve1174 rbit1top.n3 avss 7.5797791586573e-17
Cconserve1175 rbit1top.t11 avss 7.5335451499163e-16
Cconserve1176 rbit1top.n4 avss 6.9783549457782e-17
Cconserve1177 rbit1top.t12 avss 7.5428072356343e-16
Cconserve1178 rbit1top.n5 avss 6.4978269342681e-17
Cconserve1179 rbit1top.t5 avss 7.5065383752236e-16
Cconserve1180 rbit1top.n6 avss 5.976337883609e-17
Cconserve1181 rbit1top.n7 avss 6.2350954928604e-17
Cconserve1182 rbit1top.n8 avss 5.8034761848119e-17
Cconserve1183 rbit1top.n9 avss 5.9471455012303e-17
Cconserve1184 rbit1top.n10 avss 6.1586756437017e-17
Cconserve1185 rbit1top.n11 avss 2.5932005934125e-16
Cconserve1186 rbit2top avss 2.5548918463479e-15
Cconserve1187 rbit2top.t5 avss 1.0197798964284e-15
Cconserve1188 rbit2top.t6 avss 1.0344318819807e-15
Cconserve1189 rbit2top.t9 avss 1.0417717034059e-15
Cconserve1190 rbit2top.t0 avss 1.8347851575466e-16
Cconserve1191 rbit2top.t2 avss 3.853916844512e-16
Cconserve1192 rbit2top.n0 avss 1.2054880159087e-15
Cconserve1193 rbit2top.n1 avss 8.0669743425866e-16
Cconserve1194 rbit2top.t7 avss 1.0372890936253e-15
Cconserve1195 rbit2top.n2 avss 1.1168655227815e-16
Cconserve1196 rbit2top.n3 avss 8.7603428065554e-17
Cconserve1197 rbit2top.t4 avss 5.3968962320056e-16
Cconserve1198 rbit2top.t1 avss 5.3690474602792e-16
Cconserve1199 rbit2top.t3 avss 5.4158308437982e-16
Cconserve1200 rbit2top.n4 avss 1.3695894031008e-16
Cconserve1201 rbit2top.n5 avss 3.7075246380572e-16
Cconserve1202 rbit2top.t8 avss 5.5387994462265e-16
Cconserve1203 rbit2top.n6 avss 6.9295785946592e-16
Cconserve1204 rbit2top.n7 avss 4.0988328568224e-16
Cconserve1205 rbit3top avss 9.5878590519826e-15
Cconserve1206 rbit3top.t0 avss 8.7527227285667e-16
Cconserve1207 rbit3top.t7 avss 6.3240082212173e-16
Cconserve1208 rbit3top.t2 avss 1.9263475490936e-16
Cconserve1209 rbit3top.t1 avss 8.6072516350184e-16
Cconserve1210 rbit3top.n0 avss 8.0356248379345e-15
Cconserve1211 rbit3top.t3 avss 4.3452707328388e-16
Cconserve1212 rbit3top.t4 avss 6.0606173775957e-16
Cconserve1213 rbit3top.n1 avss 3.1697184867816e-16
Cconserve1214 rbit3top.t5 avss 6.1088110353359e-16
Cconserve1215 rbit3top.n2 avss 8.2450574350271e-17
Cconserve1216 rbit3top.n3 avss 7.7862215994618e-16
Cconserve1217 rbit3top.t6 avss 6.0862189336864e-16
Cconserve1218 rbit3top.n4 avss 2.8521574632199e-16
Cconserve1219 rbit3top.n5 avss 7.3381095945106e-16
Cconserve1220 rbit4top avss 6.3302122085327e-15
Cconserve1221 rbit4top.t5 avss 7.7747503594737e-16
Cconserve1222 rbit4top.t2 avss 6.4526236067111e-16
Cconserve1223 rbit4top.t3 avss 3.3071990617191e-16
Cconserve1224 rbit4top.n0 avss 1.3200819154354e-15
Cconserve1225 rbit4top.n1 avss 1.3128180955663e-15
Cconserve1226 rbit4top.t1 avss 9.9158809353561e-16
Cconserve1227 rbit4top.t4 avss 3.2696484126195e-16
Cconserve1228 rbit4top.n2 avss 2.1819947909235e-15
Cconserve1229 rbit4top.n3 avss 1.6039936362446e-15
Cconserve1230 rbit4top.t0 avss 1.4348391157095e-15
Cconserve1231 rbit5top avss 1.2996526759699e-14
Cconserve1232 rbit5top.t0 avss 4.3158461269328e-16
Cconserve1233 rbit5top.t2 avss 3.7269036281976e-16
Cconserve1234 rbit5top.n0 avss 3.5986923248906e-16
Cconserve1235 rbit5top.t1 avss 1.5186878326745e-15
Cconserve1236 rbit5top.t3 avss 3.3896952777277e-16
Cconserve1237 rbit5top.n1 avss 3.043404541918e-15
Cconserve1238 rbit5top.n2 avss 2.6678229631164e-15
Cconserve1239 rbit5top.t5 avss 5.3346240827466e-16
Cconserve1240 rbit5top.t4 avss 8.5792175854236e-16
Cconserve1241 rbit6top avss 1.0169640755752e-14
Cconserve1242 rbit6top.n0 avss 1.5480572101244e-15
Cconserve1243 rbit6top.n1 avss 6.192841273778e-16
Cconserve1244 rbit6top.t5 avss 1.937870993215e-16
Cconserve1245 rbit6top.t2 avss 9.969753340616e-16
Cconserve1246 rbit6top.t1 avss 7.956529036898e-16
Cconserve1247 rbit6top.n2 avss 2.5285989178237e-15
Cconserve1248 rbit6top.t3 avss 7.8889812485985e-17
Cconserve1249 rbit6top.t4 avss 2.1762996752926e-16
Cconserve1250 rbit6top.n3 avss 1.2085530197592e-15
Cconserve1251 rbit6top.t0 avss 3.8567085207491e-16
Cconserve1252 rfix0 avss 9.6286e-15
Cconserve1253 rfix1 avss 1.11355e-14
Cconserve1254 rfix2 avss 1.1172e-14
Cconserve1255 su_state avss 1.1755151655059e-14
Cconserve1256 su_state.t2 avss 2.0909571701963e-15
Cconserve1257 su_state.t1 avss 4.6443056917622e-15
Cconserve1258 su_state.n0 avss 9.5751909456878e-15
Cconserve1259 su_state.t0 avss 1.4744453729432e-16
Cconserve1260 v1.n0 avss 4.5700790273294e-16
Cconserve1261 v1.n1 avss 6.0888358908559e-16
Cconserve1262 v1.t1 avss 7.6755698245536e-16
Cconserve1263 v1.t0 avss 7.5963520021521e-16
Cconserve1264 v1.n2 avss 1.2467534834149e-16
Cconserve1265 v1.n3 avss 4.9274056130337e-16
Cconserve1266 v1.n4 avss 6.548128081817e-16
Cconserve1267 v1.n5 avss 3.7205178092716e-16
Cconserve1268 v1.n6 avss 1.1888569524688e-16
Cconserve1269 v1.n7 avss 3.4043882951932e-16
Cconserve1270 v1.n8 avss 1.5978719785473e-15
Cconserve1271 v1.n9 avss 2.6288524708417e-15
Cconserve1272 v1.n10 avss 2.9350345848922e-16
Cconserve1273 v1 avss 7.7025133941128e-15
Cconserve1274 vaux avss 2.4304072342203e-15
Cconserve1275 vaux.t1 avss 6.1124323312834e-16
Cconserve1276 vaux.t0 avss 1.5606251881457e-15
Cconserve1277 vaux.n0 avss 2.1292377158324e-15
Cconserve1278 vaux.t2 avss 6.1410662867325e-16
Cconserve1279 vq2.t0 avss 3.0926276538752e-16
Cconserve1280 vq2 avss 7.9551672346125e-15
Cconserve1281 vq3.t2 avss 1.5356435359661e-16
Cconserve1282 vq3.n0 avss 4.6807647086936e-16
Cconserve1283 vq3.n1 avss 1.3132488787365e-14
Cconserve1284 vq3.t0 avss 2.2953349598151e-16
Cconserve1285 vq3.n2 avss 2.8039441707091e-14
Cconserve1286 vq3 avss 9.4906895185096e-14
Cconserve1287 vsp avss 2.8507835184543e-15
Cconserve1288 vsp.t3 avss 3.3310207262072e-15
Cconserve1289 vsp.t8 avss 3.408233926239e-15
Cconserve1290 vsp.t4 avss 3.3308375797255e-15
Cconserve1291 vsp.t5 avss 3.3285787731182e-15
Cconserve1292 vsp.t10 avss 3.4296824142035e-15
Cconserve1293 vsp.t1 avss 3.4319751368259e-15
Cconserve1294 vsp.t6 avss 3.3285787731182e-15
Cconserve1295 vsp.t12 avss 2.2371308820072e-15
Cconserve1296 vsp.t15 avss 2.3521875717146e-15
Cconserve1297 vsp.t13 avss 2.3105692295557e-15
Cconserve1298 vsp.n0 avss 4.5513257335796e-16
Cconserve1299 vsp.t0 avss 2.314344082039e-15
Cconserve1300 vsp.n1 avss 3.0557990466771e-16
Cconserve1301 vsp.t2 avss 2.3145984521524e-15
Cconserve1302 vsp.n2 avss 3.0563417029191e-16
Cconserve1303 vsp.t11 avss 2.3106065371723e-15
Cconserve1304 vsp.n3 avss 3.0935475715104e-16
Cconserve1305 vsp.n4 avss 1.7501816948612e-15
Cconserve1306 vsp.t9 avss 3.4296824142035e-15
Cconserve1307 vsp.n5 avss 1.7064266437494e-15
Cconserve1308 vsp.t7 avss 3.3382109214135e-15
Cconserve1309 vsp.n6 avss 2.679263446768e-16
Cconserve1310 vsp.n7 avss 2.6632211716143e-16
Cconserve1311 vsp.n8 avss 2.679263446768e-16
Cconserve1312 vsp.n9 avss 1.0856855601414e-15
Cconserve1313 vsp.n10 avss 1.0684867488719e-15
Cconserve1314 vsp.n11 avss 2.679263446768e-16
Cconserve1315 vsp.n12 avss 2.6632211716143e-16
Cconserve1316 vsp.n13 avss 3.8181293186242e-16
Cconserve1317 vsp.t14 avss 3.3766208085417e-15
Cconserve1318 vsu1 avss 6.27575e-15
Cconserve1319 vsu2 avss 9.655e-15
Cconserve1320 vx1 avss 1.2617946448555e-15
Cconserve1321 vx1.t7 avss 5.3170266572265e-16
Cconserve1322 vx1.t6 avss 8.4673523257506e-16
Cconserve1323 vx1.n0 avss 7.9608491804313e-16
Cconserve1324 vx1.t8 avss 5.3151607632289e-16
Cconserve1325 vx1.n1 avss 4.511308750438e-16
Cconserve1326 vx1.t9 avss 5.3904931235622e-16
Cconserve1327 vx1.n2 avss 6.4958736063795e-16
Cconserve1328 vx1.t1 avss 9.4265462334956e-16
Cconserve1329 vx1.t0 avss 9.4171918849206e-16
Cconserve1330 vx1.n3 avss 2.943111920434e-16
Cconserve1331 vx1.t3 avss 1.0098840280156e-15
Cconserve1332 vx1.t2 avss 1.0040226330042e-15
Cconserve1333 vx1.n4 avss 5.8982899553865e-16
Cconserve1334 vx1.n5 avss 5.4365433874252e-16
Cconserve1335 vx1.t5 avss 9.6975984348932e-16
Cconserve1336 vx1.t4 avss 9.6783921660103e-16
Cconserve1337 vx1.n6 avss 3.8659830916908e-16
Cconserve1338 vx1.n7 avss 1.6474450798738e-15
Cconserve1339 vx1.n8 avss 1.5260773828295e-15
Cconserve1340 vx1.t10 avss 5.1604408329405e-16
Cconserve1341 vx2 avss 1.0017086647212e-15
Cconserve1342 vx2.t8 avss 2.2940187466605e-16
Cconserve1343 vx2.t7 avss 2.661755409283e-16
Cconserve1344 vx2.t6 avss 3.5413188276346e-16
Cconserve1345 vx2.n0 avss 4.7335188179526e-16
Cconserve1346 vx2.n1 avss 2.7900660079892e-16
Cconserve1347 vx2.t9 avss 2.2931888892597e-16
Cconserve1348 vx2.n2 avss 2.7037120231647e-16
Cconserve1349 vx2.t1 avss 4.4801438274317e-16
Cconserve1350 vx2.t0 avss 4.4455827074454e-16
Cconserve1351 vx2.n3 avss 2.3185971702666e-16
Cconserve1352 vx2.t3 avss 4.3539078722275e-16
Cconserve1353 vx2.t2 avss 4.2882270997112e-16
Cconserve1354 vx2.n4 avss 7.6722757461088e-17
Cconserve1355 vx2.n5 avss 2.4111750855971e-16
Cconserve1356 vx2.t5 avss 4.5291298216495e-16
Cconserve1357 vx2.t4 avss 4.4843541333622e-16
Cconserve1358 vx2.n6 avss 2.4481281475033e-16
Cconserve1359 vx2.n7 avss 6.1973750691798e-16
Cconserve1360 vx2.n8 avss 7.1766434134805e-16
Cconserve1361 vx2.t10 avss 2.2384427083775e-16
Cconserve1362 vx3 avss 4.7775814718986e-15
Cconserve1363 vx3.t1 avss 1.3004709186215e-15
Cconserve1364 vx3.t4 avss 1.3072333809368e-15
Cconserve1365 vx3.n0 avss 9.1793825929373e-16
Cconserve1366 vx3.t3 avss 1.254649990281e-15
Cconserve1367 vx3.t10 avss 1.2596355293152e-15
Cconserve1368 vx3.n1 avss 4.7579236234865e-16
Cconserve1369 vx3.n2 avss 6.8834961753527e-16
Cconserve1370 vx3.t2 avss 1.2541998363831e-15
Cconserve1371 vx3.t0 avss 1.2435924505492e-15
Cconserve1372 vx3.n3 avss 2.4439633576718e-16
Cconserve1373 vx3.n4 avss 1.5327401760726e-15
Cconserve1374 vx3.t5 avss 1.3321644607239e-15
Cconserve1375 vx3.t6 avss 6.0048194590306e-15
Cconserve1376 vx3.n5 avss 8.9388379499203e-16
Cconserve1377 vx3.t7 avss 6.7754930860228e-16
Cconserve1378 vx3.n6 avss 5.7776745098606e-16
Cconserve1379 vx3.t8 avss 6.8715146355147e-16
Cconserve1380 vx3.n7 avss 1.0366299652361e-15
Cconserve1381 vx3.t9 avss 6.5782376787478e-16
Cconserve1382 xf1 avss 2.3987414538547e-14
Cconserve1383 xf1.t9 avss 7.0992556522836e-15
Cconserve1384 xf1.t5 avss 7.1743663852899e-15
Cconserve1385 xf1.t0 avss 3.1155530467237e-15
Cconserve1386 xf1.t11 avss 3.0552669070272e-15
Cconserve1387 xf1.n0 avss 1.2201506613671e-15
Cconserve1388 xf1.t2 avss 3.3866382641985e-15
Cconserve1389 xf1.t3 avss 3.0548216024767e-15
Cconserve1390 xf1.n1 avss 1.7604589136508e-15
Cconserve1391 xf1.t4 avss 3.0574367546553e-15
Cconserve1392 xf1.n2 avss 1.2751741109208e-15
Cconserve1393 xf1.n3 avss 1.1681795720961e-15
Cconserve1394 xf1.t1 avss 2.9059684359013e-15
Cconserve1395 xf1.n4 avss 3.2651510863654e-15
Cconserve1396 xf1.n5 avss 1.050076708847e-14
Cconserve1397 xf1.t10 avss 7.0493329639451e-15
Cconserve1398 xf1.n6 avss 4.1875468359035e-15
Cconserve1399 xf1.t6 avss 7.0945759062798e-15
Cconserve1400 xf1.n7 avss 2.429306348559e-15
Cconserve1401 xf1.t8 avss 7.0738004248856e-15
Cconserve1402 xf1.n8 avss 2.8072241759311e-15
Cconserve1403 xf1.n9 avss 1.2694418268884e-15
Cconserve1404 xf1.t7 avss 7.0321684976335e-15
Cconserve1405 xf2 avss 1.4312217896289e-14
Cconserve1406 xf2.t6 avss 4.0028670558952e-15
Cconserve1407 xf2.t8 avss 4.0659398617739e-15
Cconserve1408 xf2.t2 avss 4.1958098578102e-15
Cconserve1409 xf2.t10 avss 1.9349564020639e-15
Cconserve1410 xf2.t0 avss 1.7256880839645e-15
Cconserve1411 xf2.t1 avss 1.6922223425344e-15
Cconserve1412 xf2.n0 avss 6.7726943300382e-16
Cconserve1413 xf2.t11 avss 1.8442282523444e-15
Cconserve1414 xf2.n1 avss 1.0383735568235e-15
Cconserve1415 xf2.t4 avss 1.6815102613089e-15
Cconserve1416 xf2.n2 avss 2.6830786648369e-16
Cconserve1417 xf2.t3 avss 1.6934309768558e-15
Cconserve1418 xf2.n3 avss 6.1899087659968e-16
Cconserve1419 xf2.n4 avss 2.5046126162372e-15
Cconserve1420 xf2.n5 avss 5.7146021280837e-15
Cconserve1421 xf2.t7 avss 4.0544085950639e-15
Cconserve1422 xf2.n6 avss 2.4829064391111e-15
Cconserve1423 xf2.t5 avss 4.0565259433379e-15
Cconserve1424 xf2.n7 avss 4.4537727097882e-16
Cconserve1425 xf2.n8 avss 1.1864670725711e-15
Cconserve1426 xf2.n9 avss 1.8685307550495e-15
Cconserve1427 xf2.t9 avss 4.0023164558155e-15
Cconserve1428 b0 b0_b 1.57273e-15
Cconserve1429 b0 b1 2.8169e-16
Cconserve1430 b0 b1_b 1.1519e-16
Cconserve1431 b0 b2 2.3544e-16
Cconserve1432 b0 b2_b 6.6587e-16
Cconserve1433 b3 b0 1.1624e-16
Cconserve1434 dvdd b0 2.25472e-15
Cconserve1435 dvss b0 2.19903e-15
Cconserve1436 b0 rbit0top 1.30134e-15
Cconserve1437 b0 rbit1top 9.5698e-16
Cconserve1438 b0 rbit2top 5.3646e-16
Cconserve1439 b0 rbit3top 2.6929e-16
Cconserve1440 b0 rbit4top 2.7314e-16
Cconserve1441 b0 rbit5top 6.5409e-16
Cconserve1442 b0 rbit6top 3.7638e-16
Cconserve1443 b2 b0_b 4.976e-16
Cconserve1444 b0_b b2_b 3.6378e-16
Cconserve1445 b3 b0_b 4.5596e-16
Cconserve1446 b4 b0_b 2.1404e-16
Cconserve1447 b5 b0_b 1.8986e-16
Cconserve1448 b6 b0_b 2.31e-16
Cconserve1449 dvdd b0_b 4.14987e-15
Cconserve1450 dvss b0_b 1.14456e-15
Cconserve1451 rbit0top b0_b 2.37512e-15
Cconserve1452 b0_b rbit1top 2.10468e-15
Cconserve1453 b0_b rbit2top 1.2093e-16
Cconserve1454 b0_b rbit4top 1.0611e-16
Cconserve1455 b0_b rbit5top 1.2174e-16
Cconserve1456 b0_b rbit6top 4.5445e-16
Cconserve1457 vref b0_b 4.6432e-16
Cconserve1458 b1 b1_b 2.00112e-15
Cconserve1459 b2 b1 6.1748e-16
Cconserve1460 b1 b2_b 1.6487e-16
Cconserve1461 b3 b1 1.4443e-16
Cconserve1462 b1 b3_b 1.9763e-16
Cconserve1463 b1 b4_b 2.1295e-16
Cconserve1464 dvdd b1 1.9632e-15
Cconserve1465 dvss b1 1.55352e-15
Cconserve1466 b1 rbit0top 3.846e-16
Cconserve1467 b1 rbit1top 8.303e-16
Cconserve1468 b1 rbit2top 9.9261e-16
Cconserve1469 b1 vq3 6.1141e-16
Cconserve1470 b1 vref 5.1763e-16
Cconserve1471 b4_b b1_b 1.3055e-16
Cconserve1472 b1_b b5_b 2.4169e-16
Cconserve1473 b6 b1_b 1.8908e-16
Cconserve1474 dvdd b1_b 1.71207e-15
Cconserve1475 dvss b1_b 4.0119e-16
Cconserve1476 b1_b rbit1top 1.0224e-15
Cconserve1477 b1_b rbit2top 1.0123e-15
Cconserve1478 b1_b rbit5top 1.5391e-16
Cconserve1479 b1_b rbit6top 6.1487e-16
Cconserve1480 b1_b vq3 4.6662e-16
Cconserve1481 vref b1_b 4.6737e-16
Cconserve1482 b2 b2_b 6.365e-16
Cconserve1483 b3 b2 5.2826e-16
Cconserve1484 b4 b2 1.2242e-16
Cconserve1485 b5 b2 9.131e-16
Cconserve1486 dvdd b2 2.80728e-15
Cconserve1487 dvss b2 1.49362e-15
Cconserve1488 b2 rbit0top 2.8679e-16
Cconserve1489 b2 rbit1top 5.9167e-16
Cconserve1490 b2 rbit2top 2.7743e-16
Cconserve1491 b2 rbit3top 2.8452e-16
Cconserve1492 b2 rbit4top 1.1838e-16
Cconserve1493 b2 rbit5top 1.5945e-16
Cconserve1494 b2 rbit6top 3.2719e-16
Cconserve1495 b2 vq3 5.3362e-16
Cconserve1496 b2 vref 2.7624e-16
Cconserve1497 b3 b2_b 8.6019e-16
Cconserve1498 b3_b b2_b 1.8346e-16
Cconserve1499 dvdd b2_b 2.9187e-15
Cconserve1500 dvss b2_b 1.29017e-15
Cconserve1501 b2_b rbit2top 6.2978e-16
Cconserve1502 rbit3top b2_b 1.34317e-15
Cconserve1503 rbit4top b2_b 1.7164e-16
Cconserve1504 rbit5top b2_b 2.5686e-16
Cconserve1505 rbit6top b2_b 2.5905e-16
Cconserve1506 b2_b vq3 1.6987e-16
Cconserve1507 b3 b4 2.21325e-15
Cconserve1508 b3 b4_b 1.346e-16
Cconserve1509 b3 b5 5.4286e-16
Cconserve1510 b3 b5_b 1.781e-16
Cconserve1511 b3 b6 9.0951e-16
Cconserve1512 b3 b6_b 1.2306e-16
Cconserve1513 dvdd b3 2.20359e-15
Cconserve1514 dvss b3 2.17826e-15
Cconserve1515 b3 rbit0top 5.252e-16
Cconserve1516 b3 rbit1top 3.8125e-16
Cconserve1517 b3 rbit3top 3.6575e-16
Cconserve1518 b3 rbit4top 2.00367e-15
Cconserve1519 b3 rbit5top 3.1365e-16
Cconserve1520 b3 rbit6top 2.7467e-16
Cconserve1521 b3 vq3 7.3433e-16
Cconserve1522 b3 vref 1.6929e-16
Cconserve1523 b4 b3_b 3.7929e-16
Cconserve1524 b4_b b3_b 1.2044e-16
Cconserve1525 b5 b3_b 1.4928e-16
Cconserve1526 b3_b b5_b 1.0598e-16
Cconserve1527 b6 b3_b 2.8826e-16
Cconserve1528 b6_b b3_b 1.0274e-16
Cconserve1529 dvdd b3_b 9.8607e-16
Cconserve1530 dvss b3_b 4.4394e-16
Cconserve1531 b3_b rbit3top 5.0673e-16
Cconserve1532 b3_b rbit4top 2.8591e-16
Cconserve1533 b3_b rbit6top 2.6035e-16
Cconserve1534 b3_b vq3 5.1249e-16
Cconserve1535 b4 b4_b 4.4717e-16
Cconserve1536 b4 b5 4.2193e-16
Cconserve1537 b4 b5_b 2.31201e-15
Cconserve1538 b4 b6 1.2575e-16
Cconserve1539 b4 b6_b 2.1254e-16
Cconserve1540 dvdd b4 2.36894e-15
Cconserve1541 dvss b4 1.49472e-15
Cconserve1542 b4 rbit0top 3.5802e-16
Cconserve1543 b4 rbit1top 3.0277e-16
Cconserve1544 b4 rbit2top 1.4143e-16
Cconserve1545 b4 rbit4top 1.5644e-16
Cconserve1546 b4 rbit5top 3.3512e-16
Cconserve1547 b4 vq3 1.2386e-16
Cconserve1548 b4 vref 3.2122e-16
Cconserve1549 b5 b4_b 5.1793e-16
Cconserve1550 b4_b b5_b 1.403e-16
Cconserve1551 b6 b4_b 1.8235e-16
Cconserve1552 b4_b b6_b 3.9921e-16
Cconserve1553 dvdd b4_b 2.04749e-15
Cconserve1554 dvss b4_b 1.03305e-15
Cconserve1555 b4_b rbit3top 1.6324e-16
Cconserve1556 b4_b rbit4top 5.2889e-16
Cconserve1557 b4_b rbit5top 6.4681e-16
Cconserve1558 b5 b5_b 7.1797e-16
Cconserve1559 b5 b6 7.4946e-16
Cconserve1560 dvdd b5 1.97331e-15
Cconserve1561 dvss b5 1.9132e-15
Cconserve1562 b5 rbit0top 3.1087e-16
Cconserve1563 b5 rbit1top 2.6006e-16
Cconserve1564 b5 rbit3top 1.1617e-16
Cconserve1565 b5 rbit5top 1.8324e-16
Cconserve1566 b5 rbit6top 2.3277e-16
Cconserve1567 b5 vq3 2.3596e-16
Cconserve1568 b5 vref 2.878e-16
Cconserve1569 b6 b5_b 1.2061e-16
Cconserve1570 b6_b b5_b 1.2883e-16
Cconserve1571 dvdd b5_b 8.0288e-16
Cconserve1572 dvss b5_b 1.3604e-15
Cconserve1573 rbit3top b5_b 1.0112e-16
Cconserve1574 b5_b rbit5top 3.2349e-16
Cconserve1575 b5_b rbit6top 1.7822e-16
Cconserve1576 b5_b vq3 2.0329e-16
Cconserve1577 b6 b6_b 4.6004e-16
Cconserve1578 dvdd b6 2.30224e-15
Cconserve1579 dvss b6 1.76049e-15
Cconserve1580 b6 rbit0top 3.5994e-16
Cconserve1581 b6 rbit1top 3.938e-16
Cconserve1582 b6 rbit3top 2.2366e-16
Cconserve1583 b6 rbit4top 3.5582e-16
Cconserve1584 b6 rbit5top 1.69e-16
Cconserve1585 b6 rbit6top 2.1217e-16
Cconserve1586 b6 vq3 5.2063e-16
Cconserve1587 dvdd b6_b 8.9872e-16
Cconserve1588 dvss b6_b 1.414e-15
Cconserve1589 b6_b rbit3top 1.0124e-16
Cconserve1590 b6_b rbit6top 1.3315e-16
Cconserve1591 b6_b vq3 4.4449e-16
Cconserve1592 bgsu2 bgsu1 3.0326e-16
Cconserve1593 psrg_m3_feed bgsu1 1.21311e-14
Cconserve1594 psrg_vnc bgsu1 1.53991e-15
Cconserve1595 bgsu1 rb_mid 1.0425e-16
Cconserve1596 bgsu1 vbn 8.42495e-15
Cconserve1597 bgsu1 vbn_fold 1.4888e-16
Cconserve1598 bgsu1 vbn_i 7.29036e-15
Cconserve1599 bgsu1 vcasp 1.07063e-15
Cconserve1600 vnx_bias bgsu1 1.65525e-14
Cconserve1601 bgsu1 vsu 1.7301e-16
Cconserve1602 bgsu1 vsu2 3.0458e-16
Cconserve1603 bgsu1 vsua 1.3226e-16
Cconserve1604 bgsu1 y1 1.124e-16
Cconserve1605 bgsu2 vsu2 2.7649e-16
Cconserve1606 dvdd dvss 6.13982e-15
Cconserve1607 dvdd rbit0top 1.82143e-14
Cconserve1608 dvdd rbit1top 2.52992e-14
Cconserve1609 dvdd rbit2top 1.49437e-14
Cconserve1610 dvdd rbit3top 9.08123e-15
Cconserve1611 dvdd rbit4top 5.37254e-15
Cconserve1612 dvdd rbit5top 3.45499e-15
Cconserve1613 dvdd rbit6top 3.48836e-15
Cconserve1614 dvdd vq3 2.5307e-15
Cconserve1615 dvdd vref 4.32753e-15
Cconserve1616 dvss rbit0top 7.87695e-15
Cconserve1617 dvss rbit1top 8.40737e-15
Cconserve1618 dvss rbit2top 3.84354e-15
Cconserve1619 dvss rbit3top 2.47236e-15
Cconserve1620 dvss rbit4top 2.4366e-15
Cconserve1621 dvss rbit5top 1.32184e-15
Cconserve1622 dvss rbit6top 9.5852e-16
Cconserve1623 dvss vq3 8.8599e-16
Cconserve1624 dvss vref 1.7802e-16
Cconserve1625 iref_gate pm2 1.462e-15
Cconserve1626 iref_gate su_state 9.44851e-15
Cconserve1627 iref_gate v1 1.6482e-16
Cconserve1628 v2 iref_gate 4.5614e-16
Cconserve1629 iref_gate vbn_fold 1.81815e-15
Cconserve1630 iref_gate vbn_i 4.4342e-16
Cconserve1631 iref_gate vbn_sink 5.317e-16
Cconserve1632 vbp_cas iref_gate 7.8455e-16
Cconserve1633 iref_gate vbp_i 3.93968e-15
Cconserve1634 iref_gate vbp_tail 8.6895e-16
Cconserve1635 vgn2 iref_gate 1.3704e-16
Cconserve1636 vsp iref_gate 1.0677e-16
Cconserve1637 xf2 iref_gate 5.31953e-15
Cconserve1638 su_state net3 1.07117e-14
Cconserve1639 vbn_fold net3 2.3215e-16
Cconserve1640 vbn_i net3 2.2221e-16
Cconserve1641 vbp_bias net3 1.20203e-15
Cconserve1642 vbp_i net3 2.7883e-16
Cconserve1643 vbp_tail net3 3.21059e-15
Cconserve1644 vgn2 net3 1.2429e-16
Cconserve1645 vq2 net3 1.153e-16
Cconserve1646 vref net3 1.1361e-16
Cconserve1647 vsp net3 4.0118e-16
Cconserve1648 vsu2 net3 1.3418e-16
Cconserve1649 net4 v1 1.9431e-16
Cconserve1650 v2 net4 1.1332e-16
Cconserve1651 vbn_i net4 5.1306e-16
Cconserve1652 pm2 pm1 4.91378e-15
Cconserve1653 vbp_cas pm1 9.1631e-15
Cconserve1654 vgn2 pm1 1.18258e-15
Cconserve1655 xf1 pm1 2.5267e-16
Cconserve1656 pm1 y1 1.08108e-14
Cconserve1657 pm2 vbn_i 1.7298e-16
Cconserve1658 vbp_cas pm2 9.40883e-15
Cconserve1659 vgn2 pm2 1.54129e-15
Cconserve1660 xf2 pm2 4.5658e-16
Cconserve1661 pm2 y1 8.82479e-15
Cconserve1662 psrg_m3_feed psrg_m3_protected 7.0719e-16
Cconserve1663 psrg_m3_feed psrg_mf1_protected 1.1778e-16
Cconserve1664 psrg_m3_feed psrg_vnc 8.96492e-15
Cconserve1665 psrg_m3_feed v1 2.688e-16
Cconserve1666 psrg_m3_feed v2 1.4733e-16
Cconserve1667 psrg_m3_feed vaux 1.13504e-15
Cconserve1668 psrg_m3_feed vbn 1.6912e-16
Cconserve1669 psrg_m3_feed vbn_i 1.96445e-15
Cconserve1670 psrg_m3_feed vbp_cas 5.05719e-15
Cconserve1671 psrg_m3_feed vbp_i 1.8956e-16
Cconserve1672 psrg_m3_feed vcasp 8.83225e-15
Cconserve1673 psrg_m3_feed vgn1 1.09294e-14
Cconserve1674 psrg_m3_feed vgn2 3.5919e-16
Cconserve1675 psrg_m3_feed vnx_bias 7.1126e-16
Cconserve1676 psrg_m3_feed vref 2.17415e-15
Cconserve1677 psrg_m3_feed vx1 5.51197e-15
Cconserve1678 psrg_m3_feed vx2 5.74429e-15
Cconserve1679 psrg_m3_feed vx3 4.77775e-15
Cconserve1680 psrg_vnc psrg_m3_protected 1.42805e-15
Cconserve1681 psrg_m3_protected v1 6.1706e-16
Cconserve1682 v2 psrg_m3_protected 1.98711e-15
Cconserve1683 vaux psrg_m3_protected 1.2928e-16
Cconserve1684 psrg_m3_protected vgn1 5.6942e-16
Cconserve1685 vgn2 psrg_m3_protected 1.66548e-15
Cconserve1686 psrg_vnc psrg_mf1_protected 8.6885e-16
Cconserve1687 vbn psrg_mf1_protected 1.4469e-16
Cconserve1688 psrg_mf1_protected vbn_fold 1.13136e-15
Cconserve1689 psrg_mf1_protected vbn_i 2.1759e-16
Cconserve1690 psrg_mf1_protected vcasp 1.7385e-16
Cconserve1691 vgn2 psrg_mf1_protected 1.0811e-16
Cconserve1692 psrg_vnc rb_mid 2.6276e-16
Cconserve1693 psrg_vnc v1 2.5631e-16
Cconserve1694 v2 psrg_vnc 8.3259e-16
Cconserve1695 vaux psrg_vnc 1.04986e-15
Cconserve1696 psrg_vnc vbn 1.41477e-14
Cconserve1697 psrg_vnc vbn_i 1.64743e-15
Cconserve1698 psrg_vnc vbp_i 6.7663e-15
Cconserve1699 psrg_vnc vcasp 1.41901e-14
Cconserve1700 psrg_vnc vgn1 4.2512e-16
Cconserve1701 vgn2 psrg_vnc 2.5864e-16
Cconserve1702 vnx_bias psrg_vnc 1.5984e-16
Cconserve1703 psrg_vnc y1 7.2307e-16
Cconserve1704 rb_mid v1 1.7038e-16
Cconserve1705 v2 rb_mid 2.4166e-16
Cconserve1706 vaux rb_mid 2.4947e-16
Cconserve1707 vbn rb_mid 1.6643e-16
Cconserve1708 rb_mid vbn_i 1.82048e-15
Cconserve1709 rb_mid vbp_i 1.8995e-16
Cconserve1710 rb_mid vbp_tail 6.1251e-16
Cconserve1711 rb_mid vcasp 4.1312e-16
Cconserve1712 vnx_bias rb_mid 1.3229e-16
Cconserve1713 vsu1 rb_mid 1.5385e-16
Cconserve1714 rbit0top rbit1top 1.74997e-14
Cconserve1715 rbit0top rbit2top 1.73035e-15
Cconserve1716 rbit0top rbit3top 1.9853e-16
Cconserve1717 rbit0top rbit5top 1.9532e-16
Cconserve1718 rbit0top rbit6top 1.802e-16
Cconserve1719 rbit0top rfix0 2.0304e-16
Cconserve1720 rbit0top rfix1 2.3203e-16
Cconserve1721 rbit0top rfix2 2.4932e-16
Cconserve1722 rbit0top vq3 4.3158e-16
Cconserve1723 vref rbit0top 2.59934e-15
Cconserve1724 rbit2top rbit1top 9.86141e-15
Cconserve1725 rbit3top rbit1top 1.245e-16
Cconserve1726 rbit1top vq3 7.4463e-16
Cconserve1727 vref rbit1top 2.44423e-15
Cconserve1728 rbit3top rbit2top 5.74144e-15
Cconserve1729 rbit4top rbit2top 1.33249e-15
Cconserve1730 rbit5top rbit2top 1.3796e-16
Cconserve1731 rbit6top rbit2top 2.7768e-16
Cconserve1732 rfix0 rbit2top 4.6931e-16
Cconserve1733 rfix1 rbit2top 4.7013e-16
Cconserve1734 rfix2 rbit2top 4.7492e-16
Cconserve1735 vbn_i rbit2top 1.6636e-16
Cconserve1736 rbit2top vq3 5.1692e-16
Cconserve1737 vref rbit2top 2.42452e-15
Cconserve1738 rbit4top rbit3top 4.12866e-15
Cconserve1739 rbit3top rbit5top 5.75012e-15
Cconserve1740 rbit3top rbit6top 7.3333e-16
Cconserve1741 rbit3top vq3 1.08791e-15
Cconserve1742 vref rbit3top 1.028e-16
Cconserve1743 rbit4top rbit5top 2.58032e-15
Cconserve1744 rbit4top rbit6top 5.9917e-16
Cconserve1745 rfix0 rbit4top 5.693e-16
Cconserve1746 rbit4top vq3 2.5004e-16
Cconserve1747 vref rbit4top 2.2388e-16
Cconserve1748 rbit5top rbit6top 1.10162e-15
Cconserve1749 rbit5top vq3 3.7529e-16
Cconserve1750 vref rbit5top 1.0632e-16
Cconserve1751 rfix0 rbit6top 2.51098e-15
Cconserve1752 rbit6top vq3 1.81815e-15
Cconserve1753 vref rbit6top 1.484e-16
Cconserve1754 rfix0 rfix1 1.2694e-16
Cconserve1755 rfix0 vq3 4.8937e-16
Cconserve1756 vref rfix0 4.8258e-16
Cconserve1757 rfix1 rfix2 1.2712e-16
Cconserve1758 vref rfix1 4.8168e-16
Cconserve1759 rfix2 vq3 1.9915e-16
Cconserve1760 vref rfix2 4.8703e-16
Cconserve1761 vbn su_state 1.4211e-16
Cconserve1762 su_state vbn_fold 5.4084e-16
Cconserve1763 su_state vbn_i 4.9605e-16
Cconserve1764 vbn_sink su_state 1.2828e-16
Cconserve1765 vbp_bias su_state 1.0293e-15
Cconserve1766 su_state vbp_i 1.9864e-16
Cconserve1767 vbp_tail su_state 4.41393e-15
Cconserve1768 vgn2 su_state 1.80937e-15
Cconserve1769 su_state vq2 1.4322e-16
Cconserve1770 su_state vq3 1.0044e-16
Cconserve1771 vref su_state 1.6807e-16
Cconserve1772 vsp su_state 3.1701e-16
Cconserve1773 vsu su_state 2.468e-16
Cconserve1774 v2 v1 1.86242e-14
Cconserve1775 vaux v1 9.0149e-16
Cconserve1776 vbn_i v1 3.9536e-16
Cconserve1777 vbp_bias v1 1.3071e-15
Cconserve1778 vbp_cas v1 2.35996e-15
Cconserve1779 vbp_i v1 1.3447e-16
Cconserve1780 vbp_tail v1 4.0675e-16
Cconserve1781 vcasp v1 9.4113e-16
Cconserve1782 vgn1 v1 2.18705e-15
Cconserve1783 vgn2 v1 3.0453e-16
Cconserve1784 vnx_bias v1 1.3281e-16
Cconserve1785 vq2 v1 4.327e-16
Cconserve1786 vq3 v1 4.8977e-16
Cconserve1787 vsp v1 1.0877e-14
Cconserve1788 vsu2 v1 7.1014e-16
Cconserve1789 xf1 v1 1.08469e-14
Cconserve1790 xf2 v1 8.5722e-16
Cconserve1791 vaux v2 1.7419e-16
Cconserve1792 v2 vbn_i 6.5383e-16
Cconserve1793 v2 vbp_bias 4.0782e-16
Cconserve1794 v2 vbp_cas 2.26622e-15
Cconserve1795 v2 vbp_i 1.20932e-15
Cconserve1796 v2 vbp_tail 2.0576e-16
Cconserve1797 v2 vcasp 4.9384e-16
Cconserve1798 v2 vgn1 2.08526e-15
Cconserve1799 v2 vgn2 3.00028e-15
Cconserve1800 v2 vnx_bias 1.2642e-16
Cconserve1801 v2 vsp 1.10642e-14
Cconserve1802 v2 vsu1 1.1888e-16
Cconserve1803 v2 vsu2 7.1053e-16
Cconserve1804 v2 xf1 1.25868e-15
Cconserve1805 v2 xf2 1.15641e-14
Cconserve1806 vaux vbp_i 3.4518e-16
Cconserve1807 vaux vcasp 5.42532e-15
Cconserve1808 vaux vnx_bias 1.1873e-16
Cconserve1809 vbn vcasp 2.53988e-15
Cconserve1810 vbn vsu 3.5311e-16
Cconserve1811 vbn_i vbn_fold 2.7506e-16
Cconserve1812 vbn_sink vbn_fold 3.89325e-15
Cconserve1813 vbp_i vbn_fold 1.28191e-14
Cconserve1814 vbp_tail vbn_fold 5.0114e-16
Cconserve1815 vcasp vbn_fold 6.3195e-16
Cconserve1816 vgn2 vbn_fold 2.45922e-15
Cconserve1817 vnx_bias vbn_fold 3.59657e-15
Cconserve1818 vbn_fold vq3 2.09264e-15
Cconserve1819 vref vbn_fold 5.4296e-16
Cconserve1820 vsu vbn_fold 1.15965e-15
Cconserve1821 vsua vbn_fold 3.3308e-16
Cconserve1822 xf1 vbn_fold 4.275e-15
Cconserve1823 xf2 vbn_fold 1.19048e-15
Cconserve1824 y1 vbn_fold 1.6495e-16
Cconserve1825 vbp_i vbn_i 7.65063e-15
Cconserve1826 vbp_tail vbn_i 1.51389e-15
Cconserve1827 vcasp vbn_i 2.4227e-16
Cconserve1828 vgn1 vbn_i 1.52543e-14
Cconserve1829 vgn2 vbn_i 1.16074e-15
Cconserve1830 vnx_bias vbn_i 4.3608e-15
Cconserve1831 vbn_i vq3 2.5919e-16
Cconserve1832 vref vbn_i 1.5089e-16
Cconserve1833 vsu2 vbn_i 3.0498e-16
Cconserve1834 vbn_sink vbp_i 1.8381e-14
Cconserve1835 vbn_sink vbp_tail 2.38604e-15
Cconserve1836 vgn2 vbn_sink 1.02932e-15
Cconserve1837 vbn_sink vq3 1.9963e-16
Cconserve1838 xf1 vbn_sink 6.56293e-15
Cconserve1839 xf2 vbn_sink 6.71667e-15
Cconserve1840 vbp_cas vbp_bias 1.45859e-14
Cconserve1841 vbp_bias vbp_i 3.5309e-16
Cconserve1842 vbp_bias vbp_tail 9.6899e-16
Cconserve1843 vref vbp_bias 1.13648e-15
Cconserve1844 vbp_cas vbp_i 4.1282e-16
Cconserve1845 vbp_cas vcasp 3.14978e-15
Cconserve1846 vbp_cas vgn1 1.53672e-15
Cconserve1847 vgn2 vbp_cas 9.81598e-15
Cconserve1848 vbp_cas y1 8.24885e-15
Cconserve1849 vbp_tail vbp_i 2.59405e-15
Cconserve1850 vcasp vbp_i 8.1571e-16
Cconserve1851 vgn2 vbp_i 2.1338e-16
Cconserve1852 vbp_i vq3 3.8823e-16
Cconserve1853 vref vbp_i 2.6276e-16
Cconserve1854 vsu1 vbp_i 3.328e-16
Cconserve1855 vsu2 vbp_i 1.93283e-15
Cconserve1856 vcasp vbp_tail 5.3827e-16
Cconserve1857 vbp_tail vq2 5.1793e-16
Cconserve1858 vbp_tail vq3 5.4049e-16
Cconserve1859 vref vbp_tail 2.93673e-15
Cconserve1860 vsp vbp_tail 7.83306e-15
Cconserve1861 vsu2 vbp_tail 1.18175e-15
Cconserve1862 vcasp vgn1 5.27291e-15
Cconserve1863 vgn2 vcasp 3.8385e-16
Cconserve1864 vnx_bias vcasp 7.9133e-16
Cconserve1865 vref vcasp 8.70622e-15
Cconserve1866 vsu1 vcasp 7.7783e-16
Cconserve1867 vsu2 vcasp 2.8319e-16
Cconserve1868 vsua vcasp 3.8806e-16
Cconserve1869 vcasp vx1 5.11514e-15
Cconserve1870 vcasp vx2 5.49619e-15
Cconserve1871 vx3 vcasp 5.64491e-15
Cconserve1872 vgn2 vgn1 5.07749e-15
Cconserve1873 vref vgn1 1.04938e-15
Cconserve1874 vx1 vgn1 3.76652e-15
Cconserve1875 vgn1 vx2 7.2762e-16
Cconserve1876 vx3 vgn1 1.01119e-15
Cconserve1877 vnx_bias vgn2 4.6695e-16
Cconserve1878 vgn2 xf1 1.1941e-15
Cconserve1879 vgn2 xf2 1.4832e-15
Cconserve1880 vgn2 y1 1.33328e-15
Cconserve1881 vnx_bias vsu1 6.1064e-16
Cconserve1882 vq3 vq2 1.38448e-15
Cconserve1883 vref vq3 3.56054e-14
Cconserve1884 vref vx1 7.335e-16
Cconserve1885 vref vx2 9.3047e-16
Cconserve1886 vx3 vref 2.39972e-15
Cconserve1887 vsp xf1 4.97169e-15
Cconserve1888 vsp xf2 4.80498e-15
Cconserve1889 vsua vsu 4.5111e-16
Cconserve1890 y1 vsu 1.1928e-16
Cconserve1891 y1 vsua 1.3441e-16
Cconserve1892 vx1 vx2 6.69267e-15
Cconserve1893 vx3 vx1 6.5981e-15
Cconserve1894 vx3 vx2 2.72171e-15
Cconserve1895 xf2 xf1 1.53018e-14
.ends Bandgap_Core_Res
