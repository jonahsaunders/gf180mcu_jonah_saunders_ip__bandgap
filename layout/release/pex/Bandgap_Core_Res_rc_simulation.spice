* NGSPICE file created from Bandgap_Core_Res.ext - technology: gf180mcuD

.subckt Bandgap_Core_Res avdd avss vref b0 b1 b2 b3 b4 b5 b6 dvss dvdd
Xpnp_05p00x05p00_0 avss avss vq3 pnp_05p00x05p00
Xpnp_05p00x05p00_1 avss avss vq2 pnp_05p00x05p00
Xpnp_05p00x05p00_2 avss avss vq2 pnp_05p00x05p00
Xpnp_05p00x05p00_4 avss avss vq2 pnp_05p00x05p00
Xpnp_05p00x05p00_3 avss avss vq2 pnp_05p00x05p00
Xpnp_05p00x05p00_5 avss avss v1 pnp_05p00x05p00
Xpnp_05p00x05p00_6 avss avss vq2 pnp_05p00x05p00
Xpnp_05p00x05p00_7 avss avss vq2 pnp_05p00x05p00
Xpnp_05p00x05p00_8 avss avss vq2 pnp_05p00x05p00
Xpnp_05p00x05p00_9 avss avss vq2 pnp_05p00x05p00
Xnwell_0 net3 net4 avss nwell r_length=20.19u r_width=2u
X0 rbit0top.t9 b0.t2 rbit1top.t8 dvss nfet_03v3 ad=17.6p pd=80.88u as=17.6p ps=80.88u w=40u l=0.28u
X1 avdd.t745 avdd.t742 avdd.t744 avdd.t743 pfet_05v0 ad=24.1516p pd=0.11066m as=0 ps=0 w=54.89u l=4u
X2 avss avss avss avss nfet_05v0 ad=3.322p pd=15.98u as=0.92119n ps=4.32012m w=7.55u l=4u M=10
X3 avss avss avss avss nfet_05v0 ad=7.1896p pd=33.56u as=0 ps=0 w=16.34u l=8u M=20
X4 avdd.t394 avdd.t391 avdd.t393 avdd.t392 pfet_05v0 ad=7.2248p pd=33.72u as=0 ps=0 w=16.42u l=4u
X5 vbn_sink.t11 vbp_i.t32 avdd.t61 avdd.t60 pfet_05v0 ad=8.338p pd=38.78u as=8.338p ps=38.78u w=18.95u l=8u
X6 vbn_sink.t13 vbp_i.t24 avdd.t69 avdd.t68 pfet_05v0 ad=8.338p pd=38.78u as=8.338p ps=38.78u w=18.95u l=8u
X7 avdd.t450 avdd.t447 avdd.t449 avdd.t448 pfet_05v0 ad=7.37p pd=34.38u as=0 ps=0 w=16.75u l=2u
X8 avdd.t474 avdd.t471 avdd.t473 avdd.t472 pfet_05v0 ad=7.37p pd=34.38u as=0 ps=0 w=16.75u l=2u
X9 vbn_sink.t12 vbp_i.t33 avdd.t63 avdd.t62 pfet_05v0 ad=8.338p pd=38.78u as=8.338p ps=38.78u w=18.95u l=8u
X10 avdd.t278 avdd.t275 avdd.t277 avdd.t276 pfet_05v0 ad=8.3556p pd=38.86u as=0 ps=0 w=18.99u l=8u
X11 vbn_fold.t11 vbp_i.t47 avdd.t892 avdd.t891 pfet_05v0 ad=8.3556p pd=38.86u as=8.3556p ps=38.86u w=18.99u l=8u
X12 b3_b.t0 b3.t0 dvdd.t27 dvdd.t26 pfet_03v3 ad=1.32p pd=6.88u as=1.32p ps=6.88u w=3u l=0.5u
X13 vx1.t4 psrg_m3_feed.t13 avdd.t1048 avdd.t1047 pfet_05v0 ad=7.37p pd=34.38u as=7.37p ps=34.38u w=16.75u l=2u
X14 rbit3top.t4 b2_b.t3 rbit2top.t4 dvdd.t23 pfet_03v3 ad=8.8p pd=40.88u as=8.8p ps=40.88u w=20u l=0.28u
X15 pm1.t6 y1.t13 avdd.t948 avdd.t947 pfet_05v0 ad=9.1344p pd=42.4u as=9.1344p ps=42.4u w=20.76u l=4u
X16 vbn.t1 vbn.t0 avss avss nfet_05v0 ad=3.322p pd=15.98u as=3.322p ps=15.98u w=7.55u l=4u
X17 avdd.t210 avdd.t207 avdd.t209 avdd.t208 pfet_05v0 ad=8.25p pd=38.38u as=0 ps=0 w=18.75u l=8u
X18 avdd.t298 avdd.t295 avdd.t297 avdd.t296 pfet_05v0 ad=8.338p pd=38.78u as=0 ps=0 w=18.95u l=8u
X19 vgn2.t0 vbn_fold.t14 xf2.t0 avss nfet_05v0 ad=8.1356p pd=37.86u as=8.1356p ps=37.86u w=18.49u l=6u
X20 vbp_cas.t20 vbn_i.t11 avss avss nfet_05v0 ad=0.286p pd=2.18u as=0.286p ps=2.18u w=0.65u l=8u
X21 vbn_i.t6 vbp_i.t52 avdd.t894 avdd.t893 pfet_05v0 ad=8.25p pd=38.38u as=8.25p ps=38.38u w=18.75u l=8u
X22 avdd.t442 avdd.t439 avdd.t441 avdd.t440 pfet_05v0 ad=7.2248p pd=33.72u as=0 ps=0 w=16.42u l=4u
X23 vgn2.t1 vbp_cas.t32 pm2.t2 avdd.t966 pfet_05v0 ad=9.7724p pd=45.3u as=9.7724p ps=45.3u w=22.21u l=8u
X24 avdd.t626 avdd.t623 avdd.t625 avdd.t624 pfet_05v0 ad=7.2248p pd=33.72u as=0 ps=0 w=16.42u l=4u
X25 avdd.t861 avdd.t858 avdd.t860 avdd.t859 pfet_05v0 ad=9.1344p pd=42.4u as=0 ps=0 w=20.76u l=4u
X26 avdd.t638 avdd.t635 avdd.t637 avdd.t636 pfet_05v0 ad=7.37p pd=34.38u as=0 ps=0 w=16.75u l=2u
X27 avdd.t206 avdd.t203 avdd.t205 avdd.t204 pfet_05v0 ad=8.25p pd=38.38u as=0 ps=0 w=18.75u l=8u
X28 avdd.t294 avdd.t291 avdd.t293 avdd.t292 pfet_05v0 ad=8.338p pd=38.78u as=0 ps=0 w=18.95u l=8u
X29 avdd.t514 avdd.t511 avdd.t513 avdd.t512 pfet_05v0 ad=24.1516p pd=0.11066m as=0 ps=0 w=54.89u l=4u
X30 vbn_fold.t13 vbn_fold.t12 vnx_bias avss nfet_05v0 ad=2.0328p pd=10.12u as=2.0328p ps=10.12u w=4.62u l=6u
X31 xf1.t5 vbn_sink.t23 avss avss nfet_05v0 ad=7.1896p pd=33.56u as=7.1896p ps=33.56u w=16.34u l=8u
X32 vgn1.t9 aux_gate psrg_m3_feed.t7 avdd.t1013 pfet_05v0 ad=0.88p pd=4.88u as=0.88p ps=4.88u w=2u l=2u
X33 rbit6top.t2 b5_b.t2 rbit5top.t2 dvdd.t5 pfet_03v3 ad=3.3p pd=15.88u as=3.3p ps=15.88u w=7.5u l=0.28u
X34 avdd.t757 avdd.t754 avdd.t756 avdd.t755 pfet_05v0 ad=9.7724p pd=45.3u as=0 ps=0 w=22.21u l=8u
X35 avdd.t106 avdd.t103 avdd.t105 avdd.t104 pfet_05v0 ad=8.25p pd=38.38u as=0 ps=0 w=18.75u l=8u
X36 rbit4top.t4 rbit3top.t6 avss ppolyf_u_1k r_width=6.6u r_length=16u
X37 avss avss avss avss nfet_05v0 ad=6.424p pd=30.08u as=0 ps=0 w=14.6u l=4u M=14
X38 vx3.t2 psrg_m3_feed.t26 avdd.t896 avdd.t895 pfet_05v0 ad=7.37p pd=34.38u as=7.37p ps=34.38u w=16.75u l=2u
X39 avdd.t821 avdd.t818 avdd.t820 avdd.t819 pfet_05v0 ad=9.7724p pd=45.3u as=0 ps=0 w=22.21u l=8u
X40 avdd.t550 avdd.t547 avdd.t549 avdd.t548 pfet_05v0 ad=7.37p pd=34.38u as=0 ps=0 w=16.75u l=2u
X41 avdd.t102 avdd.t99 avdd.t101 avdd.t100 pfet_05v0 ad=8.25p pd=38.38u as=0 ps=0 w=18.75u l=8u
X42 avdd.t454 avdd.t451 avdd.t453 avdd.t452 pfet_05v0 ad=7.37p pd=34.38u as=0 ps=0 w=16.75u l=2u
X43 vaux.t1 psrg_m3_feed.t28 avdd.t900 avdd.t899 pfet_05v0 ad=4.4p pd=20.88u as=4.4p ps=20.88u w=10u l=2u
X44 vbn.t3 aux_gate avdd.t1012 avdd.t1011 pfet_05v0 ad=0.22p pd=1.88u as=0.22p ps=1.88u w=0.5u l=8u
X45 avdd.t709 avdd.t706 avdd.t708 avdd.t707 pfet_05v0 ad=24.1516p pd=0.11066m as=0 ps=0 w=54.89u l=4u
X46 avdd.t506 avdd.t503 avdd.t505 avdd.t504 pfet_05v0 ad=24.1516p pd=0.11066m as=0 ps=0 w=54.89u l=4u
X47 rfix2 rfix1 avss ppolyf_u_1k r_width=6.6u r_length=0.128m
X48 avdd.t218 avdd.t215 avdd.t217 avdd.t216 pfet_05v0 ad=8.25p pd=38.38u as=0 ps=0 w=18.75u l=8u
X49 avdd.t853 avdd.t850 avdd.t852 avdd.t851 pfet_05v0 ad=9.1344p pd=42.4u as=0 ps=0 w=20.76u l=4u
X50 vref.t0 vcasp vx3.t5 avdd.t995 pfet_05v0 ad=7.2248p pd=33.72u as=7.2248p ps=33.72u w=16.42u l=4u
X51 avdd.t406 avdd.t403 avdd.t405 avdd.t404 pfet_05v0 ad=7.2248p pd=33.72u as=0 ps=0 w=16.42u l=4u
X52 rbit6top.t3 rbit5top.t5 avss ppolyf_u_1k r_width=6.6u r_length=64u
X53 psrg_vnc.t8 psrg_vnc.t7 rb_mid avss nfet_05v0 ad=0.3124p pd=2.3u as=0.3124p ps=2.3u w=0.71u l=20u
X54 avdd.t713 avdd.t710 avdd.t712 avdd.t711 pfet_05v0 ad=24.1516p pd=0.11066m as=0 ps=0 w=54.89u l=4u
X55 vx2.t2 psrg_m3_feed.t18 avdd.t3 avdd.t2 pfet_05v0 ad=7.37p pd=34.38u as=7.37p ps=34.38u w=16.75u l=2u
X56 avdd.t114 avdd.t111 avdd.t113 avdd.t112 pfet_05v0 ad=8.25p pd=38.38u as=0 ps=0 w=18.75u l=8u
X57 avdd.t690 avdd.t687 avdd.t689 avdd.t688 pfet_05v0 ad=9.7724p pd=45.3u as=0 ps=0 w=22.21u l=8u
X58 pm1.t8 y1.t9 avdd.t928 avdd.t927 pfet_05v0 ad=9.1344p pd=42.4u as=9.1344p ps=42.4u w=20.76u l=4u
X59 avdd.t594 avdd.t591 avdd.t593 avdd.t592 pfet_05v0 ad=7.37p pd=34.38u as=0 ps=0 w=16.75u l=2u
X60 avdd.t274 avdd.t271 avdd.t273 avdd.t272 pfet_05v0 ad=8.3556p pd=38.86u as=0 ps=0 w=18.99u l=8u
X61 avdd.t322 avdd.t319 avdd.t321 avdd.t320 pfet_05v0 ad=8.338p pd=38.78u as=0 ps=0 w=18.95u l=8u
X62 avdd.t358 avdd.t355 avdd.t357 avdd.t356 pfet_05v0 ad=8.338p pd=38.78u as=0 ps=0 w=18.95u l=8u
X63 avdd.t610 avdd.t607 avdd.t609 avdd.t608 pfet_05v0 ad=7.2248p pd=33.72u as=0 ps=0 w=16.42u l=4u
X64 psrg_m3_feed.t3 vcasp vx2.t6 avdd.t992 pfet_05v0 ad=7.2248p pd=33.72u as=7.2248p ps=33.72u w=16.42u l=4u
X65 pm1.t7 y1.t12 avdd.t946 avdd.t945 pfet_05v0 ad=9.1344p pd=42.4u as=9.1344p ps=42.4u w=20.76u l=4u
X66 vx2.t0 psrg_m3_feed.t25 avdd.t888 avdd.t887 pfet_05v0 ad=7.37p pd=34.38u as=7.37p ps=34.38u w=16.75u l=2u
X67 avdd.t538 avdd.t535 avdd.t537 avdd.t536 pfet_05v0 ad=7.2248p pd=33.72u as=0 ps=0 w=16.42u l=4u
X68 avdd.t270 avdd.t267 avdd.t269 avdd.t268 pfet_05v0 ad=8.3556p pd=38.86u as=0 ps=0 w=18.99u l=8u
X69 avdd.t318 avdd.t315 avdd.t317 avdd.t316 pfet_05v0 ad=8.338p pd=38.78u as=0 ps=0 w=18.95u l=8u
X70 avdd.t354 avdd.t351 avdd.t353 avdd.t352 pfet_05v0 ad=8.338p pd=38.78u as=0 ps=0 w=18.95u l=8u
X71 b2_b.t0 b2.t0 dvdd.t9 dvdd.t8 pfet_03v3 ad=1.32p pd=6.88u as=1.32p ps=6.88u w=3u l=0.5u
X72 avdd.t630 avdd.t627 avdd.t629 avdd.t628 pfet_05v0 ad=7.37p pd=34.38u as=0 ps=0 w=16.75u l=2u
X73 avdd.t670 avdd.t667 avdd.t669 avdd.t668 pfet_05v0 ad=24.1516p pd=0.11066m as=0 ps=0 w=54.89u l=4u
X74 y1.t0 vbp_cas.t26 pm1.t0 avdd.t953 pfet_05v0 ad=9.7724p pd=45.3u as=9.7724p ps=45.3u w=22.21u l=8u
X75 avdd.t833 avdd.t830 avdd.t832 avdd.t831 pfet_05v0 ad=9.7724p pd=45.3u as=0 ps=0 w=22.21u l=8u
X76 avss avss avss avss nfet_05v0 ad=5.4164p pd=25.5u as=0 ps=0 w=12.31u l=8u M=10
X77 b5_b.t0 b5.t0 dvdd.t1 dvdd.t0 pfet_03v3 ad=1.32p pd=6.88u as=1.32p ps=6.88u w=3u l=0.5u
X78 avss avss avss avss nfet_05v0 ad=8.1356p pd=37.86u as=0 ps=0 w=18.49u l=6u M=10
X79 avdd.t494 avdd.t491 avdd.t493 avdd.t492 pfet_05v0 ad=24.1516p pd=0.11066m as=0 ps=0 w=54.89u l=4u
X80 vbp_i.t10 vbp_i.t9 avdd.t1033 avdd.t1032 pfet_05v0 ad=8.25p pd=38.38u as=8.25p ps=38.38u w=18.75u l=8u
X81 vbp_bias.t11 vbp_bias.t10 avdd.t9 avdd.t8 pfet_03v3 ad=8.3864p pd=39u as=8.3864p ps=39u w=19.06u l=8u
X82 avdd.t202 avdd.t199 avdd.t201 avdd.t200 pfet_05v0 ad=8.25p pd=38.38u as=0 ps=0 w=18.75u l=8u
X83 avdd.t777 avdd.t774 avdd.t776 avdd.t775 pfet_05v0 ad=9.1344p pd=42.4u as=0 ps=0 w=20.76u l=4u
X84 vbp_bias.t27 vbp_bias.t26 avdd.t912 avdd.t911 pfet_03v3 ad=8.3864p pd=39u as=8.3864p ps=39u w=19.06u l=8u
X85 xf2.t10 vbn_sink.t24 avss avss nfet_05v0 ad=7.1896p pd=33.56u as=7.1896p ps=33.56u w=16.34u l=8u
X86 vref.t11 avss cap_mim_2f0fF c_width=70.7u c_length=70.7u
X87 vbn_sink.t0 vbp_i.t28 avdd.t19 avdd.t18 pfet_05v0 ad=8.338p pd=38.78u as=8.338p ps=38.78u w=18.95u l=8u
X88 vbn_fold.t1 vbp_i.t41 avdd.t13 avdd.t12 pfet_05v0 ad=8.3556p pd=38.86u as=8.3556p ps=38.86u w=18.99u l=8u
X89 rbit1top.t5 b0_b.t3 rbit0top.t2 dvdd.t15 pfet_03v3 ad=17.6p pd=80.88u as=17.6p ps=80.88u w=40u l=0.28u
X90 avdd.t865 avdd.t862 avdd.t864 avdd.t863 pfet_05v0 ad=9.1344p pd=42.4u as=0 ps=0 w=20.76u l=4u
X91 vbn_i.t5 iref_gate.t3 avdd.t932 avdd.t931 pfet_05v0 ad=0.22p pd=1.88u as=0.22p ps=1.88u w=0.5u l=8u
X92 vref.t6 avss cap_mim_2f0fF c_width=70.7u c_length=70.7u
X93 avdd.t310 avdd.t307 avdd.t309 avdd.t308 pfet_05v0 ad=8.338p pd=38.78u as=0 ps=0 w=18.95u l=8u
X94 avdd.t346 avdd.t343 avdd.t345 avdd.t344 pfet_05v0 ad=8.338p pd=38.78u as=0 ps=0 w=18.95u l=8u
X95 avdd.t98 avdd.t95 avdd.t97 avdd.t96 pfet_05v0 ad=8.25p pd=38.38u as=0 ps=0 w=18.75u l=8u
X96 iref_gate.t1 vbp_i.t21 vsu1 avss nfet_05v0 ad=0.22p pd=1.88u as=0.22p ps=1.88u w=0.5u l=50u
X97 vgn2.t2 vbp_cas.t29 pm2.t1 avdd.t956 pfet_05v0 ad=9.7724p pd=45.3u as=9.7724p ps=45.3u w=22.21u l=8u
X98 vbn_fold.t4 vbp_i.t51 avdd.t59 avdd.t58 pfet_05v0 ad=8.3556p pd=38.86u as=8.3556p ps=38.86u w=18.99u l=8u
X99 rbit0top.t0 rfix2 avss ppolyf_u_1k r_width=6.6u r_length=0.128m
X100 vsp.t4 vbp_tail.t12 avdd.t916 avdd.t915 pfet_03v3 ad=12.7204p pd=58.7u as=12.7204p ps=58.7u w=28.91u l=6u
X101 avdd.t606 avdd.t603 avdd.t605 avdd.t604 pfet_05v0 ad=7.2248p pd=33.72u as=0 ps=0 w=16.42u l=4u
X102 rbit4top.t2 b3_b.t2 rbit3top.t1 dvdd.t2 pfet_03v3 ad=13.2p pd=60.88u as=13.2p ps=60.88u w=30u l=0.28u
X103 avdd.t438 avdd.t435 avdd.t437 avdd.t436 pfet_05v0 ad=7.2248p pd=33.72u as=0 ps=0 w=16.42u l=4u
X104 su_state.t0 vsu avdd.t88 avdd.t87 pfet_05v0 ad=0.44p pd=2.88u as=0.44p ps=2.88u w=1u l=8u
X105 xf1.t3 vbn_sink.t27 avss avss nfet_05v0 ad=7.1896p pd=33.56u as=7.1896p ps=33.56u w=16.34u l=8u
X106 avdd.t194 avdd.t191 avdd.t193 avdd.t192 pfet_05v0 ad=8.3556p pd=38.86u as=0 ps=0 w=18.99u l=8u
X107 rbit5top.t1 b4_b.t2 rbit4top.t0 dvdd.t4 pfet_03v3 ad=6.6p pd=30.88u as=6.6p ps=30.88u w=15u l=0.28u
X108 avdd.t382 avdd.t379 avdd.t381 avdd.t380 pfet_05v0 ad=8.338p pd=38.78u as=0 ps=0 w=18.95u l=8u
X109 vbn_i.t4 vbp_i.t54 avdd.t77 avdd.t76 pfet_05v0 ad=8.25p pd=38.38u as=8.25p ps=38.38u w=18.75u l=8u
X110 xf2.t4 vbn_sink.t28 avss avss nfet_05v0 ad=7.1896p pd=33.56u as=7.1896p ps=33.56u w=16.34u l=8u
X111 avdd.t881 avdd.t878 avdd.t880 avdd.t879 pfet_05v0 ad=9.1344p pd=42.4u as=0 ps=0 w=20.76u l=4u
X112 avdd.t618 avdd.t615 avdd.t617 avdd.t616 pfet_05v0 ad=7.2248p pd=33.72u as=0 ps=0 w=16.42u l=4u
X113 xf1.t8 v1.t3 vsp.t11 avdd.t1028 pfet_05v0 ad=24.1516p pd=0.11066m as=24.1516p ps=0.11066m w=54.89u l=4u
X114 rbit2top.t7 b1_b.t4 rbit1top.t12 dvdd.t12 pfet_03v3 ad=17.6p pd=80.88u as=17.6p ps=80.88u w=40u l=0.28u
X115 psrg_m3_feed.t1 psrg_vnc.t10 psrg_m3_protected.t2 avss nfet_05v0 ad=6.424p pd=30.08u as=6.424p ps=30.08u w=14.6u l=4u
X116 avdd.t378 avdd.t375 avdd.t377 avdd.t376 pfet_05v0 ad=8.338p pd=38.78u as=0 ps=0 w=18.95u l=8u
X117 rbit4top.t1 b4.t2 rbit5top.t3 dvss nfet_03v3 ad=2.2p pd=10.88u as=2.2p ps=10.88u w=5u l=0.28u
X118 avdd.t170 avdd.t167 avdd.t169 avdd.t168 pfet_05v0 ad=8.3556p pd=38.86u as=0 ps=0 w=18.99u l=8u
X119 vbn_sink.t18 vbn_sink.t17 avss avss nfet_05v0 ad=5.4164p pd=25.5u as=5.4164p ps=25.5u w=12.31u l=8u
X120 avdd.t522 avdd.t519 avdd.t521 avdd.t520 pfet_05v0 ad=24.1516p pd=0.11066m as=0 ps=0 w=54.89u l=4u
X121 avdd.t426 avdd.t423 avdd.t425 avdd.t424 pfet_05v0 ad=7.2248p pd=33.72u as=0 ps=0 w=16.42u l=4u
X122 vbp_tail.t3 vbp_tail.t2 avdd.t920 avdd.t919 pfet_03v3 ad=6.05p pd=28.38u as=6.05p ps=28.38u w=13.75u l=6u
X123 avdd.t542 avdd.t539 avdd.t541 avdd.t540 pfet_05v0 ad=7.2248p pd=33.72u as=0 ps=0 w=16.42u l=4u
X124 avdd.t717 avdd.t714 avdd.t716 avdd.t715 pfet_05v0 ad=24.1516p pd=0.11066m as=0 ps=0 w=54.89u l=4u
X125 vbp_cas.t17 vbp_cas.t16 vbp_bias.t4 avdd.t974 pfet_05v0 ad=8.3292p pd=38.74u as=8.3292p ps=38.74u w=18.93u l=8u
X126 pm2.t3 y1.t18 avdd.t963 avdd.t962 pfet_05v0 ad=9.1344p pd=42.4u as=9.1344p ps=42.4u w=20.76u l=4u
X127 avdd.t458 avdd.t455 avdd.t457 avdd.t456 pfet_05v0 ad=7.37p pd=34.38u as=0 ps=0 w=16.75u l=2u
X128 xf2.t2 v2.t5 vsp.t1 avdd.t65 pfet_05v0 ad=24.1516p pd=0.11066m as=24.1516p ps=0.11066m w=54.89u l=4u
X129 vaux.t0 psrg_m3_feed.t27 avdd.t898 avdd.t897 pfet_05v0 ad=4.4p pd=20.88u as=4.4p ps=20.88u w=10u l=2u
X130 avdd.t825 avdd.t822 avdd.t824 avdd.t823 pfet_05v0 ad=9.7724p pd=45.3u as=0 ps=0 w=22.21u l=8u
X131 su_state.t1 vbp_tail.t13 avdd.t92 avdd.t91 pfet_05v0 ad=0.44p pd=2.88u as=0.44p ps=2.88u w=1u l=8u
X132 avdd.t705 avdd.t703 avdd.t705 avdd.t704 pfet_05v0 ad=24.1516p pd=0.11066m as=0 ps=0 w=54.89u l=4u
X133 avdd.t390 avdd.t387 avdd.t389 avdd.t388 pfet_05v0 ad=7.2248p pd=33.72u as=0 ps=0 w=16.42u l=4u
X134 avdd.t873 avdd.t870 avdd.t872 avdd.t871 pfet_05v0 ad=9.1344p pd=42.4u as=0 ps=0 w=20.76u l=4u
X135 avdd.t350 avdd.t347 avdd.t349 avdd.t348 pfet_05v0 ad=8.338p pd=38.78u as=0 ps=0 w=18.95u l=8u
X136 pm2.t6 y1.t11 avdd.t976 avdd.t975 pfet_05v0 ad=9.1344p pd=42.4u as=9.1344p ps=42.4u w=20.76u l=4u
X137 avdd.t554 avdd.t551 avdd.t553 avdd.t552 pfet_05v0 ad=7.2248p pd=33.72u as=0 ps=0 w=16.42u l=4u
X138 avdd.t602 avdd.t599 avdd.t601 avdd.t600 pfet_05v0 ad=7.2248p pd=33.72u as=0 ps=0 w=16.42u l=4u
X139 psrg_vnc.t0 vbp_i.t18 avdd.t15 avdd.t14 pfet_05v0 ad=7.8056p pd=36.36u as=7.8056p ps=36.36u w=17.74u l=4u
X140 avdd.t246 avdd.t243 avdd.t245 avdd.t244 pfet_05v0 ad=8.25p pd=38.38u as=0 ps=0 w=18.75u l=8u
X141 avdd.t370 avdd.t367 avdd.t369 avdd.t368 pfet_05v0 ad=8.338p pd=38.78u as=0 ps=0 w=18.95u l=8u
X142 xf1.t2 vbn_sink.t31 avss avss nfet_05v0 ad=7.1896p pd=33.56u as=7.1896p ps=33.56u w=16.34u l=8u
X143 vbn_sink.t6 vbp_i.t23 avdd.t49 avdd.t48 pfet_05v0 ad=8.338p pd=38.78u as=8.338p ps=38.78u w=18.95u l=8u
X144 vcasp vcasp avdd.t1010 avdd.t1009 pfet_05v0 ad=0.396p pd=2.68u as=0.396p ps=2.68u w=0.9u l=2u
X145 avdd.t198 avdd.t195 avdd.t197 avdd.t196 pfet_05v0 ad=8.3556p pd=38.86u as=0 ps=0 w=18.99u l=8u
X146 vx2.t3 psrg_m3_feed.t17 avdd.t1 avdd.t0 pfet_05v0 ad=7.37p pd=34.38u as=7.37p ps=34.38u w=16.75u l=2u
X147 vbp_bias.t13 vbp_bias.t12 avdd.t1022 avdd.t1021 pfet_03v3 ad=8.3864p pd=39u as=8.3864p ps=39u w=19.06u l=8u
X148 avdd.t614 avdd.t611 avdd.t613 avdd.t612 pfet_05v0 ad=7.2248p pd=33.72u as=0 ps=0 w=16.42u l=4u
X149 rfix0 vref.t5 avss ppolyf_u_1k r_width=6.6u r_length=0.128m
X150 avdd.t578 avdd.t575 avdd.t577 avdd.t576 pfet_05v0 ad=7.2248p pd=33.72u as=0 ps=0 w=16.42u l=4u
X151 avdd.t418 avdd.t415 avdd.t417 avdd.t416 pfet_05v0 ad=7.2248p pd=33.72u as=0 ps=0 w=16.42u l=4u
X152 vbn_fold.t10 vbp_i.t46 avdd.t890 avdd.t889 pfet_05v0 ad=8.3556p pd=38.86u as=8.3556p ps=38.86u w=18.99u l=8u
X153 pm2.t5 y1.t14 avdd.t950 avdd.t949 pfet_05v0 ad=9.1344p pd=42.4u as=9.1344p ps=42.4u w=20.76u l=4u
X154 vref.t1 vcasp vx3.t6 avdd.t997 pfet_05v0 ad=7.2248p pd=33.72u as=7.2248p ps=33.72u w=16.42u l=4u
X155 avdd.t142 avdd.t139 avdd.t141 avdd.t140 pfet_05v0 ad=8.25p pd=38.38u as=0 ps=0 w=18.75u l=8u
X156 y1.t6 vbp_cas.t23 pm1.t11 avdd.t978 pfet_05v0 ad=9.7724p pd=45.3u as=9.7724p ps=45.3u w=22.21u l=8u
X157 avdd.t306 avdd.t303 avdd.t305 avdd.t304 pfet_05v0 ad=8.338p pd=38.78u as=0 ps=0 w=18.95u l=8u
X158 vsu2 vbp_i.t20 avss avss nfet_05v0 ad=0.22p pd=1.88u as=0.22p ps=1.88u w=0.5u l=50u
X159 vbn_sink.t20 vbp_i.t35 avdd.t938 avdd.t937 pfet_05v0 ad=8.338p pd=38.78u as=8.338p ps=38.78u w=18.95u l=8u
X160 avdd.t813 avdd.t810 avdd.t812 avdd.t811 pfet_05v0 ad=9.7724p pd=45.3u as=0 ps=0 w=22.21u l=8u
X161 avdd.t845 avdd.t842 avdd.t844 avdd.t843 pfet_05v0 ad=9.1344p pd=42.4u as=0 ps=0 w=20.76u l=4u
X162 vx1.t0 psrg_m3_feed.t24 avdd.t886 avdd.t885 pfet_05v0 ad=7.37p pd=34.38u as=7.37p ps=34.38u w=16.75u l=2u
X163 avdd.t510 avdd.t507 avdd.t509 avdd.t508 pfet_05v0 ad=24.1516p pd=0.11066m as=0 ps=0 w=54.89u l=4u
X164 avdd.t302 avdd.t299 avdd.t301 avdd.t300 pfet_05v0 ad=8.338p pd=38.78u as=0 ps=0 w=18.95u l=8u
X165 vsp.t6 vbp_tail.t9 avdd.t988 avdd.t987 pfet_03v3 ad=12.7204p pd=58.7u as=12.7204p ps=58.7u w=28.91u l=6u
X166 rbit3top.t2 rbit2top.t1 avss ppolyf_u_1k r_width=6.6u r_length=8u
X167 avdd.t793 avdd.t790 avdd.t792 avdd.t791 pfet_05v0 ad=9.1344p pd=42.4u as=0 ps=0 w=20.76u l=4u
X168 vbn_sink.t14 vbp_i.t25 avdd.t71 avdd.t70 pfet_05v0 ad=8.338p pd=38.78u as=8.338p ps=38.78u w=18.95u l=8u
X169 xf1.t7 v1.t5 vsp.t9 avdd.t1026 pfet_05v0 ad=24.1516p pd=0.11066m as=24.1516p ps=0.11066m w=54.89u l=4u
X170 avdd.t837 avdd.t834 avdd.t836 avdd.t835 pfet_05v0 ad=9.7724p pd=45.3u as=0 ps=0 w=22.21u l=8u
X171 vref.t13 avss cap_mim_2f0fF c_width=70.7u c_length=70.7u
X172 avdd.t186 avdd.t183 avdd.t185 avdd.t184 pfet_05v0 ad=8.25p pd=38.38u as=0 ps=0 w=18.75u l=8u
X173 vref.t8 avss cap_mim_2f0fF c_width=70.7u c_length=70.7u
X174 avdd.t502 avdd.t499 avdd.t501 avdd.t500 pfet_05v0 ad=24.1516p pd=0.11066m as=0 ps=0 w=54.89u l=4u
X175 vbn_fold.t6 vbp_i.t48 avdd.t75 avdd.t74 pfet_05v0 ad=8.3556p pd=38.86u as=8.3556p ps=38.86u w=18.99u l=8u
X176 vbp_cas.t13 vbp_cas.t12 vbp_bias.t9 avdd.t968 pfet_05v0 ad=8.3292p pd=38.74u as=8.3292p ps=38.74u w=18.93u l=8u
X177 vbp_i.t6 vbp_i.t5 avdd.t934 avdd.t933 pfet_05v0 ad=8.25p pd=38.38u as=8.25p ps=38.38u w=18.75u l=8u
X178 vbn_sink.t16 vbn_sink.t15 avss avss nfet_05v0 ad=5.4164p pd=25.5u as=5.4164p ps=25.5u w=12.31u l=8u
X179 vbn_fold.t9 vbp_i.t45 avdd.t86 avdd.t85 pfet_05v0 ad=8.3556p pd=38.86u as=8.3556p ps=38.86u w=18.99u l=8u
X180 psrg_m3_feed.t6 vcasp vx2.t9 avdd.t1001 pfet_05v0 ad=7.2248p pd=33.72u as=7.2248p ps=33.72u w=16.42u l=4u
X181 psrg_m3_feed.t4 vcasp vx2.t7 avdd.t994 pfet_05v0 ad=7.2248p pd=33.72u as=7.2248p ps=33.72u w=16.42u l=4u
X182 psrg_vnc.t4 vbp_i.t15 avdd.t45 avdd.t44 pfet_05v0 ad=7.8056p pd=36.36u as=7.8056p ps=36.36u w=17.74u l=4u
X183 vsp.t3 vbp_tail.t11 avdd.t914 avdd.t913 pfet_03v3 ad=12.7204p pd=58.7u as=12.7204p ps=58.7u w=28.91u l=6u
X184 avdd.t254 avdd.t251 avdd.t253 avdd.t252 pfet_05v0 ad=8.3556p pd=38.86u as=0 ps=0 w=18.99u l=8u
X185 avdd.t598 avdd.t595 avdd.t597 avdd.t596 pfet_05v0 ad=7.37p pd=34.38u as=0 ps=0 w=16.75u l=2u
X186 vbp_tail.t1 vbp_tail.t0 avdd.t1037 avdd.t1036 pfet_03v3 ad=6.05p pd=28.38u as=6.05p ps=28.38u w=13.75u l=6u
X187 vbp_bias.t17 vbp_bias.t16 avdd.t82 avdd.t81 pfet_03v3 ad=8.3864p pd=39u as=8.3864p ps=39u w=19.06u l=8u
X188 avdd.t721 avdd.t718 avdd.t720 avdd.t719 pfet_05v0 ad=24.1516p pd=0.11066m as=0 ps=0 w=54.89u l=4u
X189 vbp_cas.t11 vbp_cas.t10 vbp_bias.t8 avdd.t967 pfet_05v0 ad=8.3292p pd=38.74u as=8.3292p ps=38.74u w=18.93u l=8u
X190 psrg_m3_feed.t2 vcasp vx2.t10 avdd.t1004 pfet_05v0 ad=7.2248p pd=33.72u as=7.2248p ps=33.72u w=16.42u l=4u
X191 avdd.t658 avdd.t655 avdd.t657 avdd.t656 pfet_05v0 ad=7.37p pd=34.38u as=0 ps=0 w=16.75u l=2u
X192 rfix1 rfix0 avss ppolyf_u_1k r_width=6.6u r_length=0.128m
X193 vbp_cas.t15 vbp_cas.t14 vbp_bias.t7 avdd.t973 pfet_05v0 ad=8.3292p pd=38.74u as=8.3292p ps=38.74u w=18.93u l=8u
X194 vbp_cas.t5 vbp_cas.t4 vbp_bias.t0 avdd.t972 pfet_05v0 ad=8.3292p pd=38.74u as=8.3292p ps=38.74u w=18.93u l=8u
X195 avdd.t242 avdd.t239 avdd.t241 avdd.t240 pfet_05v0 ad=8.25p pd=38.38u as=0 ps=0 w=18.75u l=8u
X196 avdd.t366 avdd.t363 avdd.t365 avdd.t364 pfet_05v0 ad=8.338p pd=38.78u as=0 ps=0 w=18.95u l=8u
X197 xf2.t3 vbn_sink.t32 avss avss nfet_05v0 ad=7.1896p pd=33.56u as=7.1896p ps=33.56u w=16.34u l=8u
X198 avdd.t518 avdd.t515 avdd.t517 avdd.t516 pfet_05v0 ad=24.1516p pd=0.11066m as=0 ps=0 w=54.89u l=4u
X199 avdd.t422 avdd.t419 avdd.t421 avdd.t420 pfet_05v0 ad=7.2248p pd=33.72u as=0 ps=0 w=16.42u l=4u
X200 avdd.t877 avdd.t874 avdd.t876 avdd.t875 pfet_05v0 ad=9.1344p pd=42.4u as=0 ps=0 w=20.76u l=4u
X201 avss net3.t0 avdd.t78 pplus_u r_width=1u r_length=0.23253m
X202 vbn_i.t2 vbn_i.t1 avss avss nfet_05v0 ad=3.4232p pd=16.44u as=3.4232p ps=16.44u w=7.78u l=8u
X203 psrg_m3_feed.t5 vcasp vx2.t8 avdd.t999 pfet_05v0 ad=7.2248p pd=33.72u as=7.2248p ps=33.72u w=16.42u l=4u
X204 y1.t4 psrg_vnc.t9 psrg_mf1_protected.t1 avss nfet_05v0 ad=8.1356p pd=37.86u as=8.1356p ps=37.86u w=18.49u l=6u
X205 avdd.t558 avdd.t555 avdd.t557 avdd.t556 pfet_05v0 ad=7.2248p pd=33.72u as=0 ps=0 w=16.42u l=4u
X206 avdd.t781 avdd.t778 avdd.t780 avdd.t779 pfet_05v0 ad=9.1344p pd=42.4u as=0 ps=0 w=20.76u l=4u
X207 pm2.t7 y1.t10 avdd.t926 avdd.t925 pfet_05v0 ad=9.1344p pd=42.4u as=9.1344p ps=42.4u w=20.76u l=4u
X208 avdd.t805 avdd.t802 avdd.t804 avdd.t803 pfet_05v0 ad=9.1344p pd=42.4u as=0 ps=0 w=20.76u l=4u
X209 vq2.t0 v2.t0 avss ppolyf_u_1k r_width=4u r_length=42.1u
X210 avdd.t362 avdd.t359 avdd.t361 avdd.t360 pfet_05v0 ad=8.338p pd=38.78u as=0 ps=0 w=18.95u l=8u
X211 xf2.t1 v2.t3 vsp.t0 avdd.t64 pfet_05v0 ad=24.1516p pd=0.11066m as=24.1516p ps=0.11066m w=54.89u l=4u
X212 vbp_i.t0 vbn_i.t10 net4.t0 avss nfet_05v0 ad=4.0172p pd=19.14u as=4.0172p ps=19.14u w=9.13u l=8u
X213 psrg_vnc.t6 vbp_i.t17 avdd.t942 avdd.t941 pfet_05v0 ad=7.8056p pd=36.36u as=7.8056p ps=36.36u w=17.74u l=4u
X214 avdd.t154 avdd.t151 avdd.t153 avdd.t152 pfet_05v0 ad=8.3556p pd=38.86u as=0 ps=0 w=18.99u l=8u
X215 avdd.t138 avdd.t135 avdd.t137 avdd.t136 pfet_05v0 ad=8.25p pd=38.38u as=0 ps=0 w=18.75u l=8u
X216 rbit3top.t7 b3.t2 rbit4top.t5 dvss nfet_03v3 ad=4.4p pd=20.88u as=4.4p ps=20.88u w=10u l=0.28u
X217 avdd.t737 avdd.t734 avdd.t736 avdd.t735 pfet_05v0 ad=24.1516p pd=0.11066m as=0 ps=0 w=54.89u l=4u
X218 avdd.t490 avdd.t487 avdd.t489 avdd.t488 pfet_05v0 ad=24.1516p pd=0.11066m as=0 ps=0 w=54.89u l=4u
X219 avdd.t190 avdd.t187 avdd.t189 avdd.t188 pfet_05v0 ad=8.25p pd=38.38u as=0 ps=0 w=18.75u l=8u
X220 avdd.t150 avdd.t147 avdd.t149 avdd.t148 pfet_05v0 ad=8.3556p pd=38.86u as=0 ps=0 w=18.99u l=8u
X221 avdd.t462 avdd.t459 avdd.t461 avdd.t460 pfet_05v0 ad=7.37p pd=34.38u as=0 ps=0 w=16.75u l=2u
X222 avdd.t582 avdd.t579 avdd.t581 avdd.t580 pfet_05v0 ad=7.2248p pd=33.72u as=0 ps=0 w=16.42u l=4u
X223 vbp_tail.t6 vbn_i.t9 avss avss nfet_05v0 ad=6.138p pd=28.78u as=6.138p ps=28.78u w=13.95u l=8u
X224 vbp_bias.t15 vbp_bias.t14 avdd.t1024 avdd.t1023 pfet_03v3 ad=8.3864p pd=39u as=8.3864p ps=39u w=19.06u l=8u
X225 avdd.t725 avdd.t722 avdd.t724 avdd.t723 pfet_05v0 ad=24.1516p pd=0.11066m as=0 ps=0 w=54.89u l=4u
X226 avdd.t773 avdd.t770 avdd.t772 avdd.t771 pfet_05v0 ad=9.1344p pd=42.4u as=0 ps=0 w=20.76u l=4u
X227 vsua vsua auxsu1 avss nfet_05v0 ad=0.44p pd=2.88u as=0.44p ps=2.88u w=1u l=2u
X228 avdd.t849 avdd.t846 avdd.t848 avdd.t847 pfet_05v0 ad=9.1344p pd=42.4u as=0 ps=0 w=20.76u l=4u
X229 vgn2.t7 avss cap_mim_2f0fF c_width=59u c_length=59u
X230 vbn_sink.t9 vbp_i.t26 avdd.t55 avdd.t54 pfet_05v0 ad=8.338p pd=38.78u as=8.338p ps=38.78u w=18.95u l=8u
X231 avdd.t258 avdd.t255 avdd.t257 avdd.t256 pfet_05v0 ad=8.3556p pd=38.86u as=0 ps=0 w=18.99u l=8u
X232 rbit1top.t1 b0_b.t7 rbit0top.t5 dvdd.t19 pfet_03v3 ad=17.6p pd=80.88u as=17.6p ps=80.88u w=40u l=0.28u
X233 rbit1top.t4 b0_b.t4 rbit0top.t6 dvdd.t18 pfet_03v3 ad=17.6p pd=80.88u as=17.6p ps=80.88u w=40u l=0.28u
X234 b3_b.t1 b3.t1 dvss dvss nfet_03v3 ad=0.44p pd=2.88u as=0.44p ps=2.88u w=1u l=0.5u
X235 avdd.t230 avdd.t227 avdd.t229 avdd.t228 pfet_05v0 ad=8.25p pd=38.38u as=0 ps=0 w=18.75u l=8u
X236 vbn_sink.t10 vbp_i.t27 avdd.t57 avdd.t56 pfet_05v0 ad=8.338p pd=38.78u as=8.338p ps=38.78u w=18.95u l=8u
X237 vbn_fold.t0 vbp_i.t40 avdd.t11 avdd.t10 pfet_05v0 ad=8.3556p pd=38.86u as=8.3556p ps=38.86u w=18.99u l=8u
X238 vbn_fold.t5 vbp_i.t49 avdd.t67 avdd.t66 pfet_05v0 ad=8.3556p pd=38.86u as=8.3556p ps=38.86u w=18.99u l=8u
X239 vx1.t5 psrg_m3_feed.t10 avdd.t94 avdd.t93 pfet_05v0 ad=7.37p pd=34.38u as=7.37p ps=34.38u w=16.75u l=2u
X240 b5_b.t1 b5.t2 dvss dvss nfet_03v3 ad=0.44p pd=2.88u as=0.44p ps=2.88u w=1u l=0.5u
X241 vbn_fold.t7 vbp_i.t50 avdd.t80 avdd.t79 pfet_05v0 ad=8.3556p pd=38.86u as=8.3556p ps=38.86u w=18.99u l=8u
X242 avdd.t126 avdd.t123 avdd.t125 avdd.t124 pfet_05v0 ad=8.25p pd=38.38u as=0 ps=0 w=18.75u l=8u
X243 vbn_sink.t2 vbp_i.t30 avdd.t23 avdd.t22 pfet_05v0 ad=8.338p pd=38.78u as=8.338p ps=38.78u w=18.95u l=8u
X244 avdd.t801 avdd.t798 avdd.t800 avdd.t799 pfet_05v0 ad=9.7724p pd=45.3u as=0 ps=0 w=22.21u l=8u
X245 vbp_i.t8 vbp_i.t7 avdd.t908 avdd.t907 pfet_05v0 ad=8.25p pd=38.38u as=8.25p ps=38.38u w=18.75u l=8u
X246 vbn_sink.t5 vbp_i.t39 avdd.t35 avdd.t34 pfet_05v0 ad=8.338p pd=38.78u as=8.338p ps=38.78u w=18.95u l=8u
X247 avdd.t789 avdd.t786 avdd.t788 avdd.t787 pfet_05v0 ad=9.1344p pd=42.4u as=0 ps=0 w=20.76u l=4u
X248 xf2.t6 v2.t4 vsp.t2 avdd.t882 pfet_05v0 ad=24.1516p pd=0.11066m as=24.1516p ps=0.11066m w=54.89u l=4u
X249 avdd.t650 avdd.t647 avdd.t649 avdd.t648 pfet_05v0 ad=7.37p pd=34.38u as=0 ps=0 w=16.75u l=2u
X250 b6_b.t0 b6.t0 dvdd.t29 dvdd.t28 pfet_03v3 ad=1.32p pd=6.88u as=1.32p ps=6.88u w=3u l=0.5u
X251 psrg_mf1_protected.t0 vbn_fold.t15 xf1.t0 avss nfet_05v0 ad=8.1356p pd=37.86u as=8.1356p ps=37.86u w=18.49u l=6u
X252 pm1.t9 y1.t8 avdd.t922 avdd.t921 pfet_05v0 ad=9.1344p pd=42.4u as=9.1344p ps=42.4u w=20.76u l=4u
X253 bgsu1 bgsu1 bgsu2 avss nfet_03v3 ad=0.44p pd=2.88u as=0.44p ps=2.88u w=1u l=2u
X254 psrg_m3_feed.t0 psrg_vnc.t11 psrg_m3_protected.t3 avss nfet_05v0 ad=6.424p pd=30.08u as=6.424p ps=30.08u w=14.6u l=4u
X255 vx1.t1 psrg_m3_feed.t23 avdd.t884 avdd.t883 pfet_05v0 ad=7.37p pd=34.38u as=7.37p ps=34.38u w=16.75u l=2u
X256 vgn1.t8 vcasp vx1.t9 avdd.t1002 pfet_05v0 ad=7.2248p pd=33.72u as=7.2248p ps=33.72u w=16.42u l=4u
X257 avdd.t817 avdd.t814 avdd.t816 avdd.t815 pfet_05v0 ad=9.7724p pd=45.3u as=0 ps=0 w=22.21u l=8u
X258 vbp_bias.t19 vbp_bias.t18 avdd.t904 avdd.t903 pfet_03v3 ad=8.3864p pd=39u as=8.3864p ps=39u w=19.06u l=8u
X259 avdd.t402 avdd.t399 avdd.t401 avdd.t400 pfet_05v0 ad=7.2248p pd=33.72u as=0 ps=0 w=16.42u l=4u
X260 avdd.t326 avdd.t323 avdd.t325 avdd.t324 pfet_05v0 ad=8.338p pd=38.78u as=0 ps=0 w=18.95u l=8u
X261 psrg_vnc.t3 vbp_i.t14 avdd.t43 avdd.t42 pfet_05v0 ad=7.8056p pd=36.36u as=7.8056p ps=36.36u w=17.74u l=4u
X262 avdd.t178 avdd.t175 avdd.t177 avdd.t176 pfet_05v0 ad=8.3556p pd=38.86u as=0 ps=0 w=18.99u l=8u
X263 vbn_fold.t2 vbp_i.t42 avdd.t39 avdd.t38 pfet_05v0 ad=8.3556p pd=38.86u as=8.3556p ps=38.86u w=18.99u l=8u
X264 avdd.t566 avdd.t563 avdd.t565 avdd.t564 pfet_05v0 ad=7.2248p pd=33.72u as=0 ps=0 w=16.42u l=4u
X265 b1_b.t0 b1.t2 dvdd.t25 dvdd.t24 pfet_03v3 ad=1.32p pd=6.88u as=1.32p ps=6.88u w=3u l=0.5u
X266 iref_gate.t0 vbp_i.t12 avdd.t27 avdd.t26 pfet_05v0 ad=35.2p pd=0.16088m as=35.2p ps=0.16088m w=80u l=1u
X267 vbp_cas.t1 vbp_cas.t0 vbp_bias.t6 avdd.t1043 pfet_05v0 ad=8.3292p pd=38.74u as=8.3292p ps=38.74u w=18.93u l=8u
X268 vq3.t0 rbit6top.t0 avss ppolyf_u_1k r_width=6.6u r_length=0.128m
X269 vgn1.t3 vgn1.t2 v1.t0 avss nfet_05v0 ad=6.424p pd=30.08u as=6.424p ps=30.08u w=14.6u l=4u
X270 avdd.t174 avdd.t171 avdd.t173 avdd.t172 pfet_05v0 ad=8.3556p pd=38.86u as=0 ps=0 w=18.99u l=8u
X271 avdd.t666 avdd.t663 avdd.t665 avdd.t664 pfet_05v0 ad=24.1516p pd=0.11066m as=0 ps=0 w=54.89u l=4u
X272 vq3.t1 b6_b.t2 rbit6top.t4 dvdd.t17 pfet_03v3 ad=1.65p pd=8.38u as=1.65p ps=8.38u w=3.75u l=0.28u
X273 avdd.t586 avdd.t583 avdd.t585 avdd.t584 pfet_05v0 ad=7.2248p pd=33.72u as=0 ps=0 w=16.42u l=4u
X274 vbp_cas.t19 vbp_cas.t18 vbp_bias.t5 avdd.t970 pfet_05v0 ad=8.3292p pd=38.74u as=8.3292p ps=38.74u w=18.93u l=8u
X275 avdd.t386 avdd.t383 avdd.t385 avdd.t384 pfet_05v0 ad=7.2248p pd=33.72u as=0 ps=0 w=16.42u l=4u
X276 rbit3top.t3 b2_b.t4 rbit2top.t3 dvdd.t20 pfet_03v3 ad=8.8p pd=40.88u as=8.8p ps=40.88u w=20u l=0.28u
X277 avdd.t590 avdd.t587 avdd.t589 avdd.t588 pfet_05v0 ad=7.2248p pd=33.72u as=0 ps=0 w=16.42u l=4u
X278 vref.t4 vcasp vx3.t7 avdd.t1000 pfet_05v0 ad=7.2248p pd=33.72u as=7.2248p ps=33.72u w=16.42u l=4u
X279 vbp_cas.t3 vbp_cas.t2 vbp_bias.t3 avdd.t957 pfet_05v0 ad=8.3292p pd=38.74u as=8.3292p ps=38.74u w=18.93u l=8u
X280 psrg_vnc.t5 vbp_i.t16 avdd.t940 avdd.t939 pfet_05v0 ad=7.8056p pd=36.36u as=7.8056p ps=36.36u w=17.74u l=4u
X281 psrg_m3_protected.t0 vgn2.t8 v2.t2 avss nfet_05v0 ad=6.424p pd=30.08u as=6.424p ps=30.08u w=14.6u l=4u
X282 vx3.t1 psrg_m3_feed.t11 avdd.t31 avdd.t30 pfet_05v0 ad=7.37p pd=34.38u as=7.37p ps=34.38u w=16.75u l=2u
X283 xf2.t5 vbn_sink.t29 avss avss nfet_05v0 ad=7.1896p pd=33.56u as=7.1896p ps=33.56u w=16.34u l=8u
X284 vx3.t9 psrg_m3_feed.t16 avdd.t1019 avdd.t1018 pfet_05v0 ad=7.37p pd=34.38u as=7.37p ps=34.38u w=16.75u l=2u
X285 avdd.t741 avdd.t738 avdd.t740 avdd.t739 pfet_05v0 ad=24.1516p pd=0.11066m as=0 ps=0 w=54.89u l=4u
X286 avdd.t482 avdd.t479 avdd.t481 avdd.t480 pfet_05v0 ad=24.1516p pd=0.11066m as=0 ps=0 w=54.89u l=4u
X287 psrg_m3_protected.t1 vgn2.t9 v2.t1 avss nfet_05v0 ad=6.424p pd=30.08u as=6.424p ps=30.08u w=14.6u l=4u
X288 vgn1.t6 vcasp vx1.t6 avdd.t991 pfet_05v0 ad=7.2248p pd=33.72u as=7.2248p ps=33.72u w=16.42u l=4u
X289 avdd.t166 avdd.t163 avdd.t165 avdd.t164 pfet_05v0 ad=8.3556p pd=38.86u as=0 ps=0 w=18.99u l=8u
X290 avdd.t646 avdd.t643 avdd.t645 avdd.t644 pfet_05v0 ad=7.37p pd=34.38u as=0 ps=0 w=16.75u l=2u
X291 vgn1.t5 vcasp vx1.t10 avdd.t1003 pfet_05v0 ad=7.2248p pd=33.72u as=7.2248p ps=33.72u w=16.42u l=4u
X292 avdd.t534 avdd.t531 avdd.t533 avdd.t532 pfet_05v0 ad=7.2248p pd=33.72u as=0 ps=0 w=16.42u l=4u
X293 avdd.t729 avdd.t726 avdd.t728 avdd.t727 pfet_05v0 ad=24.1516p pd=0.11066m as=0 ps=0 w=54.89u l=4u
X294 rbit2top.t0 b2.t2 rbit3top.t0 dvss nfet_03v3 ad=8.8p pd=40.88u as=8.8p ps=40.88u w=20u l=0.28u
X295 xf1.t9 v1.t2 vsp.t12 avdd.t1029 pfet_05v0 ad=24.1516p pd=0.11066m as=24.1516p ps=0.11066m w=54.89u l=4u
X296 avdd.t226 avdd.t223 avdd.t225 avdd.t224 pfet_05v0 ad=8.25p pd=38.38u as=0 ps=0 w=18.75u l=8u
X297 avdd.t334 avdd.t331 avdd.t333 avdd.t332 pfet_05v0 ad=8.338p pd=38.78u as=0 ps=0 w=18.95u l=8u
X298 vx2.t5 psrg_m3_feed.t9 avdd.t1031 avdd.t1030 pfet_05v0 ad=7.37p pd=34.38u as=7.37p ps=34.38u w=16.75u l=2u
X299 vsu psrg_m3_feed.t8 avdd.t902 avdd.t901 pfet_05v0 ad=0.88p pd=4.88u as=0.88p ps=4.88u w=2u l=2u
X300 avdd.t222 avdd.t219 avdd.t221 avdd.t220 pfet_05v0 ad=8.25p pd=38.38u as=0 ps=0 w=18.75u l=8u
X301 vref.t12 avss cap_mim_2f0fF c_width=70.7u c_length=70.7u
X302 avdd.t330 avdd.t327 avdd.t329 avdd.t328 pfet_05v0 ad=8.338p pd=38.78u as=0 ps=0 w=18.95u l=8u
X303 rbit5top.t0 b5.t1 rbit6top.t1 dvss nfet_03v3 ad=1.1p pd=5.88u as=1.1p ps=5.88u w=2.5u l=0.28u
X304 avdd.t702 avdd.t699 avdd.t701 avdd.t700 pfet_05v0 ad=9.7724p pd=45.3u as=0 ps=0 w=22.21u l=8u
X305 xf2.t9 v2.t6 vsp.t14 avdd.t1040 pfet_05v0 ad=24.1516p pd=0.11066m as=24.1516p ps=0.11066m w=54.89u l=4u
X306 avdd.t122 avdd.t119 avdd.t121 avdd.t120 pfet_05v0 ad=8.25p pd=38.38u as=0 ps=0 w=18.75u l=8u
X307 vref.t7 avss cap_mim_2f0fF c_width=70.7u c_length=70.7u
X308 avdd.t654 avdd.t651 avdd.t653 avdd.t652 pfet_05v0 ad=7.37p pd=34.38u as=0 ps=0 w=16.75u l=2u
X309 vbp_bias.t23 vbp_bias.t22 avdd.t7 avdd.t6 pfet_03v3 ad=8.3864p pd=39u as=8.3864p ps=39u w=19.06u l=8u
X310 rbit1top.t0 rbit0top.t1 avss ppolyf_u_1k r_width=6.6u r_length=2u
X311 vgn1.t4 vcasp vx1.t7 avdd.t996 pfet_05v0 ad=7.2248p pd=33.72u as=7.2248p ps=33.72u w=16.42u l=4u
X312 vref.t15 avss cap_mim_2f0fF c_width=70.7u c_length=70.7u
X313 vbn_i.t7 vbp_i.t53 avdd.t1046 avdd.t1045 pfet_05v0 ad=8.25p pd=38.38u as=8.25p ps=38.38u w=18.75u l=8u
X314 avdd.t118 avdd.t115 avdd.t117 avdd.t116 pfet_05v0 ad=8.25p pd=38.38u as=0 ps=0 w=18.75u l=8u
X315 avdd.t498 avdd.t495 avdd.t497 avdd.t496 pfet_05v0 ad=24.1516p pd=0.11066m as=0 ps=0 w=54.89u l=4u
X316 vbn_i.t0 vbp_i.t55 avdd.t37 avdd.t36 pfet_05v0 ad=8.25p pd=38.38u as=8.25p ps=38.38u w=18.75u l=8u
X317 avdd.t282 avdd.t279 avdd.t281 avdd.t280 pfet_05v0 ad=8.3556p pd=38.86u as=0 ps=0 w=18.99u l=8u
X318 vref.t10 avss cap_mim_2f0fF c_width=70.7u c_length=70.7u
X319 avdd.t570 avdd.t567 avdd.t569 avdd.t568 pfet_05v0 ad=7.37p pd=34.38u as=0 ps=0 w=16.75u l=2u
X320 b4_b.t0 b4.t0 dvdd.t7 dvdd.t6 pfet_03v3 ad=1.32p pd=6.88u as=1.32p ps=6.88u w=3u l=0.5u
X321 vnx_bias vnx_bias avss avss nfet_03v3 ad=0.7128p pd=4.12u as=0.7128p ps=4.12u w=1.62u l=8u
X322 vbn.t2 vcasp vaux.t2 avdd.t1006 pfet_05v0 ad=7.04p pd=32.88u as=7.04p ps=32.88u w=16u l=4u
X323 vx1.t3 psrg_m3_feed.t15 avdd.t1017 avdd.t1016 pfet_05v0 ad=7.37p pd=34.38u as=7.37p ps=34.38u w=16.75u l=2u
X324 rbit2top.t9 b1_b.t2 rbit1top.t11 dvdd.t14 pfet_03v3 ad=17.6p pd=80.88u as=17.6p ps=80.88u w=40u l=0.28u
X325 vbn_fold.t3 vbp_i.t43 avdd.t41 avdd.t40 pfet_05v0 ad=8.3556p pd=38.86u as=8.3556p ps=38.86u w=18.99u l=8u
X326 pm2.t8 y1.t7 avdd.t924 avdd.t923 pfet_05v0 ad=9.1344p pd=42.4u as=9.1344p ps=42.4u w=20.76u l=4u
X327 avdd.t430 avdd.t427 avdd.t429 avdd.t428 pfet_05v0 ad=7.2248p pd=33.72u as=0 ps=0 w=16.42u l=4u
X328 vbn_sink.t7 vbp_i.t36 avdd.t51 avdd.t50 pfet_05v0 ad=8.338p pd=38.78u as=8.338p ps=38.78u w=18.95u l=8u
X329 vbn_fold.t8 vbp_i.t44 avdd.t84 avdd.t83 pfet_05v0 ad=8.3556p pd=38.86u as=8.3556p ps=38.86u w=18.99u l=8u
X330 b1_b.t1 b1.t1 dvss dvss nfet_03v3 ad=0.44p pd=2.88u as=0.44p ps=2.88u w=1u l=0.5u
X331 vbp_bias.t21 vbp_bias.t20 avdd.t906 avdd.t905 pfet_03v3 ad=8.3864p pd=39u as=8.3864p ps=39u w=19.06u l=8u
X332 xf2.t7 vbn_sink.t21 avss avss nfet_05v0 ad=7.1896p pd=33.56u as=7.1896p ps=33.56u w=16.34u l=8u
X333 rbit1top.t10 b1.t0 rbit2top.t6 dvss nfet_03v3 ad=17.6p pd=80.88u as=17.6p ps=80.88u w=40u l=0.28u
X334 pm1.t5 y1.t16 avdd.t959 avdd.t958 pfet_05v0 ad=9.1344p pd=42.4u as=9.1344p ps=42.4u w=20.76u l=4u
X335 vsu vsu bgsu1 avss nfet_05v0 ad=0.44p pd=2.88u as=0.44p ps=2.88u w=1u l=2u
X336 vgn2.t4 vbp_cas.t25 pm2.t11 avdd.t980 pfet_05v0 ad=9.7724p pd=45.3u as=9.7724p ps=45.3u w=22.21u l=8u
X337 avdd.t829 avdd.t826 avdd.t828 avdd.t827 pfet_05v0 ad=9.7724p pd=45.3u as=0 ps=0 w=22.21u l=8u
X338 xf1.t4 vbn_sink.t22 avss avss nfet_05v0 ad=7.1896p pd=33.56u as=7.1896p ps=33.56u w=16.34u l=8u
X339 b4_b.t1 b4.t1 dvss dvss nfet_03v3 ad=0.44p pd=2.88u as=0.44p ps=2.88u w=1u l=0.5u
X340 vbn_sink.t19 vbp_i.t34 avdd.t936 avdd.t935 pfet_05v0 ad=8.338p pd=38.78u as=8.338p ps=38.78u w=18.95u l=8u
X341 vbp_cas.t7 vbp_cas.t6 vbp_bias.t2 avdd.t969 pfet_05v0 ad=8.3292p pd=38.74u as=8.3292p ps=38.74u w=18.93u l=8u
X342 avdd.t250 avdd.t247 avdd.t249 avdd.t248 pfet_05v0 ad=8.25p pd=38.38u as=0 ps=0 w=18.75u l=8u
X343 xf1.t1 vbn_sink.t30 avss avss nfet_05v0 ad=7.1896p pd=33.56u as=7.1896p ps=33.56u w=16.34u l=8u
X344 avdd.t761 avdd.t758 avdd.t760 avdd.t759 pfet_05v0 ad=9.7724p pd=45.3u as=0 ps=0 w=22.21u l=8u
X345 vsp.t13 vbp_tail.t7 avdd.t1035 avdd.t1034 pfet_03v3 ad=12.7204p pd=58.7u as=12.7204p ps=58.7u w=28.91u l=6u
X346 avdd.t338 avdd.t335 avdd.t337 avdd.t336 pfet_05v0 ad=8.338p pd=38.78u as=0 ps=0 w=18.95u l=8u
X347 vbp_cas.t9 vbp_cas.t8 vbp_bias.t1 avdd.t1044 pfet_05v0 ad=8.3292p pd=38.74u as=8.3292p ps=38.74u w=18.93u l=8u
X348 aux_gate vbn_i.t8 avss avss nfet_05v0 ad=0.44p pd=2.88u as=0.44p ps=2.88u w=1u l=8u
X349 avdd.t162 avdd.t159 avdd.t161 avdd.t160 pfet_05v0 ad=8.3556p pd=38.86u as=0 ps=0 w=18.99u l=8u
X350 avdd.t146 avdd.t143 avdd.t145 avdd.t144 pfet_05v0 ad=8.25p pd=38.38u as=0 ps=0 w=18.75u l=8u
X351 avdd.t562 avdd.t559 avdd.t561 avdd.t560 pfet_05v0 ad=7.2248p pd=33.72u as=0 ps=0 w=16.42u l=4u
X352 avdd.t466 avdd.t463 avdd.t465 avdd.t464 pfet_05v0 ad=7.37p pd=34.38u as=0 ps=0 w=16.75u l=2u
X353 avdd.t486 avdd.t483 avdd.t485 avdd.t484 pfet_05v0 ad=24.1516p pd=0.11066m as=0 ps=0 w=54.89u l=4u
X354 avdd.t158 avdd.t155 avdd.t157 avdd.t156 pfet_05v0 ad=8.3556p pd=38.86u as=0 ps=0 w=18.99u l=8u
X355 vgn1.t1 vgn1.t0 v1.t1 avss nfet_05v0 ad=6.424p pd=30.08u as=6.424p ps=30.08u w=14.6u l=4u
X356 rb_mid rb_mid avss avss nfet_05v0 ad=0.2376p pd=1.96u as=0.2376p ps=1.96u w=0.54u l=20u
X357 avdd.t769 avdd.t766 avdd.t768 avdd.t767 pfet_05v0 ad=9.1344p pd=42.4u as=0 ps=0 w=20.76u l=4u
X358 avdd.t733 avdd.t730 avdd.t732 avdd.t731 pfet_05v0 ad=24.1516p pd=0.11066m as=0 ps=0 w=54.89u l=4u
X359 avdd.t698 avdd.t695 avdd.t697 avdd.t696 pfet_05v0 ad=9.7724p pd=45.3u as=0 ps=0 w=22.21u l=8u
X360 rbit1top.t3 b0_b.t5 rbit0top.t4 dvdd.t3 pfet_03v3 ad=17.6p pd=80.88u as=17.6p ps=80.88u w=40u l=0.28u
X361 vref.t3 vcasp vx3.t8 avdd.t1005 pfet_05v0 ad=7.2248p pd=33.72u as=7.2248p ps=33.72u w=16.42u l=4u
X362 xf2.t11 vbn_sink.t25 avss avss nfet_05v0 ad=7.1896p pd=33.56u as=7.1896p ps=33.56u w=16.34u l=8u
X363 avdd.t478 avdd.t475 avdd.t477 avdd.t476 pfet_05v0 ad=24.1516p pd=0.11066m as=0 ps=0 w=54.89u l=4u
X364 avdd.t238 avdd.t235 avdd.t237 avdd.t236 pfet_05v0 ad=8.25p pd=38.38u as=0 ps=0 w=18.75u l=8u
X365 avdd.t694 avdd.t691 avdd.t693 avdd.t692 pfet_05v0 ad=9.7724p pd=45.3u as=0 ps=0 w=22.21u l=8u
X366 b0_b.t1 b0.t0 dvss dvss nfet_03v3 ad=0.44p pd=2.88u as=0.44p ps=2.88u w=1u l=0.5u
X367 y1.t5 vbp_cas.t22 pm1.t10 avdd.t977 pfet_05v0 ad=9.7724p pd=45.3u as=9.7724p ps=45.3u w=22.21u l=8u
X368 vbp_tail.t5 vbp_tail.t4 avdd.t918 avdd.t917 pfet_03v3 ad=6.05p pd=28.38u as=6.05p ps=28.38u w=13.75u l=6u
X369 rbit6top.t5 b6.t1 vq3.t2 dvss nfet_03v3 ad=0.55p pd=3.38u as=0.55p ps=3.38u w=1.25u l=0.28u
X370 xf2.t8 v2.t7 vsp.t7 avdd.t1020 pfet_05v0 ad=24.1516p pd=0.11066m as=24.1516p ps=0.11066m w=54.89u l=4u
X371 vbp_i.t2 vbp_i.t1 avdd.t47 avdd.t46 pfet_05v0 ad=8.25p pd=38.38u as=8.25p ps=38.38u w=18.75u l=8u
X372 avdd.t749 avdd.t746 avdd.t748 avdd.t747 pfet_05v0 ad=24.1516p pd=0.11066m as=0 ps=0 w=54.89u l=4u
X373 vbp_bias.t25 vbp_bias.t24 avdd.t910 avdd.t909 pfet_03v3 ad=8.3864p pd=39u as=8.3864p ps=39u w=19.06u l=8u
X374 vbn_i.t3 vbp_i.t56 avdd.t73 avdd.t72 pfet_05v0 ad=8.25p pd=38.38u as=8.25p ps=38.38u w=18.75u l=8u
X375 vref.t14 avss cap_mim_2f0fF c_width=70.7u c_length=70.7u
X376 avdd.t134 avdd.t131 avdd.t133 avdd.t132 pfet_05v0 ad=8.25p pd=38.38u as=0 ps=0 w=18.75u l=8u
X377 avdd.t342 avdd.t339 avdd.t341 avdd.t340 pfet_05v0 ad=8.338p pd=38.78u as=0 ps=0 w=18.95u l=8u
X378 vbn_sink.t8 vbp_i.t37 avdd.t53 avdd.t52 pfet_05v0 ad=8.338p pd=38.78u as=8.338p ps=38.78u w=18.95u l=8u
X379 vx3.t10 psrg_m3_feed.t12 avdd.t1039 avdd.t1038 pfet_05v0 ad=7.37p pd=34.38u as=7.37p ps=34.38u w=16.75u l=2u
X380 vx2.t1 psrg_m3_feed.t22 avdd.t986 avdd.t985 pfet_05v0 ad=7.37p pd=34.38u as=7.37p ps=34.38u w=16.75u l=2u
X381 avdd.t446 avdd.t443 avdd.t445 avdd.t444 pfet_05v0 ad=7.37p pd=34.38u as=0 ps=0 w=16.75u l=2u
X382 avdd.t785 avdd.t782 avdd.t784 avdd.t783 pfet_05v0 ad=9.1344p pd=42.4u as=0 ps=0 w=20.76u l=4u
X383 vref.t9 avss cap_mim_2f0fF c_width=70.7u c_length=70.7u
X384 iref_gate.t2 vbp_i.t11 avdd.t930 avdd.t929 pfet_05v0 ad=35.2p pd=0.16088m as=35.2p ps=0.16088m w=80u l=1u
X385 avdd.t470 avdd.t467 avdd.t469 avdd.t468 pfet_05v0 ad=7.37p pd=34.38u as=0 ps=0 w=16.75u l=2u
X386 vsua vcasp avdd.t1008 avdd.t1007 pfet_05v0 ad=0.88p pd=4.88u as=0.88p ps=4.88u w=2u l=2u
X387 avdd.t398 avdd.t395 avdd.t397 avdd.t396 pfet_05v0 ad=7.2248p pd=33.72u as=0 ps=0 w=16.42u l=4u
X388 vbn_sink.t1 vbp_i.t29 avdd.t21 avdd.t20 pfet_05v0 ad=8.338p pd=38.78u as=8.338p ps=38.78u w=18.95u l=8u
X389 vbn_sink.t4 vbp_i.t38 avdd.t33 avdd.t32 pfet_05v0 ad=8.338p pd=38.78u as=8.338p ps=38.78u w=18.95u l=8u
X390 psrg_vnc.t2 vbp_i.t13 avdd.t29 avdd.t28 pfet_05v0 ad=7.8056p pd=36.36u as=7.8056p ps=36.36u w=17.74u l=4u
X391 b6_b.t1 b6.t2 dvss dvss nfet_03v3 ad=0.44p pd=2.88u as=0.44p ps=2.88u w=1u l=0.5u
X392 avdd.t686 avdd.t683 avdd.t685 avdd.t684 pfet_05v0 ad=9.7724p pd=45.3u as=0 ps=0 w=22.21u l=8u
X393 vsu1 vbp_i.t22 vsu2 avss nfet_05v0 ad=0.22p pd=1.88u as=0.22p ps=1.88u w=0.5u l=50u
X394 avdd.t642 avdd.t639 avdd.t641 avdd.t640 pfet_05v0 ad=7.37p pd=34.38u as=0 ps=0 w=16.75u l=2u
X395 vbp_i.t4 vbp_i.t3 avdd.t90 avdd.t89 pfet_05v0 ad=8.25p pd=38.38u as=8.25p ps=38.38u w=18.75u l=8u
X396 avdd.t682 avdd.t679 avdd.t681 avdd.t680 pfet_05v0 ad=9.7724p pd=45.3u as=0 ps=0 w=22.21u l=8u
X397 bgsu2 bgsu2 avss avss nfet_03v3 ad=0.44p pd=2.88u as=0.44p ps=2.88u w=1u l=2u
X398 y1.t1 vbp_cas.t27 pm1.t1 avdd.t954 pfet_05v0 ad=9.7724p pd=45.3u as=9.7724p ps=45.3u w=22.21u l=8u
X399 xf1.t10 v1.t4 vsp.t10 avdd.t1027 pfet_05v0 ad=24.1516p pd=0.11066m as=24.1516p ps=0.11066m w=54.89u l=4u
X400 vcasp vbn.t4 avss avss nfet_05v0 ad=3.322p pd=15.98u as=3.322p ps=15.98u w=7.55u l=4u
X401 b2_b.t1 b2.t1 dvss dvss nfet_03v3 ad=0.44p pd=2.88u as=0.44p ps=2.88u w=1u l=0.5u
X402 avdd.t314 avdd.t311 avdd.t313 avdd.t312 pfet_05v0 ad=8.338p pd=38.78u as=0 ps=0 w=18.95u l=8u
X403 avdd.t266 avdd.t263 avdd.t265 avdd.t264 pfet_05v0 ad=8.3556p pd=38.86u as=0 ps=0 w=18.99u l=8u
X404 vx1.t2 psrg_m3_feed.t20 avdd.t982 avdd.t981 pfet_05v0 ad=7.37p pd=34.38u as=7.37p ps=34.38u w=16.75u l=2u
X405 su_state.t2 vgn2.t10 avss avss nfet_05v0 ad=1.76p pd=8.88u as=1.76p ps=8.88u w=4u l=1u
X406 vgn2.t3 vbp_cas.t28 pm2.t0 avdd.t955 pfet_05v0 ad=9.7724p pd=45.3u as=9.7724p ps=45.3u w=22.21u l=8u
X407 avdd.t574 avdd.t571 avdd.t573 avdd.t572 pfet_05v0 ad=7.37p pd=34.38u as=0 ps=0 w=16.75u l=2u
X408 vref.t2 vcasp vx3.t4 avdd.t993 pfet_05v0 ad=7.2248p pd=33.72u as=7.2248p ps=33.72u w=16.42u l=4u
X409 rbit3top.t5 b2_b.t2 rbit2top.t2 dvdd.t16 pfet_03v3 ad=8.8p pd=40.88u as=8.8p ps=40.88u w=20u l=0.28u
X410 rbit5top.t4 rbit4top.t3 avss ppolyf_u_1k r_width=6.6u r_length=32u
X411 avdd.t809 avdd.t806 avdd.t808 avdd.t807 pfet_05v0 ad=9.1344p pd=42.4u as=0 ps=0 w=20.76u l=4u
X412 auxsu1 auxsu1 auxsu2 avss nfet_03v3 ad=0.44p pd=2.88u as=0.44p ps=2.88u w=1u l=2u
X413 vgn1.t7 vcasp vx1.t8 avdd.t998 pfet_05v0 ad=7.2248p pd=33.72u as=7.2248p ps=33.72u w=16.42u l=4u
X414 vsp.t5 vbp_tail.t8 avdd.t944 avdd.t943 pfet_03v3 ad=12.7204p pd=58.7u as=12.7204p ps=58.7u w=28.91u l=6u
X415 avdd.t262 avdd.t259 avdd.t261 avdd.t260 pfet_05v0 ad=8.3556p pd=38.86u as=0 ps=0 w=18.99u l=8u
X416 vbn_sink.t3 vbp_i.t31 avdd.t25 avdd.t24 pfet_05v0 ad=8.338p pd=38.78u as=8.338p ps=38.78u w=18.95u l=8u
X417 b0_b.t0 b0.t1 dvdd.t11 dvdd.t10 pfet_03v3 ad=1.32p pd=6.88u as=1.32p ps=6.88u w=3u l=0.5u
X418 avdd.t622 avdd.t619 avdd.t621 avdd.t620 pfet_05v0 ad=7.2248p pd=33.72u as=0 ps=0 w=16.42u l=4u
X419 rbit2top.t5 rbit1top.t9 avss ppolyf_u_1k r_width=6.6u r_length=4u
X420 avdd.t546 avdd.t543 avdd.t545 avdd.t544 pfet_05v0 ad=7.37p pd=34.38u as=0 ps=0 w=16.75u l=2u
X421 aux_gate vcasp avdd.t990 avdd.t989 pfet_05v0 ad=0.22p pd=1.88u as=0.22p ps=1.88u w=0.5u l=10u
X422 vx3.t3 psrg_m3_feed.t21 avdd.t984 avdd.t983 pfet_05v0 ad=7.37p pd=34.38u as=7.37p ps=34.38u w=16.75u l=2u
X423 avdd.t414 avdd.t411 avdd.t413 avdd.t412 pfet_05v0 ad=7.2248p pd=33.72u as=0 ps=0 w=16.42u l=4u
X424 avdd.t869 avdd.t866 avdd.t868 avdd.t867 pfet_05v0 ad=9.1344p pd=42.4u as=0 ps=0 w=20.76u l=4u
X425 avdd.t530 avdd.t527 avdd.t529 avdd.t528 pfet_05v0 ad=7.2248p pd=33.72u as=0 ps=0 w=16.42u l=4u
X426 xf1.t11 vbn_sink.t26 avss avss nfet_05v0 ad=7.1896p pd=33.56u as=7.1896p ps=33.56u w=16.34u l=8u
X427 vgn2.t5 vbp_cas.t24 pm2.t10 avdd.t979 pfet_05v0 ad=9.7724p pd=45.3u as=9.7724p ps=45.3u w=22.21u l=8u
X428 avdd.t841 avdd.t838 avdd.t840 avdd.t839 pfet_05v0 ad=9.7724p pd=45.3u as=0 ps=0 w=22.21u l=8u
X429 avdd.t234 avdd.t231 avdd.t233 avdd.t232 pfet_05v0 ad=8.25p pd=38.38u as=0 ps=0 w=18.75u l=8u
X430 avdd.t857 avdd.t854 avdd.t856 avdd.t855 pfet_05v0 ad=9.1344p pd=42.4u as=0 ps=0 w=20.76u l=4u
X431 rbit1top.t6 b0_b.t2 rbit0top.t7 dvdd.t21 pfet_03v3 ad=17.6p pd=80.88u as=17.6p ps=80.88u w=40u l=0.28u
X432 y1.t2 vbp_cas.t30 pm1.t2 avdd.t964 pfet_05v0 ad=9.7724p pd=45.3u as=9.7724p ps=45.3u w=22.21u l=8u
X433 vsp.t15 vbp_tail.t10 avdd.t1042 avdd.t1041 pfet_03v3 ad=12.7204p pd=58.7u as=12.7204p ps=58.7u w=28.91u l=6u
X434 avdd.t214 avdd.t211 avdd.t213 avdd.t212 pfet_05v0 ad=8.25p pd=38.38u as=0 ps=0 w=18.75u l=8u
X435 vx2.t4 psrg_m3_feed.t14 avdd.t1015 avdd.t1014 pfet_05v0 ad=7.37p pd=34.38u as=7.37p ps=34.38u w=16.75u l=2u
X436 y1.t3 vbp_cas.t31 pm1.t3 avdd.t965 pfet_05v0 ad=9.7724p pd=45.3u as=9.7724p ps=45.3u w=22.21u l=8u
X437 avdd.t182 avdd.t179 avdd.t181 avdd.t180 pfet_05v0 ad=8.25p pd=38.38u as=0 ps=0 w=18.75u l=8u
X438 avdd.t765 avdd.t762 avdd.t764 avdd.t763 pfet_05v0 ad=9.1344p pd=42.4u as=0 ps=0 w=20.76u l=4u
X439 xf1.t6 v1.t6 vsp.t8 avdd.t1025 pfet_05v0 ad=24.1516p pd=0.11066m as=24.1516p ps=0.11066m w=54.89u l=4u
X440 vx3.t0 psrg_m3_feed.t19 avdd.t5 avdd.t4 pfet_05v0 ad=7.37p pd=34.38u as=7.37p ps=34.38u w=16.75u l=2u
X441 avdd.t130 avdd.t127 avdd.t129 avdd.t128 pfet_05v0 ad=8.25p pd=38.38u as=0 ps=0 w=18.75u l=8u
X442 avdd.t410 avdd.t407 avdd.t409 avdd.t408 pfet_05v0 ad=7.2248p pd=33.72u as=0 ps=0 w=16.42u l=4u
X443 avdd.t634 avdd.t631 avdd.t633 avdd.t632 pfet_05v0 ad=7.37p pd=34.38u as=0 ps=0 w=16.75u l=2u
X444 avdd.t434 avdd.t431 avdd.t433 avdd.t432 pfet_05v0 ad=7.2248p pd=33.72u as=0 ps=0 w=16.42u l=4u
X445 auxsu2 auxsu2 avss avss nfet_03v3 ad=0.44p pd=2.88u as=0.44p ps=2.88u w=1u l=2u
X446 avdd.t110 avdd.t107 avdd.t109 avdd.t108 pfet_05v0 ad=8.25p pd=38.38u as=0 ps=0 w=18.75u l=8u
X447 rbit1top.t2 b0_b.t6 rbit0top.t3 dvdd.t22 pfet_03v3 ad=17.6p pd=80.88u as=17.6p ps=80.88u w=40u l=0.28u
X448 avdd.t753 avdd.t750 avdd.t752 avdd.t751 pfet_05v0 ad=24.1516p pd=0.11066m as=0 ps=0 w=54.89u l=4u
X449 avdd.t290 avdd.t287 avdd.t289 avdd.t288 pfet_05v0 ad=8.3556p pd=38.86u as=0 ps=0 w=18.99u l=8u
X450 pm2.t4 y1.t15 avdd.t952 avdd.t951 pfet_05v0 ad=9.1344p pd=42.4u as=9.1344p ps=42.4u w=20.76u l=4u
X451 avdd.t374 avdd.t371 avdd.t373 avdd.t372 pfet_05v0 ad=8.338p pd=38.78u as=0 ps=0 w=18.95u l=8u
X452 avdd.t797 avdd.t794 avdd.t796 avdd.t795 pfet_05v0 ad=9.7724p pd=45.3u as=0 ps=0 w=22.21u l=8u
X453 rbit2top.t8 b1_b.t3 rbit1top.t13 dvdd.t13 pfet_03v3 ad=17.6p pd=80.88u as=17.6p ps=80.88u w=40u l=0.28u
X454 avdd.t662 avdd.t659 avdd.t661 avdd.t660 pfet_05v0 ad=24.1516p pd=0.11066m as=0 ps=0 w=54.89u l=4u
X455 avdd.t286 avdd.t283 avdd.t285 avdd.t284 pfet_05v0 ad=8.3556p pd=38.86u as=0 ps=0 w=18.99u l=8u
X456 avdd.t678 avdd.t675 avdd.t677 avdd.t676 pfet_05v0 ad=9.7724p pd=45.3u as=0 ps=0 w=22.21u l=8u
X457 avdd.t526 avdd.t523 avdd.t525 avdd.t524 pfet_05v0 ad=24.1516p pd=0.11066m as=0 ps=0 w=54.89u l=4u
X458 vgn2.t6 vbp_cas.t21 pm2.t9 avdd.t971 pfet_05v0 ad=9.7724p pd=45.3u as=9.7724p ps=45.3u w=22.21u l=8u
X459 pm1.t4 y1.t17 avdd.t961 avdd.t960 pfet_05v0 ad=9.1344p pd=42.4u as=9.1344p ps=42.4u w=20.76u l=4u
X460 avdd.t674 avdd.t671 avdd.t673 avdd.t672 pfet_05v0 ad=9.7724p pd=45.3u as=0 ps=0 w=22.21u l=8u
X461 psrg_vnc.t1 vbp_i.t19 avdd.t17 avdd.t16 pfet_05v0 ad=7.8056p pd=36.36u as=7.8056p ps=36.36u w=17.74u l=4u
X462 rbit0top.t8 b0.t3 rbit1top.t7 dvss nfet_03v3 ad=17.6p pd=80.88u as=17.6p ps=80.88u w=40u l=0.28u
R0 v1.n5 v1.t2 67.301
R1 v1.n0 v1.t6 65.546
R2 v1.n4 v1.t5 65.501
R3 v1.n5 v1.t3 65.4526
R4 v1.n6 v1.t4 65.4526
R5 v1.n9 v1.n0 43.0205
R6 v1.n9 v1.n3 21.8705
R7 v1.n2 v1.t0 15.379
R8 v1.n3 v1.t1 13.8293
R9 v1.n10 v1.n9 10.2155
R10 v1 v1.n10 9.0905
R11 v1.n6 v1.n5 7.6505
R12 v1.n4 v1.n0 3.8705
R13 v1.n8 v1.n1 3.7365
R14 v1.n2 v1.n1 2.41301
R15 v1.n10 v1.n1 2.0175
R16 v1.n0 v1.n8 1.1705
R17 v1.n8 v1.n7 0.699338
R18 v1.n7 v1.n6 0.555141
R19 v1.n7 v1.n4 0.480177
R20 v1.n3 v1.n2 0.233095
R21 net4 net4.t0 29.4163
R22 vq2 vq2.t0 57.3643
R23 net3 net3.t0 149.625
R24 vref.t15 vref.n0 6.00378
R25 vref.n8 vref.n7 30.3305
R26 vref.t13 vref.n19 27.7295
R27 vref.n20 vref.t11 26.3374
R28 vref.n21 vref.n20 25.4255
R29 vref.n19 vref.n18 25.4132
R30 vref.n9 vref.n8 21.9584
R31 vref.n2 vref.n22 23.0535
R32 vref.n4 vref.n5 17.2918
R33 vref.n12 vref.n11 14.8505
R34 vref.n11 vref.t3 13.8364
R35 vref.t15 vref.n17 10.3635
R36 vref.n7 vref.t5 10.0775
R37 vref.n9 vref.t0 9.28143
R38 vref.n14 vref.t1 9.27752
R39 vref.n12 vref.t4 9.27361
R40 vref.n14 vref.n13 9.2705
R41 vref.n19 vref.t14 9.12959
R42 vref.n21 vref.n5 9.09275
R43 vref.n20 vref.t12 9.07925
R44 vref.t8 vref.n5 9.0075
R45 vref.n3 vref.n22 9.0005
R46 vref.t14 vref.n4 9.0005
R47 vref.n18 vref.n0 10.4353
R48 vref.n18 vref.n4 8.2985
R49 vref.n0 vref.n7 94.7
R50 vref.n22 vref.n21 8.21525
R51 vref.n16 vref.n9 7.6505
R52 vref.n8 vref.t2 4.78535
R53 vref.n1 vref.n2 0.282009
R54 vref.n13 vref.n12 4.5005
R55 vref.n15 vref.n14 4.5005
R56 vref.n11 vref.n10 2.0495
R57 vref vref.n2 1.25494
R58 vref.t15 vref.t14 1.5365
R59 vref.t14 vref.t8 1.5335
R60 vref.n1 vref.n3 1.5165
R61 vref.n16 vref.n15 1.4405
R62 vref.n15 vref.n6 1.1255
R63 vref.n17 vref.n16 1.1255
R64 vref.n13 vref.n10 1.1255
R65 vref.t12 vref.t13 0.951922
R66 vref.n10 vref.n6 0.4325
R67 vref.t14 vref.t9 0.23471
R68 vref.t15 vref.t10 0.23271
R69 vref.n1 vref.t6 0.16771
R70 vref.t12 vref.n3 0.1485
R71 vref.n3 vref.t7 0.14771
R72 vref.n17 vref.n6 0.1445
R73 vref.n1 vref.t11 0.122697
R74 vref.t13 vref.t8 0.104594
R75 b1.n1 b1.t0 553.995
R76 b1.n0 b1.t2 52.3518
R77 b1.n0 b1.t1 34.9128
R78 b1 b1.n1 34.0655
R79 b1.n1 b1.n0 8.7305
R80 b2.n0 b2.t2 299.99
R81 b2.n1 b2.t0 44.8554
R82 b2.n0 b2.t1 30.7964
R83 b2 b2.n1 27.8105
R84 b2.n1 b2.n0 23.4005
R85 vq3 vq3.n0 46.2005
R86 vq3.n0 vq3.t1 22.347
R87 vq3.n2 vq3.n1 18.3321
R88 vq3.n2 vq3.t0 16.1042
R89 vq3.n1 vq3.t2 13.5475
R90 vq3 vq3.n2 13.1253
R91 vq3.n1 vq3.n0 4.5005
R92 b6 b6.n1 46.0805
R93 b6.n1 b6.t0 44.9115
R94 b6.n0 b6.t2 44.5322
R95 b6.n0 b6.t1 42.8627
R96 b6.n1 b6.n0 11.8355
R97 b5.n0 b5.t1 63.7544
R98 b5.n0 b5.t2 49.1564
R99 b5.n1 b5.t0 45.1489
R100 b5 b5.n1 37.0805
R101 b5.n1 b5.n0 6.2105
R102 b0.n0 b0.t3 557.883
R103 b0.n0 b0.t2 547.923
R104 b0.n1 b0.t1 44.9587
R105 b0 b0.n2 44.2355
R106 b0.n2 b0.t0 37.0514
R107 b0.n1 b0.n0 19.4405
R108 b0.n2 b0.n1 8.9555
R109 b4.n0 b4.t2 109.124
R110 b4.n1 b4.t0 49.3969
R111 b4 b4.n1 41.0855
R112 b4.n0 b4.t1 35.1074
R113 b4.n1 b4.n0 25.2455
R114 b3.n0 b3.t2 178.858
R115 b3.n1 b3.t0 44.8894
R116 b3 b3.n1 38.0705
R117 b3.n0 b3.t1 37.0593
R118 b3.n1 b3.n0 17.2355
R119 avdd.n721 avdd.t989 770.606
R120 avdd.n500 avdd.t931 650.385
R121 avdd.n499 avdd.t1011 643.567
R122 avdd.n452 avdd.t87 577.881
R123 avdd.n607 avdd.t91 576.716
R124 avdd.n497 avdd.t1009 243.613
R125 avdd.n462 avdd.t1007 197.117
R126 avdd.n460 avdd.t901 192.661
R127 avdd.n464 avdd.t1013 192.607
R128 avdd.n603 avdd.t917 133.873
R129 avdd.n603 avdd.t919 131.543
R130 avdd.n429 avdd.t968 130.758
R131 avdd.n560 avdd.t957 130.758
R132 avdd.n564 avdd.t6 129.882
R133 avdd.n840 avdd.t933 129.881
R134 avdd.n428 avdd.t1023 129.875
R135 avdd.n866 avdd.t893 128.982
R136 avdd.n864 avdd.t1032 128.982
R137 avdd.n862 avdd.t907 128.982
R138 avdd.n860 avdd.t1045 128.982
R139 avdd.n841 avdd.t89 128.982
R140 avdd.n845 avdd.t46 128.982
R141 avdd.n429 avdd.t967 128.059
R142 avdd.n430 avdd.t973 128.059
R143 avdd.n431 avdd.t1043 128.059
R144 avdd.n558 avdd.t970 128.059
R145 avdd.n559 avdd.t974 128.059
R146 avdd.n560 avdd.t969 128.059
R147 avdd.n561 avdd.t1044 128.059
R148 avdd.n757 avdd.t50 127.987
R149 avdd.n758 avdd.t52 127.987
R150 avdd.n742 avdd.t22 127.984
R151 avdd.n745 avdd.t24 127.984
R152 avdd.n746 avdd.t60 127.984
R153 avdd.n426 avdd.t70 127.957
R154 avdd.n737 avdd.t56 127.957
R155 avdd.n423 avdd.t68 127.957
R156 avdd.n427 avdd.t54 127.957
R157 avdd.n799 avdd.t12 127.805
R158 avdd.n796 avdd.t38 127.805
R159 avdd.n795 avdd.t40 127.805
R160 avdd.n819 avdd.t891 127.763
R161 avdd.n822 avdd.t74 127.763
R162 avdd.n825 avdd.t66 127.763
R163 avdd.n594 avdd.t909 127.219
R164 avdd.n593 avdd.t911 127.178
R165 avdd.n564 avdd.t905 127.171
R166 avdd.n428 avdd.t1021 127.169
R167 avdd.n565 avdd.t903 127.165
R168 avdd.n842 avdd.t36 124.481
R169 avdd.n846 avdd.t72 124.481
R170 avdd.n835 avdd.t76 124.481
R171 avdd.n563 avdd.t972 123.558
R172 avdd.n762 avdd.t32 123.487
R173 avdd.n763 avdd.t34 123.487
R174 avdd.n755 avdd.t937 123.487
R175 avdd.n741 avdd.t20 123.484
R176 avdd.n748 avdd.t62 123.484
R177 avdd.n747 avdd.t935 123.484
R178 avdd.n422 avdd.t48 123.457
R179 avdd.n734 avdd.t18 123.457
R180 avdd.n884 avdd.t83 123.305
R181 avdd.n883 avdd.t85 123.305
R182 avdd.n800 avdd.t10 123.305
R183 avdd.n828 avdd.t79 123.263
R184 avdd.n829 avdd.t58 123.263
R185 avdd.n792 avdd.t889 123.263
R186 avdd.n723 avdd.t8 122.706
R187 avdd.n567 avdd.t81 122.701
R188 avdd.n716 avdd.t1036 122.472
R189 avdd.n512 avdd.t978 114.171
R190 avdd.n514 avdd.t980 114.171
R191 avdd.n511 avdd.t977 114.118
R192 avdd.n513 avdd.t979 114.118
R193 avdd.n515 avdd.t953 114.118
R194 avdd.n505 avdd.t955 114.09
R195 avdd.n507 avdd.t964 114.09
R196 avdd.n239 avdd.t144 112.359
R197 avdd.n241 avdd.t140 112.359
R198 avdd.n243 avdd.t136 112.359
R199 avdd.n245 avdd.t132 112.359
R200 avdd.n247 avdd.t128 112.359
R201 avdd.n249 avdd.t96 112.359
R202 avdd.n251 avdd.t180 112.359
R203 avdd.n253 avdd.t100 112.359
R204 avdd.n255 avdd.t104 112.359
R205 avdd.n257 avdd.t108 112.359
R206 avdd.n259 avdd.t112 112.359
R207 avdd.n261 avdd.t116 112.359
R208 avdd.n263 avdd.t120 112.359
R209 avdd.n265 avdd.t124 112.359
R210 avdd.n267 avdd.t184 112.359
R211 avdd.n269 avdd.t188 112.359
R212 avdd.n271 avdd.t244 112.359
R213 avdd.n272 avdd.t200 112.359
R214 avdd.n274 avdd.t204 112.359
R215 avdd.n276 avdd.t208 112.359
R216 avdd.n278 avdd.t212 112.359
R217 avdd.n280 avdd.t216 112.359
R218 avdd.n282 avdd.t220 112.359
R219 avdd.n284 avdd.t224 112.359
R220 avdd.n286 avdd.t228 112.359
R221 avdd.n288 avdd.t232 112.359
R222 avdd.n290 avdd.t236 112.359
R223 avdd.n292 avdd.t240 112.359
R224 avdd.n294 avdd.t248 112.359
R225 avdd.n297 avdd.t324 111.353
R226 avdd.n299 avdd.t332 111.353
R227 avdd.n301 avdd.t328 111.353
R228 avdd.n303 avdd.t348 111.353
R229 avdd.n345 avdd.t380 111.353
R230 avdd.n347 avdd.t376 111.353
R231 avdd.n349 avdd.t372 111.353
R232 avdd.n351 avdd.t368 111.353
R233 avdd.n353 avdd.t364 111.353
R234 avdd.n355 avdd.t360 111.353
R235 avdd.n357 avdd.t356 111.353
R236 avdd.n359 avdd.t352 111.353
R237 avdd.n361 avdd.t344 111.353
R238 avdd.n363 avdd.t340 111.353
R239 avdd.n365 avdd.t336 111.353
R240 avdd.n367 avdd.t320 111.353
R241 avdd.n369 avdd.t316 111.353
R242 avdd.n371 avdd.t312 111.353
R243 avdd.n373 avdd.t308 111.353
R244 avdd.n375 avdd.t304 111.353
R245 avdd.n377 avdd.t300 111.353
R246 avdd.n379 avdd.t296 111.353
R247 avdd.n381 avdd.t292 111.353
R248 avdd.n295 avdd.t252 111.156
R249 avdd.n384 avdd.t268 111.156
R250 avdd.n386 avdd.t288 111.156
R251 avdd.n388 avdd.t192 111.156
R252 avdd.n390 avdd.t256 111.156
R253 avdd.n392 avdd.t284 111.156
R254 avdd.n394 avdd.t280 111.156
R255 avdd.n396 avdd.t276 111.156
R256 avdd.n398 avdd.t272 111.156
R257 avdd.n400 avdd.t264 111.156
R258 avdd.n402 avdd.t260 111.156
R259 avdd.n404 avdd.t148 111.156
R260 avdd.n406 avdd.t152 111.156
R261 avdd.n408 avdd.t156 111.156
R262 avdd.n410 avdd.t160 111.156
R263 avdd.n412 avdd.t164 111.156
R264 avdd.n414 avdd.t168 111.156
R265 avdd.n416 avdd.t172 111.156
R266 avdd.n418 avdd.t176 111.156
R267 avdd.n420 avdd.t196 111.156
R268 avdd.n556 avdd.t1006 109.93
R269 avdd.n504 avdd.t954 109.671
R270 avdd.n506 avdd.t956 109.671
R271 avdd.n508 avdd.t965 109.671
R272 avdd.n510 avdd.t971 109.671
R273 avdd.n509 avdd.t966 109.59
R274 avdd.n305 avdd.t700 97.2026
R275 avdd.n307 avdd.t696 97.2026
R276 avdd.n309 avdd.t692 97.2026
R277 avdd.n311 avdd.t688 97.2026
R278 avdd.n313 avdd.t684 97.2026
R279 avdd.n315 avdd.t680 97.2026
R280 avdd.n317 avdd.t676 97.2026
R281 avdd.n319 avdd.t672 97.2026
R282 avdd.n321 avdd.t759 97.2026
R283 avdd.n323 avdd.t755 97.2026
R284 avdd.n325 avdd.t799 97.2026
R285 avdd.n327 avdd.t795 97.2026
R286 avdd.n329 avdd.t839 97.2026
R287 avdd.n331 avdd.t835 97.2026
R288 avdd.n333 avdd.t831 97.2026
R289 avdd.n335 avdd.t827 97.2026
R290 avdd.n337 avdd.t823 97.2026
R291 avdd.n339 avdd.t819 97.2026
R292 avdd.n341 avdd.t815 97.2026
R293 avdd.n343 avdd.t811 97.2026
R294 avdd.n703 avdd.t995 91.1774
R295 avdd.n649 avdd.t1002 91.1684
R296 avdd.n636 avdd.t1003 91.1639
R297 avdd.n606 avdd.t897 90.4027
R298 avdd.n606 avdd.t899 89.1427
R299 avdd.n543 avdd.t42 86.6822
R300 avdd.n545 avdd.t939 86.6822
R301 avdd.n547 avdd.t14 86.6822
R302 avdd.n622 avdd.t992 86.6819
R303 avdd.n621 avdd.t993 86.6819
R304 avdd.n625 avdd.t991 86.6819
R305 avdd.n702 avdd.t994 86.6774
R306 avdd.n705 avdd.t996 86.6774
R307 avdd.n655 avdd.t999 86.6729
R308 avdd.n654 avdd.t998 86.6729
R309 avdd.n647 avdd.t1000 86.6684
R310 avdd.n648 avdd.t1001 86.6684
R311 avdd.n639 avdd.t1005 86.6639
R312 avdd.n637 avdd.t1004 86.6639
R313 avdd.n542 avdd.t28 86.6372
R314 avdd.n544 avdd.t44 86.6372
R315 avdd.n546 avdd.t941 86.6372
R316 avdd.n554 avdd.t16 82.5017
R317 avdd.n652 avdd.t997 82.1099
R318 avdd.n568 avdd.t1034 81.0334
R319 avdd.n570 avdd.t1041 78.7249
R320 avdd.n569 avdd.t987 78.6979
R321 avdd.n568 avdd.t943 78.6901
R322 avdd.n571 avdd.t913 78.6801
R323 avdd.n483 avdd.t951 78.1708
R324 avdd.n485 avdd.t960 78.1708
R325 avdd.n467 avdd.t927 78.1393
R326 avdd.n469 avdd.t975 78.1393
R327 avdd.n482 avdd.t949 78.1258
R328 avdd.n484 avdd.t958 78.1258
R329 avdd.n466 avdd.t921 78.0538
R330 avdd.n468 avdd.t925 78.0538
R331 avdd.n470 avdd.t945 78.0538
R332 avdd.n169 avdd.t532 75.1897
R333 avdd.n171 avdd.t536 75.1897
R334 avdd.n173 avdd.t540 75.1897
R335 avdd.n175 avdd.t556 75.1897
R336 avdd.n177 avdd.t560 75.1897
R337 avdd.n179 avdd.t564 75.1897
R338 avdd.n181 avdd.t580 75.1897
R339 avdd.n183 avdd.t584 75.1897
R340 avdd.n185 avdd.t588 75.1897
R341 avdd.n187 avdd.t624 75.1897
R342 avdd.n189 avdd.t620 75.1897
R343 avdd.n191 avdd.t616 75.1897
R344 avdd.n193 avdd.t612 75.1897
R345 avdd.n195 avdd.t608 75.1897
R346 avdd.n197 avdd.t604 75.1897
R347 avdd.n199 avdd.t600 75.1897
R348 avdd.n201 avdd.t576 75.1897
R349 avdd.n203 avdd.t552 75.1897
R350 avdd.n205 avdd.t528 75.1897
R351 avdd.n207 avdd.t424 75.1897
R352 avdd.n208 avdd.t384 75.1897
R353 avdd.n210 avdd.t388 75.1897
R354 avdd.n212 avdd.t392 75.1897
R355 avdd.n214 avdd.t396 75.1897
R356 avdd.n216 avdd.t400 75.1897
R357 avdd.n218 avdd.t404 75.1897
R358 avdd.n220 avdd.t408 75.1897
R359 avdd.n222 avdd.t420 75.1897
R360 avdd.n224 avdd.t416 75.1897
R361 avdd.n226 avdd.t412 75.1897
R362 avdd.n228 avdd.t428 75.1897
R363 avdd.n230 avdd.t432 75.1897
R364 avdd.n232 avdd.t436 75.1897
R365 avdd.n234 avdd.t440 75.1897
R366 avdd.n579 avdd.t915 74.1829
R367 avdd.n481 avdd.t947 73.6708
R368 avdd.n465 avdd.t923 73.6393
R369 avdd.n487 avdd.t962 73.6258
R370 avdd.n670 avdd.t1016 65.0235
R371 avdd.n671 avdd.t1018 65.0235
R372 avdd.n672 avdd.t0 65.0235
R373 avdd.n674 avdd.t4 65.0235
R374 avdd.n642 avdd.t93 64.9965
R375 avdd.n643 avdd.t30 64.9965
R376 avdd.n645 avdd.t1047 64.9965
R377 avdd.n646 avdd.t1014 64.9965
R378 avdd.n662 avdd.t983 64.9965
R379 avdd.n663 avdd.t985 64.9965
R380 avdd.n664 avdd.t883 64.9965
R381 avdd.n666 avdd.t887 64.9965
R382 avdd.n99 avdd.t879 61.7045
R383 avdd.n101 avdd.t875 61.7045
R384 avdd.n103 avdd.t871 61.7045
R385 avdd.n105 avdd.t867 61.7045
R386 avdd.n107 avdd.t863 61.7045
R387 avdd.n109 avdd.t859 61.7045
R388 avdd.n111 avdd.t855 61.7045
R389 avdd.n113 avdd.t851 61.7045
R390 avdd.n115 avdd.t803 61.7045
R391 avdd.n117 avdd.t791 61.7045
R392 avdd.n119 avdd.t787 61.7045
R393 avdd.n121 avdd.t783 61.7045
R394 avdd.n123 avdd.t763 61.7045
R395 avdd.n125 avdd.t767 61.7045
R396 avdd.n127 avdd.t771 61.7045
R397 avdd.n129 avdd.t775 61.7045
R398 avdd.n131 avdd.t779 61.7045
R399 avdd.n133 avdd.t807 61.7045
R400 avdd.n135 avdd.t847 61.7045
R401 avdd.n137 avdd.t843 61.7045
R402 avdd.n572 avdd.t78 61.092
R403 avdd.n673 avdd.t2 60.5235
R404 avdd.n675 avdd.t981 60.5235
R405 avdd.n641 avdd.t1030 60.4965
R406 avdd.n644 avdd.t1038 60.4965
R407 avdd.n665 avdd.t885 60.4965
R408 avdd.n667 avdd.t895 60.4965
R409 avdd.n537 avdd.t703 51.8176
R410 avdd.n29 avdd.t468 49.1947
R411 avdd.n31 avdd.t464 49.1947
R412 avdd.n33 avdd.t460 49.1947
R413 avdd.n35 avdd.t456 49.1947
R414 avdd.n37 avdd.t452 49.1947
R415 avdd.n39 avdd.t448 49.1947
R416 avdd.n41 avdd.t656 49.1947
R417 avdd.n43 avdd.t652 49.1947
R418 avdd.n45 avdd.t648 49.1947
R419 avdd.n47 avdd.t644 49.1947
R420 avdd.n49 avdd.t640 49.1947
R421 avdd.n51 avdd.t636 49.1947
R422 avdd.n53 avdd.t632 49.1947
R423 avdd.n55 avdd.t628 49.1947
R424 avdd.n57 avdd.t592 49.1947
R425 avdd.n59 avdd.t596 49.1947
R426 avdd.n61 avdd.t568 49.1947
R427 avdd.n63 avdd.t572 49.1947
R428 avdd.n65 avdd.t548 49.1947
R429 avdd.n67 avdd.t544 49.1947
R430 avdd.n69 avdd.t444 49.1947
R431 avdd.n71 avdd.t472 49.1947
R432 avdd.n525 avdd.t1029 45.3932
R433 avdd.n527 avdd.t882 45.3932
R434 avdd.n531 avdd.t1026 45.3932
R435 avdd.n533 avdd.t1025 45.3932
R436 avdd.n524 avdd.t64 45.3482
R437 avdd.n526 avdd.t1028 45.3482
R438 avdd.n532 avdd.t1040 45.3482
R439 avdd.n534 avdd.t1020 40.8482
R440 avdd.n530 avdd.t1027 40.8482
R441 avdd.n528 avdd.t65 40.8482
R442 avdd.n716 avdd.n715 35.8513
R443 avdd.n580 avdd.n579 32.8055
R444 avdd.n540 avdd.t929 30.8624
R445 avdd.n541 avdd.t26 30.8309
R446 avdd.n503 avdd.n502 30.5105
R447 avdd.n502 avdd.t932 27.5722
R448 avdd.n752 avdd.t936 25.6018
R449 avdd.n74 avdd.t524 25.5994
R450 avdd.n76 avdd.t520 25.5994
R451 avdd.n78 avdd.t516 25.5994
R452 avdd.n80 avdd.t512 25.5994
R453 avdd.n82 avdd.t508 25.5994
R454 avdd.n84 avdd.t504 25.5994
R455 avdd.n86 avdd.t500 25.5994
R456 avdd.n88 avdd.t496 25.5994
R457 avdd.n90 avdd.t492 25.5994
R458 avdd.n92 avdd.t488 25.5994
R459 avdd.n94 avdd.t484 25.5994
R460 avdd.n96 avdd.t480 25.5994
R461 avdd.n98 avdd.t476 25.5994
R462 avdd.t705 avdd.t704 25.5994
R463 avdd.n140 avdd.t660 25.5994
R464 avdd.n142 avdd.t664 25.5994
R465 avdd.n144 avdd.t668 25.5994
R466 avdd.n146 avdd.t751 25.5994
R467 avdd.n148 avdd.t747 25.5994
R468 avdd.n150 avdd.t743 25.5994
R469 avdd.n152 avdd.t739 25.5994
R470 avdd.n154 avdd.t735 25.5994
R471 avdd.n156 avdd.t731 25.5994
R472 avdd.n158 avdd.t727 25.5994
R473 avdd.n160 avdd.t723 25.5994
R474 avdd.n162 avdd.t719 25.5994
R475 avdd.n164 avdd.t715 25.5994
R476 avdd.n166 avdd.t711 25.5994
R477 avdd.n168 avdd.t707 25.5994
R478 avdd.n722 avdd.t9 25.1177
R479 avdd.n720 avdd.t990 22.7703
R480 avdd.n500 avdd.t1012 22.3718
R481 avdd.n424 avdd.t49 21.2629
R482 avdd.n843 avdd.t90 21.2414
R483 avdd.n743 avdd.t21 21.2292
R484 avdd.n759 avdd.t51 21.228
R485 avdd.n797 avdd.t11 21.2278
R486 avdd.n776 avdd.t75 21.2278
R487 avdd.n820 avdd.t890 21.2278
R488 avdd.n602 avdd.t1037 21.1901
R489 avdd.n735 avdd.t19 21.0905
R490 avdd.n577 avdd.t916 20.6195
R491 avdd.n488 avdd.t924 20.5509
R492 avdd.n476 avdd.t948 20.4699
R493 avdd.n766 avdd.t33 20.418
R494 avdd.n783 avdd.t80 20.4178
R495 avdd.n480 avdd.t963 20.3797
R496 avdd.n595 avdd.t912 20.0552
R497 avdd.n433 avdd.t27 19.6327
R498 avdd.n607 avdd.t92 19.221
R499 avdd.n498 avdd.t1010 18.206
R500 avdd.n452 avdd.t88 17.9225
R501 avdd.n617 avdd.t423 16.7137
R502 avdd.n751 avdd.t25 16.5942
R503 avdd.n863 avdd.t1033 16.3364
R504 avdd.n865 avdd.t894 16.2991
R505 avdd.n861 avdd.t908 16.2991
R506 avdd.n840 avdd.t934 16.2541
R507 avdd.n461 avdd.t902 16.147
R508 avdd.n756 avdd.t938 16.0773
R509 avdd.n740 avdd.t71 16.0429
R510 avdd.n824 avdd.t39 16.0078
R511 avdd.n434 avdd.n433 15.7955
R512 avdd.n548 avdd.t29 15.7386
R513 avdd.n848 avdd.t47 15.7064
R514 avdd.n641 avdd.n60 16.4217
R515 avdd.n630 avdd.n42 16.3879
R516 avdd.n566 avdd.n563 14.9855
R517 avdd.n857 avdd.t77 14.6341
R518 avdd.n557 avdd.n556 14.5355
R519 avdd.n726 avdd.t1024 14.4932
R520 avdd.n608 avdd.t898 14.3338
R521 avdd.n610 avdd.t900 13.9738
R522 avdd.n752 avdd.t63 13.9392
R523 avdd.n881 avdd.t86 13.9249
R524 avdd.n782 avdd.t59 13.9249
R525 avdd.n765 avdd.t35 13.9173
R526 avdd.n849 avdd.t73 13.9141
R527 avdd.n601 avdd.t82 13.9127
R528 avdd.n719 avdd.t918 13.8808
R529 avdd.n548 avdd.t43 13.8021
R530 avdd.n550 avdd.t940 13.8021
R531 avdd.n553 avdd.t15 13.8021
R532 avdd.n549 avdd.t45 13.7586
R533 avdd.n597 avdd.t7 13.7532
R534 avdd.n575 avdd.t1042 13.7364
R535 avdd.n479 avdd.t959 13.7197
R536 avdd.n572 avdd.t1035 13.7094
R537 avdd.n573 avdd.t944 13.6877
R538 avdd.n574 avdd.t988 13.6795
R539 avdd.n720 avdd.n719 12.8255
R540 avdd.n593 avdd.n592 12.7805
R541 avdd.n880 avdd.t84 12.0928
R542 avdd.n825 avdd.n824 12.0605
R543 avdd.n761 avdd.n753 11.9705
R544 avdd.n746 avdd.n740 11.9705
R545 avdd.n599 avdd.n598 11.9705
R546 avdd.n608 avdd.n607 11.7905
R547 avdd.n509 avdd.n508 11.7005
R548 avdd.n23 avdd.n521 11.6105
R549 avdd.n648 avdd.n647 11.6105
R550 avdd.n464 avdd.n463 11.4305
R551 avdd.n463 avdd.t1008 11.287
R552 avdd.n490 avdd.n489 11.2505
R553 avdd.n496 avdd.n495 11.1605
R554 avdd.n529 avdd.n141 12.1654
R555 avdd.n489 avdd.n488 11.0705
R556 avdd.n491 avdd.n490 11.0255
R557 avdd.n670 avdd.n64 11.9434
R558 avdd.n662 avdd.n66 11.9292
R559 avdd.n702 avdd.n12 10.8005
R560 avdd.n622 avdd.n621 10.8005
R561 avdd.n654 avdd.n653 10.7555
R562 avdd.n496 avdd.n464 10.7105
R563 avdd.n698 avdd.n697 10.7105
R564 avdd.n708 avdd.n707 10.6824
R565 avdd.n685 avdd.t1031 10.0857
R566 avdd.n676 avdd.t1017 10.0857
R567 avdd.n657 avdd.t984 10.0857
R568 avdd.n562 avdd.n559 9.9005
R569 avdd.n685 avdd.t94 9.79773
R570 avdd.n686 avdd.t31 9.79773
R571 avdd.n687 avdd.t1039 9.79773
R572 avdd.n688 avdd.t1048 9.79773
R573 avdd.n689 avdd.t1015 9.79773
R574 avdd.n676 avdd.t1019 9.79773
R575 avdd.n677 avdd.t1 9.79773
R576 avdd.n678 avdd.t3 9.79773
R577 avdd.n679 avdd.t5 9.79773
R578 avdd.n680 avdd.t982 9.79773
R579 avdd.n657 avdd.t986 9.79773
R580 avdd.n658 avdd.t884 9.79773
R581 avdd.n659 avdd.t886 9.79773
R582 avdd.n660 avdd.t888 9.79773
R583 avdd.n661 avdd.t896 9.79773
R584 avdd.n718 avdd.n602 9.4955
R585 avdd.n735 avdd.t57 9.47292
R586 avdd.n725 avdd.t1022 9.44874
R587 avdd.n631 avdd.n46 10.5079
R588 avdd.n634 avdd.n52 10.5079
R589 avdd.n635 avdd.n54 10.5079
R590 avdd.n694 avdd.n56 10.5079
R591 avdd.n714 avdd.n30 10.4959
R592 avdd.n713 avdd.n32 10.4959
R593 avdd.n712 avdd.n34 10.4959
R594 avdd.n711 avdd.n36 10.4959
R595 avdd.n710 avdd.n38 10.4959
R596 avdd.n602 avdd.t920 9.36641
R597 avdd.n858 avdd.t1046 9.31644
R598 avdd.n599 avdd.t904 9.31374
R599 avdd.n555 avdd.t17 9.30213
R600 avdd.n489 avdd.t928 9.30085
R601 avdd.n491 avdd.t976 9.30085
R602 avdd.n424 avdd.t69 9.30055
R603 avdd.n739 avdd.t55 9.30055
R604 avdd.n843 avdd.t37 9.27907
R605 avdd.n488 avdd.t922 9.27568
R606 avdd.n490 avdd.t926 9.27568
R607 avdd.n493 avdd.t946 9.27568
R608 avdd.n598 avdd.t906 9.27324
R609 avdd.n743 avdd.t23 9.2668
R610 avdd.n750 avdd.t61 9.2668
R611 avdd.n478 avdd.t952 9.26485
R612 avdd.n480 avdd.t961 9.26485
R613 avdd.n551 avdd.t942 9.25863
R614 avdd.n596 avdd.t910 9.24726
R615 avdd.n797 avdd.t13 9.24493
R616 avdd.n776 avdd.t67 9.24493
R617 avdd.n820 avdd.t892 9.24493
R618 avdd.n823 avdd.t41 9.24493
R619 avdd.n759 avdd.t53 9.2373
R620 avdd.n476 avdd.t950 9.21968
R621 avdd.n773 avdd.n16 9.20563
R622 avdd.n576 avdd.t914 9.17845
R623 avdd.n805 avdd.n802 9.16095
R624 avdd.n807 avdd.n806 9.15963
R625 avdd.n809 avdd.n808 9.15963
R626 avdd.n812 avdd.n811 9.1294
R627 avdd.n810 avdd.n804 9.12895
R628 avdd.n433 avdd.t930 9.11234
R629 avdd.n794 avdd.n793 9.0805
R630 avdd.n834 avdd.n833 9.0805
R631 avdd.n815 avdd.n801 9.0805
R632 avdd.n786 avdd.n781 9.07055
R633 avdd.n788 avdd.n780 9.03338
R634 avdd.n785 avdd.n18 9.02607
R635 avdd.n832 avdd.n831 9.0045
R636 avdd.n236 avdd.n17 9.00058
R637 avdd.n790 avdd.n789 9.00054
R638 avdd.n0 avdd.n1 3.97661
R639 avdd.n529 avdd.n528 8.7305
R640 avdd.n21 avdd.n726 8.645
R641 avdd.n639 avdd.n638 8.56623
R642 avdd.n647 avdd.n628 8.43261
R643 avdd.n492 avdd.n487 7.7855
R644 avdd.n722 avdd.n721 7.7405
R645 avdd.n578 avdd.n577 7.6955
R646 avdd.n510 avdd.n326 8.6404
R647 avdd.n499 avdd.n498 7.5155
R648 avdd.n598 avdd.n597 7.4705
R649 avdd.n800 avdd.n799 7.3805
R650 avdd.n842 avdd.n841 7.3805
R651 avdd.n742 avdd.n741 7.3805
R652 avdd.n423 avdd.n422 7.3805
R653 avdd.n597 avdd.n596 7.3805
R654 avdd.n554 avdd.n553 7.3805
R655 avdd.n508 avdd.n507 7.3805
R656 avdd.n506 avdd.n505 7.3805
R657 avdd.n846 avdd.n252 8.47876
R658 avdd.n835 avdd.n268 8.47876
R659 avdd.n741 avdd.n364 8.47556
R660 avdd.n747 avdd.n366 8.47556
R661 avdd.n422 avdd.n304 8.46431
R662 avdd.n516 avdd.n330 8.4604
R663 avdd.n754 avdd.n300 8.45156
R664 avdd.n767 avdd.n368 8.45156
R665 avdd.n868 avdd.n273 8.45101
R666 avdd.n445 avdd.n306 8.43415
R667 avdd.n836 avdd.n240 8.43001
R668 avdd.n727 avdd.n346 8.40806
R669 avdd.n857 avdd.n19 7.2275
R670 avdd.n507 avdd.n506 7.2005
R671 avdd.n505 avdd.n504 7.2005
R672 avdd.n511 avdd.n510 7.2005
R673 avdd.n850 avdd.n849 7.1555
R674 avdd.n600 avdd.n567 7.1555
R675 avdd.n486 avdd.n480 7.1555
R676 avdd.n28 avdd.n515 7.1555
R677 avdd.n859 avdd.n858 7.0205
R678 avdd.n844 avdd.n843 7.0205
R679 avdd.n750 avdd.n749 7.0205
R680 avdd.n739 avdd.n738 7.0205
R681 avdd.n425 avdd.n424 7.0205
R682 avdd.n566 avdd.n565 7.0205
R683 avdd.n562 avdd.n561 7.0205
R684 avdd.n494 avdd.n493 7.0205
R685 avdd.n744 avdd.n743 7.0205
R686 avdd.n576 avdd.n575 6.8855
R687 avdd.n798 avdd.n797 6.8405
R688 avdd.n823 avdd.n774 6.8405
R689 avdd.n760 avdd.n759 6.8405
R690 avdd.n540 avdd.n539 6.8405
R691 avdd.n777 avdd.n776 6.8405
R692 avdd.n821 avdd.n820 6.8405
R693 avdd.n736 avdd.n735 6.7955
R694 avdd.n595 avdd.n594 6.7955
R695 avdd.n501 avdd.n452 6.7505
R696 avdd.n551 avdd.n550 6.7505
R697 avdd.n465 avdd.n136 7.79564
R698 avdd.n481 avdd.n134 7.77614
R699 avdd.n882 avdd.n881 6.6605
R700 avdd.n765 avdd.n764 6.6605
R701 avdd.n479 avdd.n478 6.6605
R702 avdd.n726 avdd.n725 6.6155
R703 avdd.n725 avdd.n724 6.6155
R704 avdd.n487 avdd.n116 7.68614
R705 avdd.n858 avdd.n857 6.5705
R706 avdd.n719 avdd.n718 6.5705
R707 avdd.n650 avdd.n649 6.5705
R708 avdd.n453 avdd.n100 7.61564
R709 avdd.n471 avdd.n118 7.61564
R710 avdd.n473 avdd.n124 7.61564
R711 avdd.n480 avdd.n479 6.5255
R712 avdd.n703 avdd.n702 6.5255
R713 avdd.n764 avdd.n298 7.59656
R714 avdd.n531 avdd.n530 6.4805
R715 avdd.n637 avdd.n636 6.4805
R716 avdd.n604 avdd.n209 7.57218
R717 avdd.n850 avdd.n250 7.57501
R718 avdd.n717 avdd.n716 6.40391
R719 avdd.n600 avdd.n599 6.3905
R720 avdd.n492 avdd.n491 6.3455
R721 avdd.n704 avdd.n703 6.3455
R722 avdd.n859 avdd.n835 6.3005
R723 avdd.n749 avdd.n748 6.3005
R724 avdd.n736 avdd.n734 6.3005
R725 avdd.n724 avdd.n723 6.3005
R726 avdd.n466 avdd.n465 6.3005
R727 avdd.n482 avdd.n481 6.3005
R728 avdd.n528 avdd.n527 6.3005
R729 avdd.n534 avdd.n533 6.3005
R730 avdd.n649 avdd.n648 6.3005
R731 avdd.n653 avdd.n652 6.28197
R732 avdd.n524 avdd.n523 6.27725
R733 avdd.n579 avdd.n578 6.1205
R734 avdd.n556 avdd.n555 6.0755
R735 avdd.n552 avdd.n551 6.0305
R736 avdd.n487 avdd.n486 5.9405
R737 avdd.n710 avdd.n709 5.9405
R738 avdd.n715 avdd.n714 5.9405
R739 avdd.n634 avdd.n633 5.9405
R740 avdd.n631 avdd.n630 5.9405
R741 avdd.n645 avdd.n644 5.9405
R742 avdd.n644 avdd.n643 5.9405
R743 avdd.n642 avdd.n641 5.9405
R744 avdd.n675 avdd.n674 5.9405
R745 avdd.n674 avdd.n673 5.9405
R746 avdd.n673 avdd.n672 5.9405
R747 avdd.n667 avdd.n666 5.9405
R748 avdd.n666 avdd.n665 5.9405
R749 avdd.n665 avdd.n664 5.9405
R750 avdd.n495 avdd.n494 5.7605
R751 avdd.n500 avdd.n499 5.6705
R752 avdd.n723 avdd.n722 5.5805
R753 avdd.n721 avdd.n720 5.5805
R754 avdd.n73 avdd.t523 52.1219
R755 avdd.n75 avdd.t519 52.1219
R756 avdd.n77 avdd.t515 52.1219
R757 avdd.n79 avdd.t511 52.1219
R758 avdd.n81 avdd.t507 52.1219
R759 avdd.n83 avdd.t503 52.1219
R760 avdd.n85 avdd.t499 52.1219
R761 avdd.n87 avdd.t495 52.1219
R762 avdd.n89 avdd.t491 52.1219
R763 avdd.n91 avdd.t487 52.1219
R764 avdd.n93 avdd.t483 52.1219
R765 avdd.n95 avdd.t479 52.1219
R766 avdd.n97 avdd.t475 52.1219
R767 avdd.n139 avdd.t659 52.1219
R768 avdd.n141 avdd.t663 52.1219
R769 avdd.n143 avdd.t667 52.1219
R770 avdd.n145 avdd.t750 52.1219
R771 avdd.n147 avdd.t746 52.1219
R772 avdd.n149 avdd.t742 52.1219
R773 avdd.n151 avdd.t738 52.1219
R774 avdd.n153 avdd.t734 52.1219
R775 avdd.n155 avdd.t730 52.1219
R776 avdd.n157 avdd.t726 52.1219
R777 avdd.n159 avdd.t722 52.1219
R778 avdd.n161 avdd.t718 52.1219
R779 avdd.n163 avdd.t714 52.1219
R780 avdd.n165 avdd.t710 52.1219
R781 avdd.n167 avdd.t706 52.1219
R782 avdd.n844 avdd.n842 5.4005
R783 avdd.n756 avdd.n755 5.4005
R784 avdd.n463 avdd.n462 5.3555
R785 avdd.n824 avdd.n823 5.2205
R786 avdd.n783 avdd.n782 5.2205
R787 avdd.n766 avdd.n765 5.2205
R788 avdd.n740 avdd.n739 5.2205
R789 avdd.n501 avdd.n500 5.2205
R790 avdd.n536 avdd.n535 5.10463
R791 avdd.n580 avdd.n73 6.09043
R792 avdd.n581 avdd.n75 6.09043
R793 avdd.n582 avdd.n77 6.09043
R794 avdd.n583 avdd.n79 6.09043
R795 avdd.n584 avdd.n81 6.09043
R796 avdd.n585 avdd.n83 6.09043
R797 avdd.n586 avdd.n85 6.09043
R798 avdd.n587 avdd.n87 6.09043
R799 avdd.n588 avdd.n89 6.09043
R800 avdd.n589 avdd.n91 6.09043
R801 avdd.n590 avdd.n93 6.09043
R802 avdd.n591 avdd.n95 6.09043
R803 avdd.n592 avdd.n97 6.09043
R804 avdd.n539 avdd.n538 5.04078
R805 avdd.n535 avdd.n139 6.09043
R806 avdd.n523 avdd.n143 6.09043
R807 avdd.n22 avdd.n145 6.09043
R808 avdd.n444 avdd.n147 6.09043
R809 avdd.n443 avdd.n149 6.09043
R810 avdd.n442 avdd.n151 6.09043
R811 avdd.n441 avdd.n153 6.09043
R812 avdd.n440 avdd.n155 6.09043
R813 avdd.n439 avdd.n157 6.09043
R814 avdd.n438 avdd.n159 6.09043
R815 avdd.n437 avdd.n161 6.09043
R816 avdd.n436 avdd.n163 6.09043
R817 avdd.n435 avdd.n165 6.09043
R818 avdd.n432 avdd.n167 6.09043
R819 avdd.n652 avdd.n627 5.01107
R820 avdd.n461 avdd.n460 4.9955
R821 avdd.n530 avdd.n529 4.9955
R822 avdd.n615 avdd.n614 4.99282
R823 avdd.n867 avdd.n866 4.951
R824 avdd.n695 avdd.n694 4.947
R825 avdd.n632 avdd.n48 6.00191
R826 avdd.n709 avdd.n40 5.99592
R827 avdd.n708 avdd.n70 5.99592
R828 avdd.n715 avdd.n72 5.99592
R829 avdd.n630 avdd.n44 5.99442
R830 avdd.n633 avdd.n50 5.99442
R831 avdd.n691 avdd.n58 5.98167
R832 avdd.n11 avdd.n62 5.97942
R833 avdd.n24 avdd.n68 5.97942
R834 avdd.n497 avdd.n496 4.8605
R835 avdd.n493 avdd.n492 4.8605
R836 avdd.n717 avdd.n603 4.8605
R837 avdd.n615 avdd.n611 4.8438
R838 avdd.n453 avdd.n102 5.90564
R839 avdd.n454 avdd.n104 5.90564
R840 avdd.n455 avdd.n106 5.90564
R841 avdd.n456 avdd.n108 5.90564
R842 avdd.n457 avdd.n110 5.90564
R843 avdd.n458 avdd.n112 5.90564
R844 avdd.n459 avdd.n114 5.90564
R845 avdd.n471 avdd.n120 5.90564
R846 avdd.n472 avdd.n122 5.90564
R847 avdd.n473 avdd.n126 5.90564
R848 avdd.n474 avdd.n128 5.90564
R849 avdd.n475 avdd.n130 5.90564
R850 avdd.n8 avdd.n132 5.90564
R851 avdd.n495 avdd.n138 5.90564
R852 avdd.n614 avdd.n221 5.90718
R853 avdd.n626 avdd.n227 5.90568
R854 avdd.n886 avdd.n385 1.57786
R855 avdd.n5 avdd.t243 9.45728
R856 avdd.n6 avdd.t247 9.45728
R857 avdd.n695 avdd.n188 5.88863
R858 avdd.n627 avdd.n170 5.88168
R859 avdd.n653 avdd.n172 5.88168
R860 avdd.n656 avdd.n174 5.88168
R861 avdd.n628 avdd.n176 5.88168
R862 avdd.n650 avdd.n178 5.88168
R863 avdd.n651 avdd.n180 5.88168
R864 avdd.n629 avdd.n182 5.88168
R865 avdd.n638 avdd.n184 5.88168
R866 avdd.n640 avdd.n186 5.88168
R867 avdd.n696 avdd.n190 5.88168
R868 avdd.n697 avdd.n192 5.88168
R869 avdd.n698 avdd.n194 5.88168
R870 avdd.n699 avdd.n196 5.88168
R871 avdd.n700 avdd.n198 5.88168
R872 avdd.n701 avdd.n200 5.88168
R873 avdd.n15 avdd.n202 5.88168
R874 avdd.n14 avdd.n204 5.88168
R875 avdd.n13 avdd.n206 5.88168
R876 avdd.n619 avdd.n618 4.78705
R877 avdd.n604 avdd.n211 5.88168
R878 avdd.n605 avdd.n213 5.88168
R879 avdd.n26 avdd.n215 5.88168
R880 avdd.n612 avdd.n217 5.88168
R881 avdd.n613 avdd.n219 5.88168
R882 avdd.n620 avdd.n223 5.88168
R883 avdd.n624 avdd.n225 5.88168
R884 avdd.n12 avdd.n229 5.88168
R885 avdd.n704 avdd.n231 5.88168
R886 avdd.n706 avdd.n233 5.88168
R887 avdd.n707 avdd.n235 5.88168
R888 avdd.n451 avdd.n320 5.86915
R889 avdd.n867 avdd.n270 5.85539
R890 avdd.n733 avdd.n362 5.85431
R891 avdd.n445 avdd.n308 5.8504
R892 avdd.n446 avdd.n310 5.8504
R893 avdd.n447 avdd.n312 5.8504
R894 avdd.n448 avdd.n314 5.8504
R895 avdd.n449 avdd.n316 5.8504
R896 avdd.n450 avdd.n318 5.8504
R897 avdd.n503 avdd.n322 5.8504
R898 avdd.n9 avdd.n324 5.8504
R899 avdd.n28 avdd.n328 5.8504
R900 avdd.n516 avdd.n332 5.8504
R901 avdd.n517 avdd.n334 5.8504
R902 avdd.n518 avdd.n336 5.8504
R903 avdd.n519 avdd.n338 5.8504
R904 avdd.n520 avdd.n340 5.8504
R905 avdd.n521 avdd.n342 5.8504
R906 avdd.n23 avdd.n344 5.8504
R907 avdd.n772 avdd.n382 5.84906
R908 avdd.n834 avdd.n296 5.84167
R909 avdd.n805 avdd.n387 5.84167
R910 avdd.n831 avdd.n389 5.84167
R911 avdd.n801 avdd.n391 5.84167
R912 avdd.n811 avdd.n393 5.84167
R913 avdd.n810 avdd.n395 5.84167
R914 avdd.n809 avdd.n397 5.84167
R915 avdd.n806 avdd.n399 5.84167
R916 avdd.n890 avdd.n401 5.84167
R917 avdd.n16 avdd.n403 5.84167
R918 avdd.n784 avdd.n405 5.84167
R919 avdd.n18 avdd.n407 5.84167
R920 avdd.n17 avdd.n409 5.84167
R921 avdd.n781 avdd.n411 5.84167
R922 avdd.n780 avdd.n413 5.84167
R923 avdd.n790 avdd.n415 5.84167
R924 avdd.n791 avdd.n417 5.84167
R925 avdd.n1 avdd.n419 6.9951
R926 avdd.n793 avdd.n421 5.84167
R927 avdd.n754 avdd.n302 5.84156
R928 avdd.n727 avdd.n348 5.84156
R929 avdd.n728 avdd.n350 5.84156
R930 avdd.n729 avdd.n352 5.84156
R931 avdd.n730 avdd.n354 5.84156
R932 avdd.n21 avdd.n356 5.84156
R933 avdd.n731 avdd.n358 5.84156
R934 avdd.n732 avdd.n360 5.84156
R935 avdd.n767 avdd.n370 5.84156
R936 avdd.n768 avdd.n372 5.84156
R937 avdd.n769 avdd.n374 5.84156
R938 avdd.n770 avdd.n376 5.84156
R939 avdd.n771 avdd.n378 5.84156
R940 avdd.n20 avdd.n380 5.84156
R941 avdd.n836 avdd.n242 5.84101
R942 avdd.n837 avdd.n244 5.84101
R943 avdd.n838 avdd.n246 5.84101
R944 avdd.n839 avdd.n248 5.84101
R945 avdd.n851 avdd.n254 5.84101
R946 avdd.n852 avdd.n256 5.84101
R947 avdd.n853 avdd.n258 5.84101
R948 avdd.n854 avdd.n260 5.84101
R949 avdd.n855 avdd.n262 5.84101
R950 avdd.n856 avdd.n264 5.84101
R951 avdd.n19 avdd.n266 5.84101
R952 avdd.n868 avdd.n275 5.84101
R953 avdd.n869 avdd.n277 5.84101
R954 avdd.n870 avdd.n279 5.84101
R955 avdd.n871 avdd.n281 5.84101
R956 avdd.n872 avdd.n283 5.84101
R957 avdd.n873 avdd.n285 5.84101
R958 avdd.n874 avdd.n287 5.84101
R959 avdd.n875 avdd.n289 5.84101
R960 avdd.n876 avdd.n291 5.84101
R961 avdd.n877 avdd.n293 5.84101
R962 avdd.n751 avdd.n750 4.6355
R963 avdd.n384 avdd.n383 4.59487
R964 avdd.n4 avdd.n5 1.36007
R965 avdd.n668 avdd.n656 4.56198
R966 avdd.n683 avdd.n651 4.56161
R967 avdd.n693 avdd.n640 4.56123
R968 avdd.n4 avdd.n877 4.82916
R969 avdd.n537 avdd.n536 4.50652
R970 avdd.n617 avdd.n616 4.50652
R971 avdd.n3 avdd.n27 2.24018
R972 avdd.n888 avdd.n887 4.5005
R973 avdd.n885 avdd.n884 4.5005
R974 avdd.n792 avdd.n779 4.5005
R975 avdd.n830 avdd.n775 4.5005
R976 avdd.n881 avdd.n880 4.5005
R977 avdd.n847 avdd.n846 4.5005
R978 avdd.n7 avdd.n6 1.36007
R979 avdd.n762 avdd.n761 4.5005
R980 avdd.n25 avdd.n24 0.273405
R981 avdd.n682 avdd.n11 4.5005
R982 avdd.n692 avdd.n691 4.5005
R983 avdd.n27 avdd.n383 4.5005
R984 avdd.n887 avdd.n886 4.5005
R985 avdd.n828 avdd.n827 4.5005
R986 avdd.n623 avdd.n26 4.487
R987 avdd.n611 avdd.n610 4.37586
R988 avdd.n879 avdd.n878 4.2755
R989 avdd.n636 avdd.n629 3.93223
R990 avdd.n632 avdd.n631 3.72782
R991 avdd.n23 avdd.n22 3.2255
R992 avdd.n18 avdd.n783 3.14825
R993 avdd.n20 avdd.n766 3.11
R994 avdd.n542 avdd.n541 3.0605
R995 avdd.n477 avdd.n8 2.948
R996 avdd.n796 avdd.n795 2.8805
R997 avdd.n884 avdd.n883 2.8805
R998 avdd.n847 avdd.n845 2.8805
R999 avdd.n763 avdd.n762 2.8805
R1000 avdd.n758 avdd.n757 2.8805
R1001 avdd.n746 avdd.n745 2.8805
R1002 avdd.n427 avdd.n426 2.8805
R1003 avdd.n430 avdd.n429 2.8805
R1004 avdd.n514 avdd.n513 2.8805
R1005 avdd.n512 avdd.n511 2.8805
R1006 avdd.n561 avdd.n560 2.8805
R1007 avdd.n748 avdd.n747 2.8805
R1008 avdd.n829 avdd.n828 2.8805
R1009 avdd.n522 avdd.n9 2.8505
R1010 avdd.n722 avdd.n601 2.7905
R1011 avdd.n504 avdd.n503 2.7905
R1012 avdd.n755 avdd.n754 2.7455
R1013 avdd.n825 avdd.n822 2.7005
R1014 avdd.n819 avdd.n779 2.7005
R1015 avdd.n594 avdd.n593 2.7005
R1016 avdd.n559 avdd.n558 2.7005
R1017 avdd.n431 avdd.n430 2.7005
R1018 avdd.n9 avdd.n509 2.7005
R1019 avdd.n515 avdd.n514 2.7005
R1020 avdd.n513 avdd.n512 2.7005
R1021 avdd.n565 avdd.n564 2.7005
R1022 avdd.n793 avdd.n792 2.6555
R1023 avdd.n801 avdd.n800 2.6555
R1024 avdd.n791 avdd.n1 1.13051
R1025 avdd.n791 avdd.n790 2.6105
R1026 avdd.n790 avdd.n780 2.6105
R1027 avdd.n781 avdd.n780 2.6105
R1028 avdd.n17 avdd.n781 2.6105
R1029 avdd.n18 avdd.n17 2.6105
R1030 avdd.n19 avdd.n839 2.6105
R1031 avdd.n839 avdd.n838 2.6105
R1032 avdd.n838 avdd.n837 2.6105
R1033 avdd.n837 avdd.n836 2.6105
R1034 avdd.n856 avdd.n855 2.6105
R1035 avdd.n855 avdd.n854 2.6105
R1036 avdd.n854 avdd.n853 2.6105
R1037 avdd.n853 avdd.n852 2.6105
R1038 avdd.n852 avdd.n851 2.6105
R1039 avdd.n848 avdd.n847 2.6105
R1040 avdd.n877 avdd.n876 2.6105
R1041 avdd.n876 avdd.n875 2.6105
R1042 avdd.n875 avdd.n874 2.6105
R1043 avdd.n874 avdd.n873 2.6105
R1044 avdd.n873 avdd.n872 2.6105
R1045 avdd.n872 avdd.n871 2.6105
R1046 avdd.n871 avdd.n870 2.6105
R1047 avdd.n870 avdd.n869 2.6105
R1048 avdd.n869 avdd.n868 2.6105
R1049 avdd.n734 avdd.n733 2.6105
R1050 avdd.n731 avdd.n21 2.6105
R1051 avdd.n450 avdd.n449 2.6105
R1052 avdd.n449 avdd.n448 2.6105
R1053 avdd.n448 avdd.n447 2.6105
R1054 avdd.n447 avdd.n446 2.6105
R1055 avdd.n446 avdd.n445 2.6105
R1056 avdd.n521 avdd.n520 2.6105
R1057 avdd.n520 avdd.n519 2.6105
R1058 avdd.n519 avdd.n518 2.6105
R1059 avdd.n518 avdd.n517 2.6105
R1060 avdd.n517 avdd.n516 2.6105
R1061 avdd.n730 avdd.n729 2.6105
R1062 avdd.n729 avdd.n728 2.6105
R1063 avdd.n728 avdd.n727 2.6105
R1064 avdd.n20 avdd.n771 2.6105
R1065 avdd.n771 avdd.n770 2.6105
R1066 avdd.n770 avdd.n769 2.6105
R1067 avdd.n769 avdd.n768 2.6105
R1068 avdd.n768 avdd.n767 2.6105
R1069 avdd.n27 avdd.n890 2.6105
R1070 avdd.n809 avdd.n806 2.6105
R1071 avdd.n810 avdd.n809 2.6105
R1072 avdd.n811 avdd.n810 2.6105
R1073 avdd.n806 avdd.n27 2.5955
R1074 avdd.n811 avdd.n805 2.582
R1075 avdd.n732 avdd.n731 2.567
R1076 avdd.n451 avdd.n450 2.5655
R1077 avdd.n890 avdd.n16 2.5655
R1078 avdd.n575 avdd.n574 2.5205
R1079 avdd.n574 avdd.n573 2.5205
R1080 avdd.n573 avdd.n572 2.5205
R1081 avdd.n571 avdd.n570 2.3405
R1082 avdd.n569 avdd.n568 2.3405
R1083 avdd.n555 avdd.n554 2.2955
R1084 avdd.n271 avdd.n5 0.0210888
R1085 avdd.n6 avdd.n294 0.0210888
R1086 avdd.n385 avdd.n384 0.028787
R1087 avdd.n570 avdd.n569 2.1605
R1088 avdd.n549 avdd.n548 2.1605
R1089 avdd.n460 avdd.n459 2.1155
R1090 avdd.n782 avdd.n775 2.0705
R1091 avdd.n753 avdd.n751 1.9805
R1092 avdd.n558 avdd.n557 1.9805
R1093 avdd.n547 avdd.n546 1.9805
R1094 avdd.n545 avdd.n544 1.9805
R1095 avdd.n543 avdd.n542 1.9805
R1096 avdd.n469 avdd.n468 1.9805
R1097 avdd.n467 avdd.n466 1.9805
R1098 avdd.n485 avdd.n484 1.9805
R1099 avdd.n483 avdd.n482 1.9805
R1100 avdd.n527 avdd.n526 1.9805
R1101 avdd.n525 avdd.n524 1.9805
R1102 avdd.n533 avdd.n532 1.9805
R1103 avdd.n550 avdd.n549 1.9805
R1104 avdd.n655 avdd.n654 1.96817
R1105 avdd.n624 avdd.n623 1.9355
R1106 avdd.n552 avdd.n547 1.8905
R1107 avdd.n706 avdd.n705 1.8455
R1108 avdd.n621 avdd.n620 1.8455
R1109 avdd.n885 avdd.n774 1.8005
R1110 avdd.n798 avdd.n796 1.8005
R1111 avdd.n861 avdd.n860 1.8005
R1112 avdd.n863 avdd.n862 1.8005
R1113 avdd.n865 avdd.n864 1.8005
R1114 avdd.n845 avdd.n844 1.8005
R1115 avdd.n841 avdd.n840 1.8005
R1116 avdd.n761 avdd.n760 1.8005
R1117 avdd.n757 avdd.n756 1.8005
R1118 avdd.n745 avdd.n744 1.8005
R1119 avdd.n738 avdd.n737 1.8005
R1120 avdd.n426 avdd.n425 1.8005
R1121 avdd.n546 avdd.n545 1.8005
R1122 avdd.n544 avdd.n543 1.8005
R1123 avdd.n470 avdd.n469 1.8005
R1124 avdd.n468 avdd.n467 1.8005
R1125 avdd.n484 avdd.n483 1.8005
R1126 avdd.n526 avdd.n525 1.8005
R1127 avdd.n532 avdd.n531 1.8005
R1128 avdd.n626 avdd.n625 1.78817
R1129 avdd.n535 avdd.n534 1.77725
R1130 avdd.n882 avdd.n834 1.7555
R1131 avdd.n656 avdd.n655 1.7555
R1132 avdd.n640 avdd.n639 1.7555
R1133 avdd.n638 avdd.n637 1.7555
R1134 avdd.n625 avdd.n624 1.7555
R1135 avdd.n831 avdd.n830 1.7555
R1136 avdd.n705 avdd.n704 1.74317
R1137 avdd.n696 avdd.n695 1.72149
R1138 avdd.n822 avdd.n821 1.7105
R1139 avdd.n591 avdd.n590 1.7105
R1140 avdd.n590 avdd.n589 1.7105
R1141 avdd.n589 avdd.n588 1.7105
R1142 avdd.n588 avdd.n587 1.7105
R1143 avdd.n587 avdd.n586 1.7105
R1144 avdd.n586 avdd.n585 1.7105
R1145 avdd.n585 avdd.n584 1.7105
R1146 avdd.n584 avdd.n583 1.7105
R1147 avdd.n583 avdd.n582 1.7105
R1148 avdd.n582 avdd.n581 1.7105
R1149 avdd.n581 avdd.n580 1.7105
R1150 avdd.n539 avdd.n432 1.7105
R1151 avdd.n435 avdd.n432 1.7105
R1152 avdd.n436 avdd.n435 1.7105
R1153 avdd.n437 avdd.n436 1.7105
R1154 avdd.n438 avdd.n437 1.7105
R1155 avdd.n439 avdd.n438 1.7105
R1156 avdd.n440 avdd.n439 1.7105
R1157 avdd.n441 avdd.n440 1.7105
R1158 avdd.n442 avdd.n441 1.7105
R1159 avdd.n443 avdd.n442 1.7105
R1160 avdd.n444 avdd.n443 1.7105
R1161 avdd.n22 avdd.n444 1.7105
R1162 avdd.n459 avdd.n458 1.7105
R1163 avdd.n458 avdd.n457 1.7105
R1164 avdd.n457 avdd.n456 1.7105
R1165 avdd.n456 avdd.n455 1.7105
R1166 avdd.n455 avdd.n454 1.7105
R1167 avdd.n454 avdd.n453 1.7105
R1168 avdd.n477 avdd.n476 1.7105
R1169 avdd.n8 avdd.n472 1.7105
R1170 avdd.n472 avdd.n471 1.7105
R1171 avdd.n475 avdd.n474 1.7105
R1172 avdd.n474 avdd.n473 1.7105
R1173 avdd.n707 avdd.n706 1.7105
R1174 avdd.n700 avdd.n699 1.7105
R1175 avdd.n699 avdd.n698 1.7105
R1176 avdd.n697 avdd.n696 1.7105
R1177 avdd.n651 avdd.n650 1.7105
R1178 avdd.n613 avdd.n612 1.7105
R1179 avdd.n26 avdd.n605 1.7105
R1180 avdd.n605 avdd.n604 1.7105
R1181 avdd.n827 avdd.n777 1.7105
R1182 avdd.n620 avdd.n619 1.6895
R1183 avdd.n701 avdd.n700 1.682
R1184 avdd.n592 avdd.n591 1.6805
R1185 avdd.n13 avdd.n627 1.6655
R1186 avdd.n14 avdd.n628 1.6655
R1187 avdd.n15 avdd.n629 1.6655
R1188 avdd.n614 avdd.n613 1.6655
R1189 avdd.n462 avdd.n461 1.5755
R1190 avdd.n718 avdd.n717 1.5755
R1191 avdd.n502 avdd.n501 1.5305
R1192 avdd.n240 avdd.n239 0.0203415
R1193 avdd.n242 avdd.n241 0.0203415
R1194 avdd.n244 avdd.n243 0.0203415
R1195 avdd.n246 avdd.n245 0.0203415
R1196 avdd.n248 avdd.n247 0.0203415
R1197 avdd.n250 avdd.n249 0.0203415
R1198 avdd.n252 avdd.n251 0.0203415
R1199 avdd.n254 avdd.n253 0.0203415
R1200 avdd.n256 avdd.n255 0.0203415
R1201 avdd.n258 avdd.n257 0.0203415
R1202 avdd.n260 avdd.n259 0.0203415
R1203 avdd.n262 avdd.n261 0.0203415
R1204 avdd.n264 avdd.n263 0.0203415
R1205 avdd.n266 avdd.n265 0.0203415
R1206 avdd.n268 avdd.n267 0.0203415
R1207 avdd.n270 avdd.n269 0.0203415
R1208 avdd.n273 avdd.n272 0.0203415
R1209 avdd.n275 avdd.n274 0.0203415
R1210 avdd.n277 avdd.n276 0.0203415
R1211 avdd.n279 avdd.n278 0.0203415
R1212 avdd.n281 avdd.n280 0.0203415
R1213 avdd.n283 avdd.n282 0.0203415
R1214 avdd.n285 avdd.n284 0.0203415
R1215 avdd.n287 avdd.n286 0.0203415
R1216 avdd.n289 avdd.n288 0.0203415
R1217 avdd.n291 avdd.n290 0.0203415
R1218 avdd.n293 avdd.n292 0.0203415
R1219 avdd.n298 avdd.n297 0.020531
R1220 avdd.n300 avdd.n299 0.020531
R1221 avdd.n302 avdd.n301 0.020531
R1222 avdd.n304 avdd.n303 0.020531
R1223 avdd.n346 avdd.n345 0.020531
R1224 avdd.n348 avdd.n347 0.020531
R1225 avdd.n350 avdd.n349 0.020531
R1226 avdd.n352 avdd.n351 0.020531
R1227 avdd.n354 avdd.n353 0.020531
R1228 avdd.n356 avdd.n355 0.020531
R1229 avdd.n358 avdd.n357 0.020531
R1230 avdd.n360 avdd.n359 0.020531
R1231 avdd.n362 avdd.n361 0.020531
R1232 avdd.n364 avdd.n363 0.020531
R1233 avdd.n366 avdd.n365 0.020531
R1234 avdd.n368 avdd.n367 0.020531
R1235 avdd.n370 avdd.n369 0.020531
R1236 avdd.n372 avdd.n371 0.020531
R1237 avdd.n374 avdd.n373 0.020531
R1238 avdd.n376 avdd.n375 0.020531
R1239 avdd.n378 avdd.n377 0.020531
R1240 avdd.n380 avdd.n379 0.020531
R1241 avdd.n382 avdd.n381 0.020531
R1242 avdd.n296 avdd.n295 0.0205689
R1243 avdd.n387 avdd.n386 0.0205689
R1244 avdd.n389 avdd.n388 0.0205689
R1245 avdd.n391 avdd.n390 0.0205689
R1246 avdd.n393 avdd.n392 0.0205689
R1247 avdd.n395 avdd.n394 0.0205689
R1248 avdd.n397 avdd.n396 0.0205689
R1249 avdd.n399 avdd.n398 0.0205689
R1250 avdd.n401 avdd.n400 0.0205689
R1251 avdd.n403 avdd.n402 0.0205689
R1252 avdd.n405 avdd.n404 0.0205689
R1253 avdd.n407 avdd.n406 0.0205689
R1254 avdd.n409 avdd.n408 0.0205689
R1255 avdd.n411 avdd.n410 0.0205689
R1256 avdd.n413 avdd.n412 0.0205689
R1257 avdd.n415 avdd.n414 0.0205689
R1258 avdd.n417 avdd.n416 0.0205689
R1259 avdd.n419 avdd.n418 0.0205689
R1260 avdd.n421 avdd.n420 0.0205689
R1261 avdd.n306 avdd.n305 0.0236016
R1262 avdd.n308 avdd.n307 0.0236016
R1263 avdd.n310 avdd.n309 0.0236016
R1264 avdd.n312 avdd.n311 0.0236016
R1265 avdd.n314 avdd.n313 0.0236016
R1266 avdd.n316 avdd.n315 0.0236016
R1267 avdd.n318 avdd.n317 0.0236016
R1268 avdd.n320 avdd.n319 0.0236016
R1269 avdd.n322 avdd.n321 0.0236016
R1270 avdd.n324 avdd.n323 0.0236016
R1271 avdd.n326 avdd.n325 0.0236016
R1272 avdd.n328 avdd.n327 0.0236016
R1273 avdd.n330 avdd.n329 0.0236016
R1274 avdd.n332 avdd.n331 0.0236016
R1275 avdd.n334 avdd.n333 0.0236016
R1276 avdd.n336 avdd.n335 0.0236016
R1277 avdd.n338 avdd.n337 0.0236016
R1278 avdd.n340 avdd.n339 0.0236016
R1279 avdd.n342 avdd.n341 0.0236016
R1280 avdd.n344 avdd.n343 0.0236016
R1281 avdd.n668 avdd.n25 1.31496
R1282 avdd.n711 avdd.n710 1.4405
R1283 avdd.n712 avdd.n711 1.4405
R1284 avdd.n713 avdd.n712 1.4405
R1285 avdd.n714 avdd.n713 1.4405
R1286 avdd.n635 avdd.n634 1.4405
R1287 avdd.n646 avdd.n645 1.4405
R1288 avdd.n643 avdd.n642 1.4405
R1289 avdd.n672 avdd.n671 1.4405
R1290 avdd.n671 avdd.n670 1.4405
R1291 avdd.n664 avdd.n663 1.4405
R1292 avdd.n663 avdd.n662 1.4405
R1293 avdd.n170 avdd.n169 0.0282666
R1294 avdd.n172 avdd.n171 0.0282666
R1295 avdd.n174 avdd.n173 0.0282666
R1296 avdd.n176 avdd.n175 0.0282666
R1297 avdd.n178 avdd.n177 0.0282666
R1298 avdd.n180 avdd.n179 0.0282666
R1299 avdd.n182 avdd.n181 0.0282666
R1300 avdd.n184 avdd.n183 0.0282666
R1301 avdd.n186 avdd.n185 0.0282666
R1302 avdd.n188 avdd.n187 0.0282666
R1303 avdd.n190 avdd.n189 0.0282666
R1304 avdd.n192 avdd.n191 0.0282666
R1305 avdd.n194 avdd.n193 0.0282666
R1306 avdd.n196 avdd.n195 0.0282666
R1307 avdd.n198 avdd.n197 0.0282666
R1308 avdd.n200 avdd.n199 0.0282666
R1309 avdd.n202 avdd.n201 0.0282666
R1310 avdd.n204 avdd.n203 0.0282666
R1311 avdd.n206 avdd.n205 0.0282666
R1312 avdd.n618 avdd.n207 1.43481
R1313 avdd.n209 avdd.n208 0.0282666
R1314 avdd.n211 avdd.n210 0.0282666
R1315 avdd.n213 avdd.n212 0.0282666
R1316 avdd.n215 avdd.n214 0.0282666
R1317 avdd.n217 avdd.n216 0.0282666
R1318 avdd.n219 avdd.n218 0.0282666
R1319 avdd.n221 avdd.n220 0.0282666
R1320 avdd.n223 avdd.n222 0.0282666
R1321 avdd.n225 avdd.n224 0.0282666
R1322 avdd.n227 avdd.n226 0.0282666
R1323 avdd.n229 avdd.n228 0.0282666
R1324 avdd.n231 avdd.n230 0.0282666
R1325 avdd.n233 avdd.n232 0.0282666
R1326 avdd.n235 avdd.n234 0.0282666
R1327 avdd.n100 avdd.n99 0.0345514
R1328 avdd.n102 avdd.n101 0.0345514
R1329 avdd.n104 avdd.n103 0.0345514
R1330 avdd.n106 avdd.n105 0.0345514
R1331 avdd.n108 avdd.n107 0.0345514
R1332 avdd.n110 avdd.n109 0.0345514
R1333 avdd.n112 avdd.n111 0.0345514
R1334 avdd.n114 avdd.n113 0.0345514
R1335 avdd.n116 avdd.n115 0.0345514
R1336 avdd.n118 avdd.n117 0.0345514
R1337 avdd.n120 avdd.n119 0.0345514
R1338 avdd.n122 avdd.n121 0.0345514
R1339 avdd.n124 avdd.n123 0.0345514
R1340 avdd.n126 avdd.n125 0.0345514
R1341 avdd.n128 avdd.n127 0.0345514
R1342 avdd.n130 avdd.n129 0.0345514
R1343 avdd.n132 avdd.n131 0.0345514
R1344 avdd.n134 avdd.n133 0.0345514
R1345 avdd.n136 avdd.n135 0.0345514
R1346 avdd.n138 avdd.n137 0.0345514
R1347 avdd.n30 avdd.n29 0.0395454
R1348 avdd.n32 avdd.n31 0.0395454
R1349 avdd.n34 avdd.n33 0.0395454
R1350 avdd.n36 avdd.n35 0.0395454
R1351 avdd.n38 avdd.n37 0.0395454
R1352 avdd.n40 avdd.n39 0.0395454
R1353 avdd.n42 avdd.n41 0.0395454
R1354 avdd.n44 avdd.n43 0.0395454
R1355 avdd.n46 avdd.n45 0.0395454
R1356 avdd.n48 avdd.n47 0.0395454
R1357 avdd.n50 avdd.n49 0.0395454
R1358 avdd.n52 avdd.n51 0.0395454
R1359 avdd.n54 avdd.n53 0.0395454
R1360 avdd.n56 avdd.n55 0.0395454
R1361 avdd.n58 avdd.n57 0.0395454
R1362 avdd.n60 avdd.n59 0.0395454
R1363 avdd.n62 avdd.n61 0.0395454
R1364 avdd.n64 avdd.n63 0.0395454
R1365 avdd.n66 avdd.n65 0.0395454
R1366 avdd.n68 avdd.n67 0.0395454
R1367 avdd.n70 avdd.n69 0.0395454
R1368 avdd.n72 avdd.n71 0.0395454
R1369 avdd.n538 avdd.t705 1.38724
R1370 avdd.n24 avdd.n667 1.3805
R1371 avdd.n827 avdd.n826 1.3655
R1372 avdd.n11 avdd.n675 1.3505
R1373 avdd.n522 avdd.n22 1.34105
R1374 avdd.n832 avdd.n775 1.2855
R1375 avdd.n541 avdd.n540 1.2605
R1376 avdd.n633 avdd.n632 1.22379
R1377 avdd.n15 avdd.n701 1.22082
R1378 avdd.n596 avdd.n595 1.2155
R1379 avdd.n694 avdd.n635 1.2155
R1380 avdd.n692 avdd.n646 1.2155
R1381 avdd.n709 avdd.n708 1.1705
R1382 avdd.n623 avdd.n622 1.1705
R1383 avdd avdd.n889 1.1295
R1384 avdd.n826 avdd.n825 1.1255
R1385 avdd.n822 avdd.n778 1.1255
R1386 avdd.n819 avdd.n818 1.1255
R1387 avdd.n817 avdd.n779 1.1255
R1388 avdd.n681 avdd.n669 1.1255
R1389 avdd.n690 avdd.n684 1.1255
R1390 avdd.n860 avdd.n859 1.0805
R1391 avdd.n864 avdd.n863 1.0805
R1392 avdd.n737 avdd.n736 1.0805
R1393 avdd.n601 avdd.n600 1.0805
R1394 avdd.n733 avdd.n732 1.06944
R1395 avdd.n609 avdd.n606 0.9905
R1396 avdd.n880 avdd.n879 0.9455
R1397 avdd.n795 avdd.n774 0.9005
R1398 avdd.n799 avdd.n798 0.9005
R1399 avdd.n883 avdd.n882 0.9005
R1400 avdd.n862 avdd.n861 0.9005
R1401 avdd.n866 avdd.n865 0.9005
R1402 avdd.n849 avdd.n848 0.9005
R1403 avdd.n764 avdd.n763 0.9005
R1404 avdd.n760 avdd.n758 0.9005
R1405 avdd.n753 avdd.n752 0.9005
R1406 avdd.n749 avdd.n746 0.9005
R1407 avdd.n744 avdd.n742 0.9005
R1408 avdd.n738 avdd.n427 0.9005
R1409 avdd.n425 avdd.n423 0.9005
R1410 avdd.n724 avdd.n428 0.9005
R1411 avdd.n557 avdd.n431 0.9005
R1412 avdd.n830 avdd.n829 0.9005
R1413 avdd.n851 avdd.n850 0.8555
R1414 avdd.n821 avdd.n819 0.8105
R1415 avdd.n609 avdd.n608 0.8105
R1416 avdd.n825 avdd.n777 0.8105
R1417 avdd.n523 avdd.n522 0.725787
R1418 avdd.n578 avdd.n571 0.7205
R1419 avdd.n694 avdd.n693 0.7205
R1420 avdd.n889 avdd.n885 0.5855
R1421 avdd.n538 avdd.n434 0.551312
R1422 avdd.n494 avdd.n470 0.5405
R1423 avdd.n618 avdd.n616 0.501038
R1424 avdd.n553 avdd.n552 0.4955
R1425 avdd.n878 avdd.n867 0.47529
R1426 avdd.n878 avdd.n7 2.68284
R1427 avdd.n498 avdd.n497 0.4505
R1428 avdd.n610 avdd.n609 0.4505
R1429 avdd.n691 avdd.n690 0.411125
R1430 avdd.n536 avdd.n434 0.409662
R1431 avdd.n74 avdd.n73 0.0768096
R1432 avdd.n76 avdd.n75 0.0768096
R1433 avdd.n78 avdd.n77 0.0768096
R1434 avdd.n80 avdd.n79 0.0768096
R1435 avdd.n82 avdd.n81 0.0768096
R1436 avdd.n84 avdd.n83 0.0768096
R1437 avdd.n86 avdd.n85 0.0768096
R1438 avdd.n88 avdd.n87 0.0768096
R1439 avdd.n90 avdd.n89 0.0768096
R1440 avdd.n92 avdd.n91 0.0768096
R1441 avdd.n94 avdd.n93 0.0768096
R1442 avdd.n96 avdd.n95 0.0768096
R1443 avdd.n98 avdd.n97 0.0768096
R1444 avdd.t705 avdd.n537 0.402089
R1445 avdd.n140 avdd.n139 0.0768096
R1446 avdd.n142 avdd.n141 0.0768096
R1447 avdd.n144 avdd.n143 0.0768096
R1448 avdd.n146 avdd.n145 0.0768096
R1449 avdd.n148 avdd.n147 0.0768096
R1450 avdd.n150 avdd.n149 0.0768096
R1451 avdd.n152 avdd.n151 0.0768096
R1452 avdd.n154 avdd.n153 0.0768096
R1453 avdd.n156 avdd.n155 0.0768096
R1454 avdd.n158 avdd.n157 0.0768096
R1455 avdd.n160 avdd.n159 0.0768096
R1456 avdd.n162 avdd.n161 0.0768096
R1457 avdd.n164 avdd.n163 0.0768096
R1458 avdd.n166 avdd.n165 0.0768096
R1459 avdd.n168 avdd.n167 0.0768096
R1460 avdd.n619 avdd.n611 0.399831
R1461 avdd.n684 avdd.n683 0.398975
R1462 avdd.n669 avdd.n668 0.383225
R1463 avdd.n486 avdd.n485 0.3605
R1464 avdd.n682 avdd.n669 0.337775
R1465 avdd.n886 avdd.n383 0.326525
R1466 avdd.n692 avdd.n684 0.322025
R1467 avdd.n478 avdd.n477 0.3155
R1468 avdd.n889 avdd.n888 0.291612
R1469 avdd.n689 avdd.n688 0.2885
R1470 avdd.n688 avdd.n687 0.2885
R1471 avdd.n687 avdd.n686 0.2885
R1472 avdd.n686 avdd.n685 0.2885
R1473 avdd.n680 avdd.n679 0.2885
R1474 avdd.n679 avdd.n678 0.2885
R1475 avdd.n678 avdd.n677 0.2885
R1476 avdd.n677 avdd.n676 0.2885
R1477 avdd.n661 avdd.n660 0.2885
R1478 avdd.n660 avdd.n659 0.2885
R1479 avdd.n659 avdd.n658 0.2885
R1480 avdd.n658 avdd.n657 0.2885
R1481 avdd.n794 avdd.n0 0.284152
R1482 avdd.n169 avdd.t533 0.259912
R1483 avdd.n169 avdd.t534 0.259912
R1484 avdd.n171 avdd.t537 0.259912
R1485 avdd.n171 avdd.t538 0.259912
R1486 avdd.n173 avdd.t541 0.259912
R1487 avdd.n173 avdd.t542 0.259912
R1488 avdd.n175 avdd.t557 0.259912
R1489 avdd.n175 avdd.t558 0.259912
R1490 avdd.n177 avdd.t561 0.259912
R1491 avdd.n177 avdd.t562 0.259912
R1492 avdd.n179 avdd.t565 0.259912
R1493 avdd.n179 avdd.t566 0.259912
R1494 avdd.n181 avdd.t581 0.259912
R1495 avdd.n181 avdd.t582 0.259912
R1496 avdd.n183 avdd.t585 0.259912
R1497 avdd.n183 avdd.t586 0.259912
R1498 avdd.n185 avdd.t589 0.259912
R1499 avdd.n185 avdd.t590 0.259912
R1500 avdd.n187 avdd.t625 0.259912
R1501 avdd.n187 avdd.t626 0.259912
R1502 avdd.n189 avdd.t621 0.259912
R1503 avdd.n189 avdd.t622 0.259912
R1504 avdd.n191 avdd.t617 0.259912
R1505 avdd.n191 avdd.t618 0.259912
R1506 avdd.n193 avdd.t613 0.259912
R1507 avdd.n193 avdd.t614 0.259912
R1508 avdd.n195 avdd.t609 0.259912
R1509 avdd.n195 avdd.t610 0.259912
R1510 avdd.n197 avdd.t605 0.259912
R1511 avdd.n197 avdd.t606 0.259912
R1512 avdd.n199 avdd.t601 0.259912
R1513 avdd.n199 avdd.t602 0.259912
R1514 avdd.n201 avdd.t577 0.259912
R1515 avdd.n201 avdd.t578 0.259912
R1516 avdd.n203 avdd.t553 0.259912
R1517 avdd.n203 avdd.t554 0.259912
R1518 avdd.n205 avdd.t529 0.259912
R1519 avdd.n205 avdd.t530 0.259912
R1520 avdd.n207 avdd.t425 0.259912
R1521 avdd.n207 avdd.t426 0.259912
R1522 avdd.n208 avdd.t385 0.259912
R1523 avdd.n208 avdd.t386 0.259912
R1524 avdd.n210 avdd.t389 0.259912
R1525 avdd.n210 avdd.t390 0.259912
R1526 avdd.n212 avdd.t393 0.259912
R1527 avdd.n212 avdd.t394 0.259912
R1528 avdd.n214 avdd.t397 0.259912
R1529 avdd.n214 avdd.t398 0.259912
R1530 avdd.n216 avdd.t401 0.259912
R1531 avdd.n216 avdd.t402 0.259912
R1532 avdd.n218 avdd.t405 0.259912
R1533 avdd.n218 avdd.t406 0.259912
R1534 avdd.n220 avdd.t409 0.259912
R1535 avdd.n220 avdd.t410 0.259912
R1536 avdd.n222 avdd.t421 0.259912
R1537 avdd.n222 avdd.t422 0.259912
R1538 avdd.n224 avdd.t417 0.259912
R1539 avdd.n224 avdd.t418 0.259912
R1540 avdd.n226 avdd.t413 0.259912
R1541 avdd.n226 avdd.t414 0.259912
R1542 avdd.n228 avdd.t429 0.259912
R1543 avdd.n228 avdd.t430 0.259912
R1544 avdd.n230 avdd.t433 0.259912
R1545 avdd.n230 avdd.t434 0.259912
R1546 avdd.n232 avdd.t437 0.259912
R1547 avdd.n232 avdd.t438 0.259912
R1548 avdd.n234 avdd.t441 0.259912
R1549 avdd.n234 avdd.t442 0.259912
R1550 avdd.n29 avdd.t469 0.257728
R1551 avdd.n29 avdd.t470 0.257728
R1552 avdd.n31 avdd.t465 0.257728
R1553 avdd.n31 avdd.t466 0.257728
R1554 avdd.n33 avdd.t461 0.257728
R1555 avdd.n33 avdd.t462 0.257728
R1556 avdd.n35 avdd.t457 0.257728
R1557 avdd.n35 avdd.t458 0.257728
R1558 avdd.n37 avdd.t453 0.257728
R1559 avdd.n37 avdd.t454 0.257728
R1560 avdd.n39 avdd.t449 0.257728
R1561 avdd.n39 avdd.t450 0.257728
R1562 avdd.n41 avdd.t657 0.257728
R1563 avdd.n41 avdd.t658 0.257728
R1564 avdd.n43 avdd.t653 0.257728
R1565 avdd.n43 avdd.t654 0.257728
R1566 avdd.n45 avdd.t649 0.257728
R1567 avdd.n45 avdd.t650 0.257728
R1568 avdd.n47 avdd.t645 0.257728
R1569 avdd.n47 avdd.t646 0.257728
R1570 avdd.n49 avdd.t641 0.257728
R1571 avdd.n49 avdd.t642 0.257728
R1572 avdd.n51 avdd.t637 0.257728
R1573 avdd.n51 avdd.t638 0.257728
R1574 avdd.n53 avdd.t633 0.257728
R1575 avdd.n53 avdd.t634 0.257728
R1576 avdd.n55 avdd.t629 0.257728
R1577 avdd.n55 avdd.t630 0.257728
R1578 avdd.n57 avdd.t593 0.257728
R1579 avdd.n57 avdd.t594 0.257728
R1580 avdd.n59 avdd.t597 0.257728
R1581 avdd.n59 avdd.t598 0.257728
R1582 avdd.n61 avdd.t569 0.257728
R1583 avdd.n61 avdd.t570 0.257728
R1584 avdd.n63 avdd.t573 0.257728
R1585 avdd.n63 avdd.t574 0.257728
R1586 avdd.n65 avdd.t549 0.257728
R1587 avdd.n65 avdd.t550 0.257728
R1588 avdd.n67 avdd.t545 0.257728
R1589 avdd.n67 avdd.t546 0.257728
R1590 avdd.n69 avdd.t445 0.257728
R1591 avdd.n69 avdd.t446 0.257728
R1592 avdd.n71 avdd.t473 0.257728
R1593 avdd.n71 avdd.t474 0.257728
R1594 avdd.n826 avdd.n778 0.2565
R1595 avdd.n818 avdd.n817 0.2565
R1596 avdd.n693 avdd.n692 0.2525
R1597 avdd.n683 avdd.n682 0.2525
R1598 avdd.n818 avdd.n778 0.2405
R1599 avdd.n879 avdd.n834 0.234387
R1600 avdd.n239 avdd.t145 0.227567
R1601 avdd.n239 avdd.t146 0.227567
R1602 avdd.n241 avdd.t141 0.227567
R1603 avdd.n241 avdd.t142 0.227567
R1604 avdd.n243 avdd.t137 0.227567
R1605 avdd.n243 avdd.t138 0.227567
R1606 avdd.n245 avdd.t133 0.227567
R1607 avdd.n245 avdd.t134 0.227567
R1608 avdd.n247 avdd.t129 0.227567
R1609 avdd.n247 avdd.t130 0.227567
R1610 avdd.n249 avdd.t97 0.227567
R1611 avdd.n249 avdd.t98 0.227567
R1612 avdd.n251 avdd.t181 0.227567
R1613 avdd.n251 avdd.t182 0.227567
R1614 avdd.n253 avdd.t101 0.227567
R1615 avdd.n253 avdd.t102 0.227567
R1616 avdd.n255 avdd.t105 0.227567
R1617 avdd.n255 avdd.t106 0.227567
R1618 avdd.n257 avdd.t109 0.227567
R1619 avdd.n257 avdd.t110 0.227567
R1620 avdd.n259 avdd.t113 0.227567
R1621 avdd.n259 avdd.t114 0.227567
R1622 avdd.n261 avdd.t117 0.227567
R1623 avdd.n261 avdd.t118 0.227567
R1624 avdd.n263 avdd.t121 0.227567
R1625 avdd.n263 avdd.t122 0.227567
R1626 avdd.n265 avdd.t125 0.227567
R1627 avdd.n265 avdd.t126 0.227567
R1628 avdd.n267 avdd.t185 0.227567
R1629 avdd.n267 avdd.t186 0.227567
R1630 avdd.n269 avdd.t189 0.227567
R1631 avdd.n269 avdd.t190 0.227567
R1632 avdd.n271 avdd.t245 0.227567
R1633 avdd.n271 avdd.t246 0.227567
R1634 avdd.n272 avdd.t201 0.227567
R1635 avdd.n272 avdd.t202 0.227567
R1636 avdd.n274 avdd.t205 0.227567
R1637 avdd.n274 avdd.t206 0.227567
R1638 avdd.n276 avdd.t209 0.227567
R1639 avdd.n276 avdd.t210 0.227567
R1640 avdd.n278 avdd.t213 0.227567
R1641 avdd.n278 avdd.t214 0.227567
R1642 avdd.n280 avdd.t217 0.227567
R1643 avdd.n280 avdd.t218 0.227567
R1644 avdd.n282 avdd.t221 0.227567
R1645 avdd.n282 avdd.t222 0.227567
R1646 avdd.n284 avdd.t225 0.227567
R1647 avdd.n284 avdd.t226 0.227567
R1648 avdd.n286 avdd.t229 0.227567
R1649 avdd.n286 avdd.t230 0.227567
R1650 avdd.n288 avdd.t233 0.227567
R1651 avdd.n288 avdd.t234 0.227567
R1652 avdd.n290 avdd.t237 0.227567
R1653 avdd.n290 avdd.t238 0.227567
R1654 avdd.n292 avdd.t241 0.227567
R1655 avdd.n292 avdd.t242 0.227567
R1656 avdd.n294 avdd.t249 0.227567
R1657 avdd.n294 avdd.t250 0.227567
R1658 avdd.n297 avdd.t325 0.226542
R1659 avdd.n297 avdd.t326 0.226542
R1660 avdd.n299 avdd.t333 0.226542
R1661 avdd.n299 avdd.t334 0.226542
R1662 avdd.n301 avdd.t329 0.226542
R1663 avdd.n301 avdd.t330 0.226542
R1664 avdd.n303 avdd.t349 0.226542
R1665 avdd.n303 avdd.t350 0.226542
R1666 avdd.n345 avdd.t381 0.226542
R1667 avdd.n345 avdd.t382 0.226542
R1668 avdd.n347 avdd.t377 0.226542
R1669 avdd.n347 avdd.t378 0.226542
R1670 avdd.n349 avdd.t373 0.226542
R1671 avdd.n349 avdd.t374 0.226542
R1672 avdd.n351 avdd.t369 0.226542
R1673 avdd.n351 avdd.t370 0.226542
R1674 avdd.n353 avdd.t365 0.226542
R1675 avdd.n353 avdd.t366 0.226542
R1676 avdd.n355 avdd.t361 0.226542
R1677 avdd.n355 avdd.t362 0.226542
R1678 avdd.n357 avdd.t357 0.226542
R1679 avdd.n357 avdd.t358 0.226542
R1680 avdd.n359 avdd.t353 0.226542
R1681 avdd.n359 avdd.t354 0.226542
R1682 avdd.n361 avdd.t345 0.226542
R1683 avdd.n361 avdd.t346 0.226542
R1684 avdd.n363 avdd.t341 0.226542
R1685 avdd.n363 avdd.t342 0.226542
R1686 avdd.n365 avdd.t337 0.226542
R1687 avdd.n365 avdd.t338 0.226542
R1688 avdd.n367 avdd.t321 0.226542
R1689 avdd.n367 avdd.t322 0.226542
R1690 avdd.n369 avdd.t317 0.226542
R1691 avdd.n369 avdd.t318 0.226542
R1692 avdd.n371 avdd.t313 0.226542
R1693 avdd.n371 avdd.t314 0.226542
R1694 avdd.n373 avdd.t309 0.226542
R1695 avdd.n373 avdd.t310 0.226542
R1696 avdd.n375 avdd.t305 0.226542
R1697 avdd.n375 avdd.t306 0.226542
R1698 avdd.n377 avdd.t301 0.226542
R1699 avdd.n377 avdd.t302 0.226542
R1700 avdd.n379 avdd.t297 0.226542
R1701 avdd.n379 avdd.t298 0.226542
R1702 avdd.n381 avdd.t293 0.226542
R1703 avdd.n381 avdd.t294 0.226542
R1704 avdd.n295 avdd.t253 0.22634
R1705 avdd.n295 avdd.t254 0.22634
R1706 avdd.n384 avdd.t269 0.22634
R1707 avdd.n384 avdd.t270 0.22634
R1708 avdd.n386 avdd.t289 0.22634
R1709 avdd.n386 avdd.t290 0.22634
R1710 avdd.n388 avdd.t193 0.22634
R1711 avdd.n388 avdd.t194 0.22634
R1712 avdd.n390 avdd.t257 0.22634
R1713 avdd.n390 avdd.t258 0.22634
R1714 avdd.n392 avdd.t285 0.22634
R1715 avdd.n392 avdd.t286 0.22634
R1716 avdd.n394 avdd.t281 0.22634
R1717 avdd.n394 avdd.t282 0.22634
R1718 avdd.n396 avdd.t277 0.22634
R1719 avdd.n396 avdd.t278 0.22634
R1720 avdd.n398 avdd.t273 0.22634
R1721 avdd.n398 avdd.t274 0.22634
R1722 avdd.n400 avdd.t265 0.22634
R1723 avdd.n400 avdd.t266 0.22634
R1724 avdd.n402 avdd.t261 0.22634
R1725 avdd.n402 avdd.t262 0.22634
R1726 avdd.n404 avdd.t149 0.22634
R1727 avdd.n404 avdd.t150 0.22634
R1728 avdd.n406 avdd.t153 0.22634
R1729 avdd.n406 avdd.t154 0.22634
R1730 avdd.n408 avdd.t157 0.22634
R1731 avdd.n408 avdd.t158 0.22634
R1732 avdd.n410 avdd.t161 0.22634
R1733 avdd.n410 avdd.t162 0.22634
R1734 avdd.n412 avdd.t165 0.22634
R1735 avdd.n412 avdd.t166 0.22634
R1736 avdd.n414 avdd.t169 0.22634
R1737 avdd.n414 avdd.t170 0.22634
R1738 avdd.n416 avdd.t173 0.22634
R1739 avdd.n416 avdd.t174 0.22634
R1740 avdd.n418 avdd.t177 0.22634
R1741 avdd.n418 avdd.t178 0.22634
R1742 avdd.n420 avdd.t197 0.22634
R1743 avdd.n420 avdd.t198 0.22634
R1744 avdd.n690 avdd.n689 0.2228
R1745 avdd.n681 avdd.n680 0.2228
R1746 avdd.n25 avdd.n661 0.310592
R1747 avdd.n99 avdd.t880 0.20635
R1748 avdd.n99 avdd.t881 0.20635
R1749 avdd.n101 avdd.t876 0.20635
R1750 avdd.n101 avdd.t877 0.20635
R1751 avdd.n103 avdd.t872 0.20635
R1752 avdd.n103 avdd.t873 0.20635
R1753 avdd.n105 avdd.t868 0.20635
R1754 avdd.n105 avdd.t869 0.20635
R1755 avdd.n107 avdd.t864 0.20635
R1756 avdd.n107 avdd.t865 0.20635
R1757 avdd.n109 avdd.t860 0.20635
R1758 avdd.n109 avdd.t861 0.20635
R1759 avdd.n111 avdd.t856 0.20635
R1760 avdd.n111 avdd.t857 0.20635
R1761 avdd.n113 avdd.t852 0.20635
R1762 avdd.n113 avdd.t853 0.20635
R1763 avdd.n115 avdd.t804 0.20635
R1764 avdd.n115 avdd.t805 0.20635
R1765 avdd.n117 avdd.t792 0.20635
R1766 avdd.n117 avdd.t793 0.20635
R1767 avdd.n119 avdd.t788 0.20635
R1768 avdd.n119 avdd.t789 0.20635
R1769 avdd.n121 avdd.t784 0.20635
R1770 avdd.n121 avdd.t785 0.20635
R1771 avdd.n123 avdd.t764 0.20635
R1772 avdd.n123 avdd.t765 0.20635
R1773 avdd.n125 avdd.t768 0.20635
R1774 avdd.n125 avdd.t769 0.20635
R1775 avdd.n127 avdd.t772 0.20635
R1776 avdd.n127 avdd.t773 0.20635
R1777 avdd.n129 avdd.t776 0.20635
R1778 avdd.n129 avdd.t777 0.20635
R1779 avdd.n131 avdd.t780 0.20635
R1780 avdd.n131 avdd.t781 0.20635
R1781 avdd.n133 avdd.t808 0.20635
R1782 avdd.n133 avdd.t809 0.20635
R1783 avdd.n135 avdd.t848 0.20635
R1784 avdd.n135 avdd.t849 0.20635
R1785 avdd.n137 avdd.t844 0.20635
R1786 avdd.n137 avdd.t845 0.20635
R1787 avdd.n817 avdd.n816 0.2005
R1788 avdd.n305 avdd.t701 0.193083
R1789 avdd.n305 avdd.t702 0.193083
R1790 avdd.n307 avdd.t697 0.193083
R1791 avdd.n307 avdd.t698 0.193083
R1792 avdd.n309 avdd.t693 0.193083
R1793 avdd.n309 avdd.t694 0.193083
R1794 avdd.n311 avdd.t689 0.193083
R1795 avdd.n311 avdd.t690 0.193083
R1796 avdd.n313 avdd.t685 0.193083
R1797 avdd.n313 avdd.t686 0.193083
R1798 avdd.n315 avdd.t681 0.193083
R1799 avdd.n315 avdd.t682 0.193083
R1800 avdd.n317 avdd.t677 0.193083
R1801 avdd.n317 avdd.t678 0.193083
R1802 avdd.n319 avdd.t673 0.193083
R1803 avdd.n319 avdd.t674 0.193083
R1804 avdd.n321 avdd.t760 0.193083
R1805 avdd.n321 avdd.t761 0.193083
R1806 avdd.n323 avdd.t756 0.193083
R1807 avdd.n323 avdd.t757 0.193083
R1808 avdd.n325 avdd.t800 0.193083
R1809 avdd.n325 avdd.t801 0.193083
R1810 avdd.n327 avdd.t796 0.193083
R1811 avdd.n327 avdd.t797 0.193083
R1812 avdd.n329 avdd.t840 0.193083
R1813 avdd.n329 avdd.t841 0.193083
R1814 avdd.n331 avdd.t836 0.193083
R1815 avdd.n331 avdd.t837 0.193083
R1816 avdd.n333 avdd.t832 0.193083
R1817 avdd.n333 avdd.t833 0.193083
R1818 avdd.n335 avdd.t828 0.193083
R1819 avdd.n335 avdd.t829 0.193083
R1820 avdd.n337 avdd.t824 0.193083
R1821 avdd.n337 avdd.t825 0.193083
R1822 avdd.n339 avdd.t820 0.193083
R1823 avdd.n339 avdd.t821 0.193083
R1824 avdd.n341 avdd.t816 0.193083
R1825 avdd.n341 avdd.t817 0.193083
R1826 avdd.n343 avdd.t812 0.193083
R1827 avdd.n343 avdd.t813 0.193083
R1828 avdd.n567 avdd.n566 0.1805
R1829 avdd.n563 avdd.n562 0.1805
R1830 avdd.n808 avdd.n803 0.170875
R1831 avdd.n237 avdd.n238 0.0487132
R1832 avdd.n833 avdd.n832 0.156929
R1833 avdd.n888 avdd.n3 0.17017
R1834 avdd.n236 avdd.n785 0.135989
R1835 avdd.n577 avdd.n576 0.1355
R1836 avdd.n816 avdd.n815 0.128929
R1837 avdd.n789 avdd.n788 0.127989
R1838 avdd.n2 avdd.n0 0.0562901
R1839 avdd.n808 avdd.n807 0.101981
R1840 avdd.n814 avdd.n813 0.1005
R1841 avdd.n786 avdd.n237 0.0943978
R1842 avdd.n812 avdd.n802 0.0904484
R1843 avdd.n890 avdd.n10 9.14876
R1844 avdd.n787 avdd.n786 0.0885
R1845 avdd.n238 avdd.n785 0.0620137
R1846 avdd.n421 avdd.t195 9.56733
R1847 avdd.n419 avdd.t175 9.56733
R1848 avdd.n417 avdd.t171 9.56733
R1849 avdd.n415 avdd.t167 9.56733
R1850 avdd.n413 avdd.t163 9.56733
R1851 avdd.n411 avdd.t159 9.56733
R1852 avdd.n409 avdd.t155 9.56733
R1853 avdd.n407 avdd.t151 9.56733
R1854 avdd.n405 avdd.t147 9.56733
R1855 avdd.n403 avdd.t259 9.56733
R1856 avdd.n401 avdd.t263 9.56733
R1857 avdd.n399 avdd.t271 9.56733
R1858 avdd.n397 avdd.t275 9.56733
R1859 avdd.n395 avdd.t279 9.56733
R1860 avdd.n393 avdd.t283 9.56733
R1861 avdd.n391 avdd.t255 9.56733
R1862 avdd.n389 avdd.t191 9.56733
R1863 avdd.n387 avdd.t287 9.56733
R1864 avdd.t267 avdd.n385 9.55923
R1865 avdd.n382 avdd.t291 9.54895
R1866 avdd.n380 avdd.t295 9.54895
R1867 avdd.n378 avdd.t299 9.54895
R1868 avdd.n376 avdd.t303 9.54895
R1869 avdd.n374 avdd.t307 9.54895
R1870 avdd.n372 avdd.t311 9.54895
R1871 avdd.n370 avdd.t315 9.54895
R1872 avdd.n368 avdd.t319 9.54895
R1873 avdd.n366 avdd.t335 9.54895
R1874 avdd.n364 avdd.t339 9.54895
R1875 avdd.n362 avdd.t343 9.54895
R1876 avdd.n360 avdd.t351 9.54895
R1877 avdd.n358 avdd.t355 9.54895
R1878 avdd.n356 avdd.t359 9.54895
R1879 avdd.n354 avdd.t363 9.54895
R1880 avdd.n352 avdd.t367 9.54895
R1881 avdd.n350 avdd.t371 9.54895
R1882 avdd.n348 avdd.t375 9.54895
R1883 avdd.n346 avdd.t379 9.54895
R1884 avdd.n344 avdd.t810 11.0472
R1885 avdd.n342 avdd.t814 11.0472
R1886 avdd.n340 avdd.t818 11.0472
R1887 avdd.n338 avdd.t822 11.0472
R1888 avdd.n336 avdd.t826 11.0472
R1889 avdd.n334 avdd.t830 11.0472
R1890 avdd.n332 avdd.t834 11.0472
R1891 avdd.n330 avdd.t838 11.0472
R1892 avdd.n328 avdd.t794 11.0472
R1893 avdd.n326 avdd.t798 11.0472
R1894 avdd.n324 avdd.t754 11.0472
R1895 avdd.n322 avdd.t758 11.0472
R1896 avdd.n320 avdd.t671 11.0472
R1897 avdd.n318 avdd.t675 11.0472
R1898 avdd.n316 avdd.t679 11.0472
R1899 avdd.n314 avdd.t683 11.0472
R1900 avdd.n312 avdd.t687 11.0472
R1901 avdd.n310 avdd.t691 11.0472
R1902 avdd.n308 avdd.t695 11.0472
R1903 avdd.n306 avdd.t699 11.0472
R1904 avdd.n304 avdd.t347 9.54895
R1905 avdd.n302 avdd.t327 9.54895
R1906 avdd.n300 avdd.t331 9.54895
R1907 avdd.n298 avdd.t323 9.54895
R1908 avdd.n296 avdd.t251 9.56733
R1909 avdd.n293 avdd.t239 9.45703
R1910 avdd.n291 avdd.t235 9.45703
R1911 avdd.n289 avdd.t231 9.45703
R1912 avdd.n287 avdd.t227 9.45703
R1913 avdd.n285 avdd.t223 9.45703
R1914 avdd.n283 avdd.t219 9.45703
R1915 avdd.n281 avdd.t215 9.45703
R1916 avdd.n279 avdd.t211 9.45703
R1917 avdd.n277 avdd.t207 9.45703
R1918 avdd.n275 avdd.t203 9.45703
R1919 avdd.n273 avdd.t199 9.45703
R1920 avdd.n270 avdd.t187 9.45703
R1921 avdd.n268 avdd.t183 9.45703
R1922 avdd.n266 avdd.t123 9.45703
R1923 avdd.n264 avdd.t119 9.45703
R1924 avdd.n262 avdd.t115 9.45703
R1925 avdd.n260 avdd.t111 9.45703
R1926 avdd.n258 avdd.t107 9.45703
R1927 avdd.n256 avdd.t103 9.45703
R1928 avdd.n254 avdd.t99 9.45703
R1929 avdd.n252 avdd.t179 9.45703
R1930 avdd.n250 avdd.t95 9.45703
R1931 avdd.n248 avdd.t127 9.45703
R1932 avdd.n246 avdd.t131 9.45703
R1933 avdd.n244 avdd.t135 9.45703
R1934 avdd.n242 avdd.t139 9.45703
R1935 avdd.n240 avdd.t143 9.45703
R1936 avdd.n814 avdd.n802 0.0861055
R1937 avdd.n833 avdd.n773 0.0843923
R1938 avdd.n237 avdd.n236 0.0826923
R1939 avdd.n10 avdd.n773 0.0998572
R1940 avdd.n74 avdd.t526 0.0781017
R1941 avdd.n76 avdd.t522 0.0781017
R1942 avdd.n78 avdd.t518 0.0781017
R1943 avdd.n80 avdd.t514 0.0781017
R1944 avdd.n82 avdd.t510 0.0781017
R1945 avdd.n84 avdd.t506 0.0781017
R1946 avdd.n86 avdd.t502 0.0781017
R1947 avdd.n88 avdd.t498 0.0781017
R1948 avdd.n90 avdd.t494 0.0781017
R1949 avdd.n92 avdd.t490 0.0781017
R1950 avdd.n94 avdd.t486 0.0781017
R1951 avdd.n96 avdd.t482 0.0781017
R1952 avdd.n98 avdd.t478 0.0781017
R1953 avdd.n140 avdd.t662 0.0781017
R1954 avdd.n142 avdd.t666 0.0781017
R1955 avdd.n144 avdd.t670 0.0781017
R1956 avdd.n146 avdd.t753 0.0781017
R1957 avdd.n148 avdd.t749 0.0781017
R1958 avdd.n150 avdd.t745 0.0781017
R1959 avdd.n152 avdd.t741 0.0781017
R1960 avdd.n154 avdd.t737 0.0781017
R1961 avdd.n156 avdd.t733 0.0781017
R1962 avdd.n158 avdd.t729 0.0781017
R1963 avdd.n160 avdd.t725 0.0781017
R1964 avdd.n162 avdd.t721 0.0781017
R1965 avdd.n164 avdd.t717 0.0781017
R1966 avdd.n166 avdd.t713 0.0781017
R1967 avdd.n168 avdd.t709 0.0781017
R1968 avdd.n815 avdd.n814 0.0767
R1969 avdd.n616 avdd.n615 0.0748204
R1970 avdd.n812 avdd.n804 0.0725
R1971 avdd.n813 avdd.n803 0.0725
R1972 avdd.n816 avdd.n794 0.0645
R1973 avdd.n238 avdd.n784 9.31584
R1974 avdd.n235 avdd.t439 16.8096
R1975 avdd.n233 avdd.t435 16.8096
R1976 avdd.n231 avdd.t431 16.8096
R1977 avdd.n229 avdd.t427 16.8096
R1978 avdd.n227 avdd.t411 16.8096
R1979 avdd.n225 avdd.t415 16.8096
R1980 avdd.n223 avdd.t419 16.8096
R1981 avdd.n221 avdd.t407 16.8096
R1982 avdd.n219 avdd.t403 16.8096
R1983 avdd.n217 avdd.t399 16.8096
R1984 avdd.n215 avdd.t395 16.8096
R1985 avdd.n213 avdd.t391 16.8096
R1986 avdd.n211 avdd.t387 16.8096
R1987 avdd.n209 avdd.t383 16.8096
R1988 avdd.n207 avdd.n617 0.125484
R1989 avdd.n206 avdd.t527 16.8096
R1990 avdd.n204 avdd.t551 16.8096
R1991 avdd.n202 avdd.t575 16.8096
R1992 avdd.n200 avdd.t599 16.8096
R1993 avdd.n198 avdd.t603 16.8096
R1994 avdd.n196 avdd.t607 16.8096
R1995 avdd.n194 avdd.t611 16.8096
R1996 avdd.n192 avdd.t615 16.8096
R1997 avdd.n190 avdd.t619 16.8096
R1998 avdd.n188 avdd.t623 16.8096
R1999 avdd.n186 avdd.t587 16.8096
R2000 avdd.n184 avdd.t583 16.8096
R2001 avdd.n182 avdd.t579 16.8096
R2002 avdd.n180 avdd.t563 16.8096
R2003 avdd.n178 avdd.t559 16.8096
R2004 avdd.n176 avdd.t555 16.8096
R2005 avdd.n174 avdd.t539 16.8096
R2006 avdd.n172 avdd.t535 16.8096
R2007 avdd.n170 avdd.t531 16.8096
R2008 avdd.n138 avdd.t842 20.7938
R2009 avdd.n136 avdd.t846 20.7938
R2010 avdd.n134 avdd.t806 20.7938
R2011 avdd.n132 avdd.t778 20.7938
R2012 avdd.n130 avdd.t774 20.7938
R2013 avdd.n128 avdd.t770 20.7938
R2014 avdd.n126 avdd.t766 20.7938
R2015 avdd.n124 avdd.t762 20.7938
R2016 avdd.n122 avdd.t782 20.7938
R2017 avdd.n120 avdd.t786 20.7938
R2018 avdd.n118 avdd.t790 20.7938
R2019 avdd.n116 avdd.t802 20.7938
R2020 avdd.n114 avdd.t850 20.7938
R2021 avdd.n112 avdd.t854 20.7938
R2022 avdd.n110 avdd.t858 20.7938
R2023 avdd.n108 avdd.t862 20.7938
R2024 avdd.n106 avdd.t866 20.7938
R2025 avdd.n104 avdd.t870 20.7938
R2026 avdd.n102 avdd.t874 20.7938
R2027 avdd.n100 avdd.t878 20.7938
R2028 avdd.n72 avdd.t471 34.1741
R2029 avdd.n70 avdd.t443 34.1741
R2030 avdd.n68 avdd.t543 34.1741
R2031 avdd.n66 avdd.t547 34.1741
R2032 avdd.n64 avdd.t571 34.1741
R2033 avdd.n62 avdd.t567 34.1741
R2034 avdd.n60 avdd.t595 34.1741
R2035 avdd.n58 avdd.t591 34.1741
R2036 avdd.n56 avdd.t627 34.1741
R2037 avdd.n54 avdd.t631 34.1741
R2038 avdd.n52 avdd.t635 34.1741
R2039 avdd.n50 avdd.t639 34.1741
R2040 avdd.n48 avdd.t643 34.1741
R2041 avdd.n46 avdd.t647 34.1741
R2042 avdd.n44 avdd.t651 34.1741
R2043 avdd.n42 avdd.t655 34.1741
R2044 avdd.n40 avdd.t447 34.1741
R2045 avdd.n38 avdd.t451 34.1741
R2046 avdd.n36 avdd.t455 34.1741
R2047 avdd.n34 avdd.t459 34.1741
R2048 avdd.n32 avdd.t463 34.1741
R2049 avdd.n30 avdd.t467 34.1741
R2050 avdd.n9 avdd.n28 1.01368
R2051 avdd.n887 avdd.n27 0.193025
R2052 avdd.n168 avdd.t708 0.0807146
R2053 avdd.n166 avdd.t712 0.0807146
R2054 avdd.n164 avdd.t716 0.0807146
R2055 avdd.n162 avdd.t720 0.0807146
R2056 avdd.n160 avdd.t724 0.0807146
R2057 avdd.n158 avdd.t728 0.0807146
R2058 avdd.n156 avdd.t732 0.0807146
R2059 avdd.n154 avdd.t736 0.0807146
R2060 avdd.n152 avdd.t740 0.0807146
R2061 avdd.n150 avdd.t744 0.0807146
R2062 avdd.n148 avdd.t748 0.0807146
R2063 avdd.n146 avdd.t752 0.0807146
R2064 avdd.n144 avdd.t669 0.0807146
R2065 avdd.n142 avdd.t665 0.0807146
R2066 avdd.n140 avdd.t661 0.0807146
R2067 avdd.n98 avdd.t477 0.0807146
R2068 avdd.n96 avdd.t481 0.0807146
R2069 avdd.n94 avdd.t485 0.0807146
R2070 avdd.n92 avdd.t489 0.0807146
R2071 avdd.n90 avdd.t493 0.0807146
R2072 avdd.n88 avdd.t497 0.0807146
R2073 avdd.n86 avdd.t501 0.0807146
R2074 avdd.n84 avdd.t505 0.0807146
R2075 avdd.n82 avdd.t509 0.0807146
R2076 avdd.n80 avdd.t513 0.0807146
R2077 avdd.n78 avdd.t517 0.0807146
R2078 avdd.n76 avdd.t521 0.0807146
R2079 avdd.n74 avdd.t525 0.0807146
R2080 avdd.n807 avdd 0.0520066
R2081 avdd.n813 avdd.n812 0.0485
R2082 avdd.n789 avdd.n2 0.0191987
R2083 avdd.n788 avdd.n787 0.0443571
R2084 avdd.n804 avdd.n803 0.0441364
R2085 avdd avdd.n3 4.62755
R2086 avdd.n21 avdd.n730 2.6105
R2087 avdd.n19 avdd.n856 2.6105
R2088 avdd.n18 avdd.n784 2.6105
R2089 avdd.n772 avdd.n20 2.603
R2090 avdd.n16 avdd.n772 1.99344
R2091 avdd.n612 avdd.n26 1.7105
R2092 avdd.n8 avdd.n475 1.7105
R2093 avdd.n14 avdd.n15 1.23732
R2094 avdd.n13 avdd.n14 1.23732
R2095 avdd.n12 avdd.n13 1.23732
R2096 avdd.n12 avdd.n626 1.23732
R2097 avdd.n28 avdd.n23 1.02867
R2098 avdd.n9 avdd.n451 1.02493
R2099 avdd.n11 avdd.n681 0.437375
R2100 avdd.n4 avdd.n7 2.69452
R2101 avdd.n787 avdd.n2 0.206082
R2102 avdd.n10 avdd 0.100992
R2103 dvdd.n11 dvdd.t26 109.692
R2104 dvdd.n32 dvdd.t28 109.445
R2105 dvdd.n25 dvdd.t8 109.422
R2106 dvdd.n7 dvdd.t10 109.272
R2107 dvdd.n29 dvdd.t6 109.264
R2108 dvdd.n13 dvdd.t0 104.746
R2109 dvdd.n10 dvdd.t24 100.174
R2110 dvdd.n8 dvdd.t17 82.4916
R2111 dvdd.n3 dvdd.t5 60.7437
R2112 dvdd.n24 dvdd.t4 45.3749
R2113 dvdd.n37 dvdd.t20 39.4649
R2114 dvdd.n38 dvdd.t23 39.4347
R2115 dvdd.n12 dvdd.t2 33.4172
R2116 dvdd.n18 dvdd.t14 31.6601
R2117 dvdd.n15 dvdd.t19 31.4969
R2118 dvdd.n20 dvdd.t21 30.6194
R2119 dvdd.n18 dvdd.t13 30.6149
R2120 dvdd.n17 dvdd.t18 30.6059
R2121 dvdd.n21 dvdd.t15 30.578
R2122 dvdd.n19 dvdd.t12 30.5714
R2123 dvdd.n16 dvdd.t3 30.5689
R2124 dvdd.n15 dvdd.t22 30.5667
R2125 dvdd.n5 dvdd.t16 30.4271
R2126 dvdd.n9 dvdd.n8 24.3348
R2127 dvdd.n2 dvdd.n11 18.9905
R2128 dvdd.n6 dvdd.n5 15.8855
R2129 dvdd.n14 dvdd.t1 15.5386
R2130 dvdd.n33 dvdd.t29 15.1483
R2131 dvdd.n2 dvdd.t27 15.0931
R2132 dvdd.n26 dvdd.t9 15.0481
R2133 dvdd.n39 dvdd.n0 14.8505
R2134 dvdd.n10 dvdd.n9 14.186
R2135 dvdd dvdd.n3 12.4205
R2136 dvdd.n8 dvdd.n7 11.5239
R2137 dvdd.n6 dvdd.t11 10.5249
R2138 dvdd.n9 dvdd.t25 10.5033
R2139 dvdd.n28 dvdd.t7 10.4782
R2140 dvdd.n2 dvdd.n33 10.4405
R2141 dvdd.n0 dvdd.n5 9.37175
R2142 dvdd.n34 dvdd.n10 9.288
R2143 dvdd.n13 dvdd.n12 6.5255
R2144 dvdd.n28 dvdd.n27 6.0305
R2145 dvdd.n7 dvdd.n6 5.3555
R2146 dvdd.n29 dvdd.n28 5.0405
R2147 dvdd.n14 dvdd.n13 4.5005
R2148 dvdd.n39 dvdd.n3 4.5005
R2149 dvdd.n34 dvdd.n2 2.4305
R2150 dvdd.n23 dvdd.n22 1.80783
R2151 dvdd.n30 dvdd.n12 1.40779
R2152 dvdd.n20 dvdd.n19 1.2605
R2153 dvdd.n40 dvdd.n39 1.2375
R2154 dvdd.n29 dvdd.n14 1.1705
R2155 dvdd.n2 dvdd.n1 1.1705
R2156 dvdd.n32 dvdd.n31 1.12958
R2157 dvdd.n37 dvdd.n4 1.1255
R2158 dvdd.n0 dvdd.n36 1.1255
R2159 dvdd.n35 dvdd.n34 1.1255
R2160 dvdd.n30 dvdd.n29 1.1255
R2161 dvdd.n26 dvdd.n11 1.0805
R2162 dvdd.n21 dvdd.n20 1.0805
R2163 dvdd.n16 dvdd.n15 1.0805
R2164 dvdd.n25 dvdd.n24 0.9905
R2165 dvdd.n24 dvdd.n23 0.965742
R2166 dvdd.n19 dvdd.n18 0.9005
R2167 dvdd.n17 dvdd.n16 0.9005
R2168 dvdd.n38 dvdd.n37 0.8105
R2169 dvdd.n36 dvdd.n35 0.6965
R2170 dvdd.n22 dvdd.n17 0.5855
R2171 dvdd dvdd.n40 0.4925
R2172 dvdd.n40 dvdd.n4 0.4885
R2173 dvdd.n0 dvdd.n38 0.4505
R2174 dvdd.n23 dvdd.n1 0.30824
R2175 dvdd.n27 dvdd.n25 0.2705
R2176 dvdd.n33 dvdd.n32 0.2255
R2177 dvdd.n22 dvdd.n21 0.2255
R2178 dvdd.n31 dvdd.n1 0.199468
R2179 dvdd.n31 dvdd.n30 0.175539
R2180 dvdd.n27 dvdd.n26 0.1355
R2181 dvdd.n36 dvdd.n4 0.1285
R2182 dvdd.n35 dvdd.n1 0.1205
R2183 psrg_mf1_protected psrg_mf1_protected.t1 34.4979
R2184 psrg_mf1_protected psrg_mf1_protected.t0 4.75063
R2185 y1.n0 y1.t7 36.1922
R2186 y1.n6 y1.t13 36.1574
R2187 y1.n1 y1.t9 34.3923
R2188 y1.n3 y1.t11 34.3923
R2189 y1.n7 y1.t15 34.3574
R2190 y1.n9 y1.t17 34.3574
R2191 y1.n0 y1.t8 34.3472
R2192 y1.n2 y1.t10 34.3472
R2193 y1.n6 y1.t14 34.2865
R2194 y1.n8 y1.t16 34.2865
R2195 y1.n10 y1.t18 34.2865
R2196 y1.n4 y1.t4 31.8593
R2197 y1.n4 y1.t12 29.8473
R2198 y1.n12 y1.n11 25.6505
R2199 y1.n15 y1.t5 21.1316
R2200 y1.n14 y1.t3 13.894
R2201 y1.n13 y1.t2 13.7842
R2202 y1.n12 y1.t1 13.759
R2203 y1.n16 y1.n14 10.6205
R2204 y1.n15 y1.t6 9.21558
R2205 y1.n13 y1.n12 8.6405
R2206 y1 y1.n16 7.394
R2207 y1.n11 y1.n5 5.9405
R2208 y1.n16 y1.n15 5.8505
R2209 y1 y1.t0 4.69308
R2210 y1.n5 y1.n4 4.5005
R2211 y1.n14 y1.n13 2.7905
R2212 y1.n9 y1.n8 1.9805
R2213 y1.n7 y1.n6 1.9805
R2214 y1.n3 y1.n2 1.9805
R2215 y1.n1 y1.n0 1.9805
R2216 y1.n10 y1.n9 1.8005
R2217 y1.n8 y1.n7 1.8005
R2218 y1.n5 y1.n3 1.8005
R2219 y1.n2 y1.n1 1.8005
R2220 y1.n11 y1.n10 0.1805
R2221 pm1.n5 pm1.n4 41.324
R2222 pm1.n6 pm1.n5 22.0055
R2223 pm1 pm1.n8 20.849
R2224 pm1.n1 pm1.t7 19.4457
R2225 pm1.n2 pm1.t6 17.6349
R2226 pm1.n1 pm1.t9 15.8457
R2227 pm1.n8 pm1.n7 14.8955
R2228 pm1.n2 pm1.n1 14.5355
R2229 pm1.n1 pm1.t8 13.9359
R2230 pm1.n4 pm1.t4 13.7649
R2231 pm1.n7 pm1.t3 13.759
R2232 pm1.n3 pm1.t5 13.7197
R2233 pm1.n0 pm1.t10 12.3566
R2234 pm1.n8 pm1.n0 10.1705
R2235 pm1.n6 pm1.t2 9.28421
R2236 pm1.n0 pm1.t11 9.21558
R2237 pm1.n7 pm1.n6 7.5605
R2238 pm1.n5 pm1.t1 4.75058
R2239 pm1 pm1.t0 4.69308
R2240 pm1.n4 pm1.n3 2.1605
R2241 pm1.n3 pm1.n2 1.8905
R2242 pm2.n7 pm2.n6 33.5705
R2243 pm2.n0 pm2.t2 26.7442
R2244 pm2.n4 pm2.t8 19.5609
R2245 pm2 pm2.n9 16.6692
R2246 pm2.n2 pm2.t5 15.8797
R2247 pm2.n3 pm2.n2 14.7155
R2248 pm2.n3 pm2.t3 13.8997
R2249 pm2.n6 pm2.n3 13.8155
R2250 pm2.n5 pm2.t6 13.8009
R2251 pm2.n4 pm2.t7 13.7757
R2252 pm2.n2 pm2.t4 13.7649
R2253 pm2.n7 pm2.t9 13.7156
R2254 pm2.n1 pm2.n0 12.1055
R2255 pm2.n8 pm2.n1 10.8905
R2256 pm2.n9 pm2.n8 10.6205
R2257 pm2.n1 pm2.t0 9.28421
R2258 pm2.n0 pm2.t1 9.25904
R2259 pm2.n9 pm2.t10 9.25158
R2260 pm2.n6 pm2.n5 6.4805
R2261 pm2 pm2.t11 4.69308
R2262 pm2.n8 pm2.n7 2.5205
R2263 pm2.n5 pm2.n4 2.1605
R2264 iref_gate.n0 iref_gate.t3 155.671
R2265 iref_gate.n1 iref_gate.t1 38.5561
R2266 iref_gate.n0 iref_gate.t2 13.6303
R2267 iref_gate.n1 iref_gate.n0 5.9855
R2268 iref_gate iref_gate.t0 4.55384
R2269 iref_gate iref_gate.n1 4.50383
R2270 vbn.n0 vbn.t3 130.732
R2271 vbn.n1 vbn.t2 26.3118
R2272 vbn.n1 vbn.t0 17.7886
R2273 vbn.n0 vbn.t4 17.7886
R2274 vbn vbn.n2 10.4394
R2275 vbn.n2 vbn.n0 6.3005
R2276 vbn vbn.t1 5.1112
R2277 vbn.n2 vbn.n1 4.5005
R2278 psrg_m3_protected.n1 psrg_m3_protected.t0 33.6292
R2279 psrg_m3_protected.n0 psrg_m3_protected.t3 20.4823
R2280 psrg_m3_protected.n1 psrg_m3_protected.n0 20.2505
R2281 psrg_m3_protected.n0 psrg_m3_protected.t2 9.52742
R2282 psrg_m3_protected psrg_m3_protected.t1 4.81592
R2283 psrg_m3_protected psrg_m3_protected.n1 4.559
R2284 psrg_vnc.n4 psrg_vnc.t9 122.335
R2285 psrg_vnc.n9 psrg_vnc.n8 27.3155
R2286 psrg_vnc.n9 psrg_vnc.t10 24.2364
R2287 psrg_vnc psrg_vnc.t11 19.6464
R2288 psrg_vnc.n7 psrg_vnc.t8 17.666
R2289 psrg_vnc.n0 psrg_vnc.t2 15.9186
R2290 psrg_vnc psrg_vnc.n9 15.3376
R2291 psrg_vnc.n8 psrg_vnc.t7 14.1938
R2292 psrg_vnc.n0 psrg_vnc.t3 13.8021
R2293 psrg_vnc.n2 psrg_vnc.t5 13.8021
R2294 psrg_vnc.n1 psrg_vnc.t4 13.7586
R2295 psrg_vnc.n3 psrg_vnc.t6 13.7586
R2296 psrg_vnc.n7 psrg_vnc.n6 13.0955
R2297 psrg_vnc.n6 psrg_vnc.n5 9.4955
R2298 psrg_vnc.n4 psrg_vnc.t0 9.30213
R2299 psrg_vnc.n6 psrg_vnc.t1 9.30213
R2300 psrg_vnc.n8 psrg_vnc.n7 6.9305
R2301 psrg_vnc.n5 psrg_vnc.n4 4.6355
R2302 psrg_vnc.n2 psrg_vnc.n1 2.1605
R2303 psrg_vnc.n5 psrg_vnc.n3 2.0705
R2304 psrg_vnc.n3 psrg_vnc.n2 1.9805
R2305 psrg_vnc.n1 psrg_vnc.n0 1.9805
R2306 vbp_cas.n29 vbp_cas.n28 68.5805
R2307 vbp_cas.n13 vbp_cas.t20 31.3027
R2308 vbp_cas.n4 vbp_cas.t27 27.3674
R2309 vbp_cas.n0 vbp_cas.t21 27.3528
R2310 vbp_cas.n10 vbp_cas.t2 25.8124
R2311 vbp_cas.n23 vbp_cas.t14 25.5874
R2312 vbp_cas.n25 vbp_cas.t10 25.5874
R2313 vbp_cas.n27 vbp_cas.t12 25.5874
R2314 vbp_cas.n21 vbp_cas.t0 25.5874
R2315 vbp_cas.n5 vbp_cas.t29 24.6674
R2316 vbp_cas.n7 vbp_cas.t31 24.6674
R2317 vbp_cas.n3 vbp_cas.t25 24.6528
R2318 vbp_cas.n4 vbp_cas.t28 24.6224
R2319 vbp_cas.n6 vbp_cas.t30 24.6224
R2320 vbp_cas.n8 vbp_cas.t32 24.6224
R2321 vbp_cas.n0 vbp_cas.t22 24.5751
R2322 vbp_cas.n2 vbp_cas.t24 24.5751
R2323 vbp_cas.n17 vbp_cas.t16 24.0124
R2324 vbp_cas.n13 vbp_cas.t4 23.1124
R2325 vbp_cas.n14 vbp_cas.t8 23.1124
R2326 vbp_cas.n10 vbp_cas.t6 23.1124
R2327 vbp_cas.n18 vbp_cas.t18 23.1124
R2328 vbp_cas.n1 vbp_cas.t23 20.1528
R2329 vbp_cas.n9 vbp_cas.t3 16.8665
R2330 vbp_cas.n19 vbp_cas.t17 15.6333
R2331 vbp_cas vbp_cas.t26 15.5628
R2332 vbp_cas.n16 vbp_cas.t5 13.9041
R2333 vbp_cas.n12 vbp_cas.t9 13.8065
R2334 vbp_cas.n28 vbp_cas.t13 13.8031
R2335 vbp_cas.n24 vbp_cas.t15 13.8031
R2336 vbp_cas.n20 vbp_cas.t19 13.8031
R2337 vbp_cas.n9 vbp_cas.t7 13.7691
R2338 vbp_cas.n22 vbp_cas.t1 13.7433
R2339 vbp_cas.n26 vbp_cas.t11 13.7433
R2340 vbp_cas.n15 vbp_cas.n14 11.2955
R2341 vbp_cas.n11 vbp_cas.n10 11.2955
R2342 vbp_cas.n29 vbp_cas.n8 10.8005
R2343 vbp_cas.n1 vbp_cas.n0 7.3805
R2344 vbp_cas.n29 vbp_cas.n3 7.2005
R2345 vbp_cas.n2 vbp_cas.n1 7.2005
R2346 vbp_cas vbp_cas.n29 4.51287
R2347 vbp_cas.n3 vbp_cas.n2 2.8805
R2348 vbp_cas.n7 vbp_cas.n6 2.8805
R2349 vbp_cas.n5 vbp_cas.n4 2.8805
R2350 vbp_cas.n17 vbp_cas.n16 2.7905
R2351 vbp_cas.n8 vbp_cas.n7 2.7005
R2352 vbp_cas.n6 vbp_cas.n5 2.7005
R2353 vbp_cas.n14 vbp_cas.n13 2.7005
R2354 vbp_cas.n19 vbp_cas.n18 2.4305
R2355 vbp_cas.n12 vbp_cas.n11 1.9805
R2356 vbp_cas.n23 vbp_cas.n22 1.8905
R2357 vbp_cas.n25 vbp_cas.n24 1.8905
R2358 vbp_cas.n27 vbp_cas.n26 1.8905
R2359 vbp_cas.n21 vbp_cas.n20 1.8905
R2360 vbp_cas.n16 vbp_cas.n15 1.8905
R2361 vbp_cas.n18 vbp_cas.n17 1.8005
R2362 vbp_cas.n24 vbp_cas.n23 1.1705
R2363 vbp_cas.n28 vbp_cas.n27 1.1705
R2364 vbp_cas.n20 vbp_cas.n19 1.1705
R2365 vbp_cas.n15 vbp_cas.n12 1.0805
R2366 vbp_cas.n26 vbp_cas.n25 0.9905
R2367 vbp_cas.n22 vbp_cas.n21 0.9905
R2368 vbp_cas.n11 vbp_cas.n9 0.9005
R2369 xf1.n5 xf1.t0 42.9365
R2370 xf1.n5 xf1.n4 41.1755
R2371 xf1.n6 xf1.n5 36.0108
R2372 xf1.n8 xf1.n7 25.1105
R2373 xf1.n1 xf1.t3 21.2642
R2374 xf1.n0 xf1.t1 16.7624
R2375 xf1.n0 xf1.t2 13.9742
R2376 xf1.n2 xf1.t5 13.8392
R2377 xf1.n1 xf1.t4 13.8024
R2378 xf1.n9 xf1.t7 13.6715
R2379 xf1.n7 xf1.t8 13.6463
R2380 xf1 xf1.n9 13.0989
R2381 xf1.n7 xf1.n6 11.0115
R2382 xf1.n3 xf1.n2 10.1705
R2383 xf1.n4 xf1.t11 9.30241
R2384 xf1.n8 xf1.t10 9.14631
R2385 xf1.n3 xf1.n0 8.9105
R2386 xf1.n9 xf1.n8 6.6605
R2387 xf1 xf1.t6 4.5781
R2388 xf1.n6 xf1.t9 4.5781
R2389 xf1.n2 xf1.n1 3.0605
R2390 xf1.n4 xf1.n3 2.7905
R2391 xf2.n5 xf2.t0 44.9165
R2392 xf2.n6 xf2.n5 38.8805
R2393 xf2.n5 xf2.n4 33.8405
R2394 xf2.n4 xf2.t3 30.2624
R2395 xf2.n9 xf2.n8 29.6105
R2396 xf2.n1 xf2.t7 24.0542
R2397 xf2 xf2.n9 22.1187
R2398 xf2.n0 xf2.t4 16.7624
R2399 xf2.n0 xf2.t5 13.9742
R2400 xf2.n3 xf2.t11 13.9742
R2401 xf2.n8 xf2.t2 13.6463
R2402 xf2.n2 xf2.t10 9.30241
R2403 xf2.n7 xf2.t6 9.17148
R2404 xf2.n6 xf2.t1 9.14631
R2405 xf2.n1 xf2.n0 8.9105
R2406 xf2.n3 xf2.n2 7.4705
R2407 xf2.n8 xf2.n7 6.4805
R2408 xf2.n7 xf2.n6 5.9405
R2409 xf2.n4 xf2.n3 4.7705
R2410 xf2.n9 xf2.t9 4.64631
R2411 xf2 xf2.t8 4.5781
R2412 xf2.n2 xf2.n1 2.7905
R2413 vgn2.n1 vgn2.t10 49.7719
R2414 vgn2.n2 vgn2.n1 46.3055
R2415 vgn2.n8 vgn2.t8 33.1543
R2416 vgn2.n8 vgn2.n7 22.1072
R2417 vgn2.n7 vgn2.t1 20.3042
R2418 vgn2 vgn2.t9 19.6464
R2419 vgn2.n0 vgn2.t3 19.0975
R2420 vgn2.n2 vgn2.t0 18.6825
R2421 vgn2.n0 vgn2.t2 18.2924
R2422 vgn2.n5 vgn2.t5 18.2516
R2423 vgn2.n6 vgn2.t4 18.2489
R2424 vgn2.n3 vgn2.t6 18.2156
R2425 vgn2.n1 vgn2.t7 16.4921
R2426 vgn2 vgn2.n8 15.3438
R2427 vgn2.n3 vgn2.n2 4.5605
R2428 vgn2.n4 vgn2.n0 1.78717
R2429 vgn2.n4 vgn2.n3 1.7205
R2430 vgn2.n7 vgn2.n6 1.02717
R2431 vgn2.n6 vgn2.n5 0.813833
R2432 vgn2.n5 vgn2.n4 0.813833
R2433 vsp.n5 vsp.n4 37.1705
R2434 vsp.n10 vsp.n9 16.8305
R2435 vsp.n0 vsp.t13 16.2006
R2436 vsp.n4 vsp.t4 13.8156
R2437 vsp.n1 vsp.t6 13.7139
R2438 vsp.n2 vsp.t15 13.7139
R2439 vsp.n0 vsp.t5 13.686
R2440 vsp.n3 vsp.t3 13.686
R2441 vsp.n6 vsp.t12 13.6715
R2442 vsp.n13 vsp.t8 13.6715
R2443 vsp.n11 vsp.t9 13.6715
R2444 vsp.n8 vsp.t2 13.6715
R2445 vsp.n12 vsp.t14 13.6463
R2446 vsp.n10 vsp.t10 13.6463
R2447 vsp.n9 vsp.t1 13.6463
R2448 vsp.n7 vsp.t11 13.6463
R2449 vsp.n5 vsp.t0 13.6463
R2450 vsp vsp.n13 11.2737
R2451 vsp vsp.t7 4.5781
R2452 vsp.n3 vsp.n2 2.5205
R2453 vsp.n1 vsp.n0 2.5205
R2454 vsp.n4 vsp.n3 2.4305
R2455 vsp.n2 vsp.n1 2.3405
R2456 vsp.n7 vsp.n6 2.1605
R2457 vsp.n9 vsp.n8 2.1605
R2458 vsp.n12 vsp.n11 2.1605
R2459 vsp.n8 vsp.n7 1.9805
R2460 vsp.n11 vsp.n10 1.9805
R2461 vsp.n13 vsp.n12 1.9805
R2462 vsp.n6 vsp.n5 1.9805
R2463 v2.n2 v2.t4 65.501
R2464 v2.n1 v2.t3 65.4526
R2465 v2.n3 v2.t5 65.4526
R2466 v2.n4 v2.t6 60.9526
R2467 v2.n5 v2.t7 60.9526
R2468 v2.n6 v2.n5 54.8555
R2469 v2.n6 v2.t0 15.4715
R2470 v2.n10 v2.t2 13.8293
R2471 v2.n5 v2.n4 13.0505
R2472 v2.n4 v2.n3 12.2855
R2473 v2.n7 v2.n0 10.5305
R2474 v2.n11 v2.n10 9.0455
R2475 v2.n11 v2.n0 6.7055
R2476 v2.n8 v2.n1 6.5855
R2477 v2.n2 v2.n1 5.8505
R2478 v2 v2.n11 5.774
R2479 v2 v2.t1 4.81592
R2480 v2.n7 v2.n6 1.8455
R2481 v2.n3 v2.n2 1.8005
R2482 v2.n10 v2.n9 1.76429
R2483 v2.n9 v2.n0 1.1415
R2484 v2.n8 v2.n7 1.1255
R2485 v2.n9 v2.n8 0.9285
R2486 vaux.n0 vaux.t2 55.5092
R2487 vaux vaux.n0 15.2091
R2488 vaux.n0 vaux.t0 9.47375
R2489 vaux vaux.t1 4.93012
R2490 vx3 vx3.n4 34.3187
R2491 vx3.n5 vx3.t4 31.1652
R2492 vx3 vx3.n7 19.6205
R2493 vx3.n6 vx3.n5 18.4205
R2494 vx3.n7 vx3.t7 13.8364
R2495 vx3.n0 vx3.t2 13.3392
R2496 vx3.n0 vx3.t3 13.0962
R2497 vx3.n1 vx3.t0 11.7192
R2498 vx3.n1 vx3.t9 11.4762
R2499 vx3.n3 vx3.t10 10.6392
R2500 vx3.n3 vx3.t1 10.3962
R2501 vx3.n2 vx3.n0 9.61925
R2502 vx3.n6 vx3.t6 9.33641
R2503 vx3.n7 vx3.n6 9.3155
R2504 vx3 vx3.t8 4.76969
R2505 vx3.n5 vx3.t5 4.75991
R2506 vx3.n4 vx3.n2 4.57925
R2507 vx3.n2 vx3.n1 4.5005
R2508 vx3.n4 vx3.n3 4.5005
R2509 psrg_m3_feed.n1 psrg_m3_feed.n0 129.106
R2510 psrg_m3_feed.n7 psrg_m3_feed.t15 49.1087
R2511 psrg_m3_feed.n1 psrg_m3_feed.t9 47.7002
R2512 psrg_m3_feed.n2 psrg_m3_feed.t10 47.7002
R2513 psrg_m3_feed.n3 psrg_m3_feed.t11 47.7002
R2514 psrg_m3_feed.n5 psrg_m3_feed.t13 47.7002
R2515 psrg_m3_feed.n6 psrg_m3_feed.t14 47.7002
R2516 psrg_m3_feed.n13 psrg_m3_feed.t21 47.6777
R2517 psrg_m3_feed.n14 psrg_m3_feed.t22 47.6777
R2518 psrg_m3_feed.n15 psrg_m3_feed.t23 47.6777
R2519 psrg_m3_feed.n16 psrg_m3_feed.t24 47.6777
R2520 psrg_m3_feed.n17 psrg_m3_feed.t25 47.6777
R2521 psrg_m3_feed.n21 psrg_m3_feed.t26 47.6777
R2522 psrg_m3_feed.n7 psrg_m3_feed.t16 47.6688
R2523 psrg_m3_feed.n8 psrg_m3_feed.t17 47.6688
R2524 psrg_m3_feed.n10 psrg_m3_feed.t19 47.6688
R2525 psrg_m3_feed.n11 psrg_m3_feed.t20 47.6688
R2526 psrg_m3_feed.n4 psrg_m3_feed.t12 43.2002
R2527 psrg_m3_feed.n9 psrg_m3_feed.t18 43.1688
R2528 psrg_m3_feed.n18 psrg_m3_feed.t28 36.691
R2529 psrg_m3_feed.n18 psrg_m3_feed.t27 35.431
R2530 psrg_m3_feed.n0 psrg_m3_feed.t8 29.1043
R2531 psrg_m3_feed.n19 psrg_m3_feed.t4 26.7064
R2532 psrg_m3_feed psrg_m3_feed.n24 18.437
R2533 psrg_m3_feed.n23 psrg_m3_feed.t5 16.3114
R2534 psrg_m3_feed.n12 psrg_m3_feed.t1 15.8724
R2535 psrg_m3_feed.n20 psrg_m3_feed.n19 15.3905
R2536 psrg_m3_feed.n23 psrg_m3_feed.n22 15.3005
R2537 psrg_m3_feed.n13 psrg_m3_feed.n12 14.7605
R2538 psrg_m3_feed.n12 psrg_m3_feed.t0 13.8673
R2539 psrg_m3_feed.n0 psrg_m3_feed.t7 11.305
R2540 psrg_m3_feed.n24 psrg_m3_feed.n23 10.3505
R2541 psrg_m3_feed.n19 psrg_m3_feed.t3 9.33641
R2542 psrg_m3_feed.n24 psrg_m3_feed.t6 9.33641
R2543 psrg_m3_feed.n21 psrg_m3_feed.n20 8.8205
R2544 psrg_m3_feed.n10 psrg_m3_feed.n9 5.9405
R2545 psrg_m3_feed.n9 psrg_m3_feed.n8 5.9405
R2546 psrg_m3_feed.n5 psrg_m3_feed.n4 5.9405
R2547 psrg_m3_feed.n4 psrg_m3_feed.n3 5.9405
R2548 psrg_m3_feed.n22 psrg_m3_feed.n6 5.0405
R2549 psrg_m3_feed.n22 psrg_m3_feed.n21 4.8605
R2550 psrg_m3_feed psrg_m3_feed.t2 4.75991
R2551 psrg_m3_feed.n21 psrg_m3_feed.n17 1.4405
R2552 psrg_m3_feed.n17 psrg_m3_feed.n16 1.4405
R2553 psrg_m3_feed.n16 psrg_m3_feed.n15 1.4405
R2554 psrg_m3_feed.n15 psrg_m3_feed.n14 1.4405
R2555 psrg_m3_feed.n14 psrg_m3_feed.n13 1.4405
R2556 psrg_m3_feed.n11 psrg_m3_feed.n10 1.4405
R2557 psrg_m3_feed.n8 psrg_m3_feed.n7 1.4405
R2558 psrg_m3_feed.n6 psrg_m3_feed.n5 1.4405
R2559 psrg_m3_feed.n3 psrg_m3_feed.n2 1.4405
R2560 psrg_m3_feed.n2 psrg_m3_feed.n1 1.4405
R2561 psrg_m3_feed.n20 psrg_m3_feed.n18 1.1705
R2562 psrg_m3_feed.n22 psrg_m3_feed.n11 0.1805
R2563 vx2.n0 vx2.t6 39.3003
R2564 vx2.n8 vx2.n7 34.1431
R2565 vx2.n0 vx2.t7 19.4964
R2566 vx2.n2 vx2.n1 17.3255
R2567 vx2.n8 vx2.n2 13.8605
R2568 vx2.n6 vx2.t5 13.2762
R2569 vx2.n6 vx2.t4 12.7992
R2570 vx2.n3 vx2.t1 12.1962
R2571 vx2.n3 vx2.t0 11.7192
R2572 vx2.n1 vx2.n0 10.8905
R2573 vx2.n4 vx2.t3 10.5762
R2574 vx2.n4 vx2.t2 10.0992
R2575 vx2.n5 vx2.n3 9.61925
R2576 vx2.n1 vx2.t8 9.27752
R2577 vx2.n2 vx2.t9 9.27361
R2578 vx2.n7 vx2.n5 5.11925
R2579 vx2 vx2.t10 4.75991
R2580 vx2 vx2.n8 4.51028
R2581 vx2.n7 vx2.n6 4.5005
R2582 vx2.n5 vx2.n4 4.5005
R2583 vgn1.n3 vgn1.t9 119.844
R2584 vgn1.n7 vgn1.n6 46.8905
R2585 vgn1.n5 vgn1.t2 29.9964
R2586 vgn1.n6 vgn1.t0 28.6542
R2587 vgn1.n0 vgn1.t6 23.9614
R2588 vgn1 vgn1.n7 14.8603
R2589 vgn1.n4 vgn1.t1 13.9643
R2590 vgn1.n3 vgn1.t3 13.8744
R2591 vgn1.n0 vgn1.t4 13.7814
R2592 vgn1.n1 vgn1.t7 13.7775
R2593 vgn1.n2 vgn1.t8 13.7736
R2594 vgn1.n5 vgn1.n4 10.5755
R2595 vgn1.n2 vgn1.n1 4.8605
R2596 vgn1.n1 vgn1.n0 4.8155
R2597 vgn1 vgn1.t5 4.75991
R2598 vgn1.n7 vgn1.n2 2.4755
R2599 vgn1.n4 vgn1.n3 1.8905
R2600 vgn1.n6 vgn1.n5 0.5405
R2601 vx1.n8 vx1.n7 46.0231
R2602 vx1.n0 vx1.t6 37.6353
R2603 vx1.n1 vx1.n0 13.8605
R2604 vx1.n2 vx1.t9 13.8364
R2605 vx1.n4 vx1.t3 13.4562
R2606 vx1.n4 vx1.t2 13.3392
R2607 vx1 vx1.n8 12.137
R2608 vx1.n6 vx1.t5 11.8362
R2609 vx1.n6 vx1.t4 11.7192
R2610 vx1.n2 vx1.n1 10.6655
R2611 vx1.n3 vx1.t1 10.2162
R2612 vx1.n3 vx1.t0 10.0992
R2613 vx1.n0 vx1.t7 9.33641
R2614 vx1.n1 vx1.t8 9.33641
R2615 vx1.n5 vx1.n3 9.07925
R2616 vx1.n8 vx1.n2 5.5805
R2617 vx1.n7 vx1.n5 5.11925
R2618 vx1 vx1.t10 4.75991
R2619 vx1.n7 vx1.n6 4.5005
R2620 vx1.n5 vx1.n4 4.5005
R2621 su_state.n0 su_state.t1 133.207
R2622 su_state.n0 su_state.t0 72.447
R2623 su_state su_state.t2 5.6975
R2624 su_state su_state.n0 2.69913
R2625 vbp_tail.n11 vbp_tail.n10 76.0955
R2626 vbp_tail.n0 vbp_tail.t7 34.687
R2627 vbp_tail.n6 vbp_tail.t6 34.6554
R2628 vbp_tail.n2 vbp_tail.t10 32.3785
R2629 vbp_tail.n1 vbp_tail.t9 32.3515
R2630 vbp_tail.n0 vbp_tail.t8 32.3436
R2631 vbp_tail.n3 vbp_tail.t11 32.3337
R2632 vbp_tail.n4 vbp_tail.t13 31.2736
R2633 vbp_tail.n10 vbp_tail.t4 23.8189
R2634 vbp_tail vbp_tail.t12 23.284
R2635 vbp_tail.n4 vbp_tail.t0 23.1246
R2636 vbp_tail.n5 vbp_tail.t2 23.1102
R2637 vbp_tail.n6 vbp_tail.t1 15.0643
R2638 vbp_tail.n9 vbp_tail.t5 13.9935
R2639 vbp_tail.n8 vbp_tail.t3 13.8613
R2640 vbp_tail vbp_tail.n11 9.05298
R2641 vbp_tail.n9 vbp_tail.n8 2.4305
R2642 vbp_tail.n5 vbp_tail.n4 2.3405
R2643 vbp_tail.n11 vbp_tail.n3 2.3405
R2644 vbp_tail.n3 vbp_tail.n2 2.3405
R2645 vbp_tail.n1 vbp_tail.n0 2.3405
R2646 vbp_tail.n2 vbp_tail.n1 2.1605
R2647 vbp_tail.n7 vbp_tail.n5 1.7105
R2648 vbp_tail.n10 vbp_tail.n9 1.3505
R2649 vbp_tail.n8 vbp_tail.n7 0.8105
R2650 vbp_tail.n7 vbp_tail.n6 0.5405
R2651 vbp_bias.n12 vbp_bias.t10 25.8965
R2652 vbp_bias.n4 vbp_bias.t22 25.8785
R2653 vbp_bias.n0 vbp_bias.t9 25.7583
R2654 vbp_bias.n7 vbp_bias.t24 25.5095
R2655 vbp_bias.n5 vbp_bias.t26 25.469
R2656 vbp_bias.n13 vbp_bias.t14 25.4377
R2657 vbp_bias.n17 vbp_bias.t16 24.0965
R2658 vbp_bias.n4 vbp_bias.t20 23.1627
R2659 vbp_bias.n18 vbp_bias.t18 23.1573
R2660 vbp_bias.n12 vbp_bias.t12 23.1403
R2661 vbp_bias.n3 vbp_bias.t3 16.8291
R2662 vbp_bias.n21 vbp_bias.t0 15.8765
R2663 vbp_bias.n21 vbp_bias.n20 14.7155
R2664 vbp_bias.n13 vbp_bias.t15 14.6957
R2665 vbp_bias.n5 vbp_bias.t27 14.652
R2666 vbp_bias.n24 vbp_bias.n23 14.2205
R2667 vbp_bias.n2 vbp_bias.t6 13.9381
R2668 vbp_bias.n0 vbp_bias.t8 13.9381
R2669 vbp_bias.n20 vbp_bias.t17 13.887
R2670 vbp_bias.n1 vbp_bias.t7 13.8783
R2671 vbp_bias.n25 vbp_bias.t5 13.8783
R2672 vbp_bias.n16 vbp_bias.t11 13.867
R2673 vbp_bias.n3 vbp_bias.t2 13.8065
R2674 vbp_bias.n8 vbp_bias.t23 13.7957
R2675 vbp_bias.n9 vbp_bias.t21 13.7957
R2676 vbp_bias.n6 vbp_bias.t25 13.7481
R2677 vbp_bias.n11 vbp_bias.t19 13.7481
R2678 vbp_bias.n14 vbp_bias.t13 13.7311
R2679 vbp_bias vbp_bias.n25 12.047
R2680 vbp_bias.n2 vbp_bias.n1 11.8805
R2681 vbp_bias.n1 vbp_bias.n0 11.7005
R2682 vbp_bias.n23 vbp_bias.t1 9.26915
R2683 vbp_bias.n24 vbp_bias.n2 7.2005
R2684 vbp_bias vbp_bias.t4 4.72664
R2685 vbp_bias.n23 vbp_bias.n22 4.6355
R2686 vbp_bias.n25 vbp_bias.n24 4.5005
R2687 vbp_bias.n9 vbp_bias.n8 3.0605
R2688 vbp_bias.n17 vbp_bias.n16 2.7905
R2689 vbp_bias.n22 vbp_bias.n3 2.7905
R2690 vbp_bias.n19 vbp_bias.n18 2.2505
R2691 vbp_bias.n10 vbp_bias.n4 2.2505
R2692 vbp_bias.n15 vbp_bias.n12 2.2505
R2693 vbp_bias.n11 vbp_bias.n10 1.9805
R2694 vbp_bias.n8 vbp_bias.n7 1.9805
R2695 vbp_bias.n6 vbp_bias.n5 1.9805
R2696 vbp_bias.n14 vbp_bias.n13 1.9805
R2697 vbp_bias.n16 vbp_bias.n15 1.8905
R2698 vbp_bias.n20 vbp_bias.n19 1.8905
R2699 vbp_bias.n18 vbp_bias.n17 1.8005
R2700 vbp_bias.n15 vbp_bias.n14 0.9005
R2701 vbp_bias.n19 vbp_bias.n11 0.9005
R2702 vbp_bias.n22 vbp_bias.n21 0.9005
R2703 vbp_bias.n10 vbp_bias.n9 0.9005
R2704 vbp_bias.n7 vbp_bias.n6 0.9005
R2705 vbn_sink.n28 vbn_sink.n27 47.3855
R2706 vbn_sink.n24 vbn_sink.n23 46.8905
R2707 vbn_sink.n0 vbn_sink.t21 24.8377
R2708 vbn_sink.n4 vbn_sink.t27 24.8242
R2709 vbn_sink.n0 vbn_sink.t22 22.0027
R2710 vbn_sink.n2 vbn_sink.t24 22.0027
R2711 vbn_sink.n4 vbn_sink.t28 21.9892
R2712 vbn_sink.n6 vbn_sink.t30 21.9892
R2713 vbn_sink.n1 vbn_sink.t23 21.9577
R2714 vbn_sink.n3 vbn_sink.t25 21.9577
R2715 vbn_sink.n5 vbn_sink.t29 21.9442
R2716 vbn_sink.n7 vbn_sink.t31 21.9442
R2717 vbn_sink.n26 vbn_sink.t17 20.1359
R2718 vbn_sink.n24 vbn_sink.t15 20.0583
R2719 vbn_sink.n28 vbn_sink.t32 17.4892
R2720 vbn_sink.n8 vbn_sink.t20 16.863
R2721 vbn_sink.n13 vbn_sink.t1 16.6468
R2722 vbn_sink.n25 vbn_sink.t16 15.5285
R2723 vbn_sink.n27 vbn_sink.t18 15.5033
R2724 vbn_sink.n11 vbn_sink.t5 13.938
R2725 vbn_sink.n23 vbn_sink.t6 13.9355
R2726 vbn_sink.n22 vbn_sink.t13 13.8379
R2727 vbn_sink.n20 vbn_sink.t9 13.8379
R2728 vbn_sink.n13 vbn_sink.t2 13.8042
R2729 vbn_sink.n15 vbn_sink.t11 13.8042
R2730 vbn_sink.n9 vbn_sink.t8 13.803
R2731 vbn_sink.n21 vbn_sink.t14 13.8005
R2732 vbn_sink.n19 vbn_sink.t10 13.8005
R2733 vbn_sink.n14 vbn_sink.t3 13.7668
R2734 vbn_sink.n16 vbn_sink.t12 13.7668
R2735 vbn_sink.n8 vbn_sink.t7 13.7373
R2736 vbn_sink.n10 vbn_sink.t4 13.7373
R2737 vbn_sink vbn_sink.t26 12.8857
R2738 vbn_sink.n18 vbn_sink.n17 9.6755
R2739 vbn_sink.n12 vbn_sink.n11 9.6755
R2740 vbn_sink.n18 vbn_sink.t0 9.33792
R2741 vbn_sink.n12 vbn_sink.t19 9.30417
R2742 vbn_sink vbn_sink.n30 9.2975
R2743 vbn_sink.n19 vbn_sink.n18 7.3805
R2744 vbn_sink.n30 vbn_sink.n29 4.8605
R2745 vbn_sink.n17 vbn_sink.n12 4.6355
R2746 vbn_sink.n29 vbn_sink.n28 4.5005
R2747 vbn_sink.n16 vbn_sink.n15 3.0605
R2748 vbn_sink.n14 vbn_sink.n13 3.0605
R2749 vbn_sink.n10 vbn_sink.n9 3.0605
R2750 vbn_sink.n20 vbn_sink.n19 3.0605
R2751 vbn_sink.n22 vbn_sink.n21 3.0605
R2752 vbn_sink.n15 vbn_sink.n14 2.8805
R2753 vbn_sink.n9 vbn_sink.n8 2.8805
R2754 vbn_sink.n21 vbn_sink.n20 2.8805
R2755 vbn_sink.n29 vbn_sink.n7 2.8805
R2756 vbn_sink.n6 vbn_sink.n5 2.8805
R2757 vbn_sink.n2 vbn_sink.n1 2.8805
R2758 vbn_sink.n17 vbn_sink.n16 2.7905
R2759 vbn_sink.n11 vbn_sink.n10 2.7905
R2760 vbn_sink.n23 vbn_sink.n22 2.7905
R2761 vbn_sink.n7 vbn_sink.n6 2.7005
R2762 vbn_sink.n5 vbn_sink.n4 2.7005
R2763 vbn_sink.n30 vbn_sink.n3 2.7005
R2764 vbn_sink.n3 vbn_sink.n2 2.7005
R2765 vbn_sink.n1 vbn_sink.n0 2.7005
R2766 vbn_sink.n26 vbn_sink.n25 1.8005
R2767 vbn_sink.n27 vbn_sink.n26 1.0805
R2768 vbn_sink.n25 vbn_sink.n24 0.9005
R2769 b3_b b3_b.t2 413.057
R2770 b3_b.n0 b3_b.t0 29.9251
R2771 b3_b.n0 b3_b.t1 18.2995
R2772 b3_b b3_b.n0 11.9367
R2773 b1_b.n1 b1_b.t2 552.784
R2774 b1_b.n2 b1_b.t3 552.491
R2775 b1_b b1_b.t4 543.413
R2776 b1_b.n0 b1_b.t1 19.0513
R2777 b1_b.n0 b1_b.t0 17.9371
R2778 b1_b b1_b.n2 9.91021
R2779 b1_b.n1 b1_b.n0 7.6505
R2780 b1_b.n2 b1_b.n1 0.7205
R2781 b6_b b6_b.t2 70.8681
R2782 b6_b.n0 b6_b.t0 33.2506
R2783 b6_b.n0 b6_b.t1 26.6113
R2784 b6_b b6_b.n0 9.06575
R2785 b4_b b4_b.t2 217.519
R2786 b4_b.n0 b4_b.t1 38.4035
R2787 b4_b.n0 b4_b.t0 20.5606
R2788 b4_b b4_b.n0 19.2897
R2789 b0_b.n1 b0_b.t2 552.495
R2790 b0_b.n3 b0_b.t4 552.482
R2791 b0_b.n2 b0_b.t3 552.424
R2792 b0_b.n4 b0_b.t5 547.922
R2793 b0_b.n5 b0_b.t6 547.922
R2794 b0_b b0_b.t7 543.413
R2795 b0_b.n0 b0_b.t0 21.7749
R2796 b0_b.n0 b0_b.t1 18.3369
R2797 b0_b b0_b.n5 14.4612
R2798 b0_b.n5 b0_b.n4 10.0805
R2799 b0_b.n1 b0_b.n0 5.8055
R2800 b0_b.n4 b0_b.n3 5.4005
R2801 b0_b.n3 b0_b.n2 1.0805
R2802 b0_b.n2 b0_b.n1 1.0805
R2803 rbit0top.n1 rbit0top.t0 47.8149
R2804 rbit0top.n1 rbit0top.t1 27.35
R2805 rbit0top.n2 rbit0top.n1 24.7955
R2806 rbit0top.n0 rbit0top.t8 14.9729
R2807 rbit0top.n3 rbit0top.t2 13.6904
R2808 rbit0top.n0 rbit0top.t9 13.6898
R2809 rbit0top.n5 rbit0top.t4 13.6634
R2810 rbit0top.n7 rbit0top.t3 13.6544
R2811 rbit0top.n4 rbit0top.t6 13.6145
R2812 rbit0top rbit0top.n7 10.3573
R2813 rbit0top.n2 rbit0top.t7 9.11555
R2814 rbit0top.n3 rbit0top.n2 5.7605
R2815 rbit0top rbit0top.t5 4.60718
R2816 rbit0top.n6 rbit0top.n0 3.3178
R2817 rbit0top.n5 rbit0top.n4 1.2605
R2818 rbit0top.n4 rbit0top.n3 1.0805
R2819 rbit0top.n6 rbit0top.n5 0.6755
R2820 rbit0top.n7 rbit0top.n6 0.1355
R2821 rbit1top.n2 rbit1top.n1 31.7705
R2822 rbit1top.n1 rbit1top.t9 22.274
R2823 rbit1top.n0 rbit1top.t8 14.8598
R2824 rbit1top.n7 rbit1top.t5 13.8254
R2825 rbit1top.n9 rbit1top.t3 13.7984
R2826 rbit1top.n10 rbit1top.t2 13.7894
R2827 rbit1top.n2 rbit1top.t10 13.7888
R2828 rbit1top.n0 rbit1top.t7 13.7579
R2829 rbit1top.n8 rbit1top.t4 13.7495
R2830 rbit1top.n3 rbit1top.t11 13.6949
R2831 rbit1top.n5 rbit1top.t12 13.6724
R2832 rbit1top.n6 rbit1top.t6 13.6155
R2833 rbit1top.n4 rbit1top.t13 13.6152
R2834 rbit1top.n11 rbit1top.n0 10.3055
R2835 rbit1top.n1 rbit1top.t0 10.142
R2836 rbit1top rbit1top.n11 9.00729
R2837 rbit1top rbit1top.t1 4.60718
R2838 rbit1top.n3 rbit1top.n2 1.5305
R2839 rbit1top.n5 rbit1top.n4 1.2605
R2840 rbit1top.n4 rbit1top.n3 1.2605
R2841 rbit1top.n11 rbit1top.n10 1.2155
R2842 rbit1top.n7 rbit1top.n6 1.1705
R2843 rbit1top.n6 rbit1top.n5 1.0805
R2844 rbit1top.n9 rbit1top.n8 1.0805
R2845 rbit1top.n10 rbit1top.n9 0.9005
R2846 rbit1top.n8 rbit1top.n7 0.9005
R2847 rbit2top.n1 rbit2top.n0 34.9521
R2848 rbit2top.n0 rbit2top.t5 25.739
R2849 rbit2top.n4 rbit2top.t3 15.0003
R2850 rbit2top.n5 rbit2top.t2 13.9426
R2851 rbit2top.n4 rbit2top.t4 13.9336
R2852 rbit2top.n6 rbit2top.t0 13.8011
R2853 rbit2top.n3 rbit2top.t8 13.7502
R2854 rbit2top.n2 rbit2top.t9 13.6949
R2855 rbit2top.n7 rbit2top.n6 11.9255
R2856 rbit2top.n6 rbit2top.n5 10.6655
R2857 rbit2top.n0 rbit2top.t1 10.106
R2858 rbit2top rbit2top.n7 9.20075
R2859 rbit2top.n1 rbit2top.t6 9.11557
R2860 rbit2top.n2 rbit2top.n1 5.5805
R2861 rbit2top rbit2top.t7 4.60718
R2862 rbit2top.n3 rbit2top.n2 1.1705
R2863 rbit2top.n7 rbit2top.n3 1.0805
R2864 rbit2top.n5 rbit2top.n4 0.9005
R2865 b2_b.n1 b2_b.t2 291.709
R2866 b2_b.n2 b2_b.t3 291.709
R2867 b2_b b2_b.t4 282.7
R2868 b2_b.n0 b2_b.t0 29.7878
R2869 b2_b.n1 b2_b.n0 29.7455
R2870 b2_b b2_b.n2 9.96125
R2871 b2_b.n0 b2_b.t1 9.37191
R2872 b2_b.n2 b2_b.n1 1.0805
R2873 rbit6top.n2 rbit6top.t0 20.1082
R2874 rbit6top rbit6top.n3 16.4243
R2875 rbit6top.n2 rbit6top.t3 16.2905
R2876 rbit6top.n3 rbit6top.n0 11.2267
R2877 rbit6top.n3 rbit6top.t4 10.197
R2878 rbit6top.n1 rbit6top.n2 9.5405
R2879 rbit6top.n1 rbit6top.t5 9.02203
R2880 rbit6top.n1 rbit6top.n0 4.4644
R2881 rbit6top rbit6top.t2 5.06817
R2882 rbit6top.n0 rbit6top.t1 17.5032
R2883 rbit5top.n2 rbit5top.n1 30.1505
R2884 rbit5top rbit5top.t0 29.2375
R2885 rbit5top.n1 rbit5top.t5 28.961
R2886 rbit5top rbit5top.n2 16.7383
R2887 rbit5top.n2 rbit5top.n0 12.9155
R2888 rbit5top.n0 rbit5top.t2 11.3205
R2889 rbit5top.n0 rbit5top.t3 9.9581
R2890 rbit5top.n1 rbit5top.t4 5.59703
R2891 rbit5top rbit5top.t1 4.78433
R2892 b5_b b5_b.t2 119.752
R2893 b5_b b5_b.n0 34.8211
R2894 b5_b.n0 b5_b.t0 31.9875
R2895 b5_b.n0 b5_b.t1 9.33465
R2896 rbit3top.n3 rbit3top.n0 34.6609
R2897 rbit3top.n0 rbit3top.t2 21.3044
R2898 rbit3top.n1 rbit3top.t7 18.735
R2899 rbit3top.n0 rbit3top.t6 15.732
R2900 rbit3top.n5 rbit3top.n4 15.2105
R2901 rbit3top.n1 rbit3top.t3 13.9653
R2902 rbit3top.n4 rbit3top.t5 13.8076
R2903 rbit3top.n2 rbit3top.t4 13.7986
R2904 rbit3top rbit3top.n5 12.5895
R2905 rbit3top.n5 rbit3top.t0 9.43613
R2906 rbit3top rbit3top.t1 4.64242
R2907 rbit3top.n2 rbit3top.n1 1.0805
R2908 rbit3top.n3 rbit3top.n2 0.9905
R2909 rbit3top.n4 rbit3top.n3 0.1355
R2910 rbit4top.n2 rbit4top.t4 31.67
R2911 rbit4top.n3 rbit4top.n2 20.2505
R2912 rbit4top.n0 rbit4top.t5 17.61
R2913 rbit4top.n1 rbit4top.n0 17.0555
R2914 rbit4top.n0 rbit4top.t1 14.5188
R2915 rbit4top.n1 rbit4top.t0 13.9981
R2916 rbit4top.n3 rbit4top.n1 12.2405
R2917 rbit4top.n2 rbit4top.t3 10.097
R2918 rbit4top rbit4top.t2 4.64242
R2919 rbit4top rbit4top.n3 4.53446
R2920 vbn_fold.n13 vbn_fold.n12 129.555
R2921 vbn_fold.n1 vbn_fold.n0 44.9105
R2922 vbn_fold.n1 vbn_fold.t14 25.9901
R2923 vbn_fold.n0 vbn_fold.t12 17.6066
R2924 vbn_fold vbn_fold.t15 16.9451
R2925 vbn_fold.n2 vbn_fold.t10 16.6249
R2926 vbn_fold.n0 vbn_fold.t13 16.0915
R2927 vbn_fold.n6 vbn_fold.t4 13.9378
R2928 vbn_fold.n12 vbn_fold.t0 13.8799
R2929 vbn_fold.n2 vbn_fold.t11 13.8028
R2930 vbn_fold.n4 vbn_fold.t5 13.8028
R2931 vbn_fold.n9 vbn_fold.t3 13.8028
R2932 vbn_fold.n11 vbn_fold.t1 13.8028
R2933 vbn_fold.n3 vbn_fold.t6 13.7449
R2934 vbn_fold.n5 vbn_fold.t7 13.7449
R2935 vbn_fold.n8 vbn_fold.t8 13.7449
R2936 vbn_fold.n10 vbn_fold.t2 13.7449
R2937 vbn_fold.n7 vbn_fold.n6 9.6755
R2938 vbn_fold.n7 vbn_fold.t9 9.30284
R2939 vbn_fold vbn_fold.n13 9.0455
R2940 vbn_fold.n8 vbn_fold.n7 7.3805
R2941 vbn_fold.n11 vbn_fold.n10 3.0605
R2942 vbn_fold.n9 vbn_fold.n8 3.0605
R2943 vbn_fold.n5 vbn_fold.n4 3.0605
R2944 vbn_fold.n3 vbn_fold.n2 3.0605
R2945 vbn_fold.n10 vbn_fold.n9 2.8805
R2946 vbn_fold.n4 vbn_fold.n3 2.8805
R2947 vbn_fold.n12 vbn_fold.n11 2.7905
R2948 vbn_fold.n6 vbn_fold.n5 2.7905
R2949 vbn_fold.n13 vbn_fold.n1 2.3405
R2950 vbn_i.n1 vbn_i.n0 128.25
R2951 vbn_i.n6 vbn_i.n5 61.5605
R2952 vbn_i.n0 vbn_i.t5 25.027
R2953 vbn_i.n4 vbn_i.t10 18.7019
R2954 vbn_i.n0 vbn_i.t8 18.4407
R2955 vbn_i.n2 vbn_i.t1 18.0635
R2956 vbn_i.n3 vbn_i.t9 16.3752
R2957 vbn_i.n9 vbn_i.n8 16.2005
R2958 vbn_i vbn_i.n9 14.8944
R2959 vbn_i.n9 vbn_i.t0 13.8164
R2960 vbn_i.n8 vbn_i.t4 13.8164
R2961 vbn_i.n7 vbn_i.t7 13.7791
R2962 vbn_i.n7 vbn_i.n6 13.1405
R2963 vbn_i.n2 vbn_i.n1 11.0705
R2964 vbn_i.n5 vbn_i.t11 10.307
R2965 vbn_i.n3 vbn_i.n2 9.6755
R2966 vbn_i.n6 vbn_i.t6 9.31644
R2967 vbn_i.n4 vbn_i.n3 8.8205
R2968 vbn_i.n5 vbn_i.n4 7.0205
R2969 vbn_i.n1 vbn_i.t2 5.16057
R2970 vbn_i vbn_i.t3 4.72757
R2971 vbn_i.n8 vbn_i.n7 2.8805
R2972 vbp_i.n0 vbp_i.t11 313.841
R2973 vbp_i.n0 vbp_i.t12 312.521
R2974 vbp_i.n7 vbp_i.t19 31.7827
R2975 vbp_i.n2 vbp_i.t14 31.6027
R2976 vbp_i.n4 vbp_i.t16 31.6027
R2977 vbp_i.n6 vbp_i.t18 31.6027
R2978 vbp_i.n1 vbp_i.t13 31.5532
R2979 vbp_i.n3 vbp_i.t15 31.5532
R2980 vbp_i.n5 vbp_i.t17 31.5532
R2981 vbp_i.n12 vbp_i.t23 26.033
R2982 vbp_i.n16 vbp_i.t29 26.0263
R2983 vbp_i.n23 vbp_i.t40 26.0198
R2984 vbp_i.n27 vbp_i.t46 26.0198
R2985 vbp_i.n32 vbp_i.t56 25.9418
R2986 vbp_i.n20 vbp_i.t35 25.8215
R2987 vbp_i.n54 vbp_i.n11 23.6705
R2988 vbp_i.n12 vbp_i.t24 23.153
R2989 vbp_i.n13 vbp_i.t25 23.153
R2990 vbp_i.n14 vbp_i.t26 23.153
R2991 vbp_i.n15 vbp_i.t27 23.153
R2992 vbp_i.n16 vbp_i.t30 23.1463
R2993 vbp_i.n17 vbp_i.t31 23.1463
R2994 vbp_i.n18 vbp_i.t32 23.1463
R2995 vbp_i.n19 vbp_i.t33 23.1463
R2996 vbp_i.n52 vbp_i.t34 23.1463
R2997 vbp_i.n23 vbp_i.t41 23.1398
R2998 vbp_i.n24 vbp_i.t42 23.1398
R2999 vbp_i.n25 vbp_i.t43 23.1398
R3000 vbp_i.n26 vbp_i.t44 23.1398
R3001 vbp_i.n48 vbp_i.t45 23.1398
R3002 vbp_i.n28 vbp_i.t48 23.1398
R3003 vbp_i.n30 vbp_i.t50 23.1398
R3004 vbp_i.n27 vbp_i.t47 23.1398
R3005 vbp_i.n29 vbp_i.t49 23.1398
R3006 vbp_i.n31 vbp_i.t51 23.1398
R3007 vbp_i.n20 vbp_i.t36 23.1215
R3008 vbp_i.n21 vbp_i.t37 23.1215
R3009 vbp_i.n22 vbp_i.t38 23.1215
R3010 vbp_i.n50 vbp_i.t39 23.1215
R3011 vbp_i.n37 vbp_i.t5 23.0618
R3012 vbp_i.n35 vbp_i.t3 23.0618
R3013 vbp_i.n34 vbp_i.t55 23.0618
R3014 vbp_i.n32 vbp_i.t1 23.0618
R3015 vbp_i.n45 vbp_i.t52 23.0618
R3016 vbp_i.n42 vbp_i.t9 23.0618
R3017 vbp_i.n41 vbp_i.t7 23.0618
R3018 vbp_i.n40 vbp_i.t53 23.0618
R3019 vbp_i.n39 vbp_i.t54 23.0618
R3020 vbp_i.n10 vbp_i.n9 21.3755
R3021 vbp_i.n11 vbp_i.n10 21.3305
R3022 vbp_i.n49 vbp_i.n48 18.0005
R3023 vbp_i.n1 vbp_i.n0 17.0105
R3024 vbp_i.n43 vbp_i.t8 16.6064
R3025 vbp_i.n38 vbp_i.t6 15.9314
R3026 vbp_i.n36 vbp_i.t4 15.8941
R3027 vbp_i.n33 vbp_i.t2 15.8941
R3028 vbp_i.n11 vbp_i.t22 14.9342
R3029 vbp_i vbp_i.t28 14.0765
R3030 vbp_i.n10 vbp_i.t0 14.0571
R3031 vbp_i.n9 vbp_i.t21 14.0084
R3032 vbp_i.n43 vbp_i.t10 13.9141
R3033 vbp_i.n8 vbp_i.t20 13.8092
R3034 vbp_i.n46 vbp_i.n45 13.7705
R3035 vbp_i vbp_i.n54 9.077
R3036 vbp_i.n53 vbp_i.n52 5.5805
R3037 vbp_i.n51 vbp_i.n50 5.4005
R3038 vbp_i.n7 vbp_i.n6 5.2205
R3039 vbp_i.n39 vbp_i.n38 4.8605
R3040 vbp_i.n46 vbp_i.n31 4.4105
R3041 vbp_i.n40 vbp_i.n39 2.8805
R3042 vbp_i.n42 vbp_i.n41 2.8805
R3043 vbp_i.n35 vbp_i.n34 2.8805
R3044 vbp_i.n25 vbp_i.n24 2.8805
R3045 vbp_i.n21 vbp_i.n20 2.8805
R3046 vbp_i.n18 vbp_i.n17 2.8805
R3047 vbp_i.n14 vbp_i.n13 2.8805
R3048 vbp_i.n31 vbp_i.n30 2.8805
R3049 vbp_i.n29 vbp_i.n28 2.8805
R3050 vbp_i.n41 vbp_i.n40 2.7005
R3051 vbp_i.n47 vbp_i.n26 2.7005
R3052 vbp_i.n26 vbp_i.n25 2.7005
R3053 vbp_i.n24 vbp_i.n23 2.7005
R3054 vbp_i.n22 vbp_i.n21 2.7005
R3055 vbp_i.n51 vbp_i.n19 2.7005
R3056 vbp_i.n19 vbp_i.n18 2.7005
R3057 vbp_i.n17 vbp_i.n16 2.7005
R3058 vbp_i.n53 vbp_i.n15 2.7005
R3059 vbp_i.n15 vbp_i.n14 2.7005
R3060 vbp_i.n13 vbp_i.n12 2.7005
R3061 vbp_i.n30 vbp_i.n29 2.7005
R3062 vbp_i.n28 vbp_i.n27 2.7005
R3063 vbp_i.n8 vbp_i.n7 2.2055
R3064 vbp_i.n6 vbp_i.n5 1.9805
R3065 vbp_i.n4 vbp_i.n3 1.9805
R3066 vbp_i.n2 vbp_i.n1 1.9805
R3067 vbp_i.n44 vbp_i.n43 1.8905
R3068 vbp_i.n45 vbp_i.n44 1.8005
R3069 vbp_i.n34 vbp_i.n33 1.8005
R3070 vbp_i.n37 vbp_i.n36 1.8005
R3071 vbp_i.n49 vbp_i.n22 1.8005
R3072 vbp_i.n5 vbp_i.n4 1.8005
R3073 vbp_i.n3 vbp_i.n2 1.8005
R3074 vbp_i.n9 vbp_i.n8 1.6655
R3075 vbp_i.n38 vbp_i.n37 1.0805
R3076 vbp_i.n50 vbp_i.n49 1.0805
R3077 vbp_i.n47 vbp_i.n46 0.9905
R3078 vbp_i.n44 vbp_i.n42 0.9005
R3079 vbp_i.n33 vbp_i.n32 0.9005
R3080 vbp_i.n36 vbp_i.n35 0.9005
R3081 vbp_i.n48 vbp_i.n47 0.1805
R3082 vbp_i.n52 vbp_i.n51 0.1805
R3083 vbp_i.n54 vbp_i.n53 0.1805
C0 vbn psrg_m3_feed 0.15731f
C1 b1 rbit0top 0.38571f
C2 rb_mid vnx_bias 0.13229f
C3 aux_gate iref_gate 15.7958f
C4 vcasp v2 0.39417f
C5 rbit6top b1_b 0.61487f
C6 vcasp vref 8.70622f
C7 b2 rbit5top 0.15945f
C8 vbp_tail vsp 7.75864f
C9 b1 rbit1top 0.8303f
C10 vcasp vbp_i 0.81813f
C11 rb_mid vbn_i 1.83745f
C12 bgsu1 vnx_bias 7.65514f
C13 v1 vcasp 2.09942f
C14 avdd xf1 33.834f
C15 vq3 b4 0.12386f
C16 su_state vbn_i 0.31895f
C17 b5 vref 0.2878f
C18 rbit5top b1_b 0.15391f
C19 b5_b b3_b 0.10598f
C20 vcasp vsua 0.35493f
C21 vgn1 vx2 0.72762f
C22 b1 rbit2top 0.99261f
C23 su_state vsu 0.25313f
C24 vbn_i bgsu1 5.84265f
C25 rbit0top rfix1 0.23203f
C26 b6 b3_b 0.28826f
C27 b1 b4_b 0.21295f
C28 vref b0_b 0.46432f
C29 vbp_tail vbn_i 1.41501f
C30 rbit3top b3_b 0.50673f
C31 b3 dvdd 2.20454f
C32 vsu bgsu1 0.24904f
C33 vcasp psrg_mf1_protected 0.17385f
C34 vcasp vgn2 0.38385f
C35 vq3 rfix2 0.19915f
C36 vbn_sink xf2 6.54073f
C37 vref rbit6top 0.1484f
C38 b4_b b3_b 0.12044f
C39 iref_gate vbn_fold 1.99656f
C40 rbit4top b3_b 0.28591f
C41 psrg_mf1_protected vbn 0.14469f
C42 rbit6top rfix0 2.51098f
C43 vref rbit5top 0.10632f
C44 vx2 vx3 2.72171f
C45 rbit2top rfix1 0.47013f
C46 aux_gate vbn_i 0.5512f
C47 avdd psrg_vnc 16.3334f
C48 vq3 b5 0.23596f
C49 b2 b1 0.61748f
C50 vsu1 avdd 0.5438f
C51 aux_gate vsu 0.2354f
C52 vx2 psrg_m3_feed 5.74429f
C53 vq3 b2_b 0.16987f
C54 b1 b1_b 2.00112f
C55 pm2 pm1 4.31442f
C56 y1 vbn_fold 0.18844f
C57 vsu2 auxsu1 0.34171f
C58 rbit2top vbn_i 0.16636f
C59 b0 dvdd 2.26731f
C60 vq3 rbit6top 1.81815f
C61 psrg_vnc psrg_m3_protected 1.61441f
C62 vref vx2 0.93047f
C63 vbn_fold vnx_bias 3.57721f
C64 dvss b4 1.24793f
C65 vq3 rbit5top 0.37529f
C66 vbn_i vgn1 15.2543f
C67 psrg_m3_feed vaux 1.262f
C68 vbn_fold vbn_i 0.2675f
C69 iref_gate v2 0.45614f
C70 dvdd rbit0top 18.3773f
C71 aux_gate xf2 4.88286f
C72 vref iref_gate 0.10308f
C73 b1 vref 0.51763f
C74 vsu vbn_fold 0.44257f
C75 vcasp avdd 46.192f
C76 dvdd b5_b 0.80288f
C77 iref_gate vbp_i 3.93968f
C78 v1 iref_gate 0.16482f
C79 dvdd rbit1top 25.3067f
C80 vaux v2 0.47588f
C81 vq3 b6_b 0.44449f
C82 pm2 vgn2 1.53172f
C83 pm1 y1 10.8089f
C84 vsu2 bgsu1 0.30458f
C85 rb_mid auxsu1 0.15762f
C86 avdd vbn 2.00673f
C87 b6 dvdd 2.30319f
C88 dvdd rbit3top 9.08135f
C89 vbp_i vaux 0.3289f
C90 vsu2 vbp_tail 0.12196f
C91 v1 vaux 1.38295f
C92 psrg_m3_feed vnx_bias 0.50386f
C93 net4 v2 0.52157f
C94 dvdd rbit2top 14.9452f
C95 iref_gate vgn2 0.13452f
C96 v2 vsp 11.0642f
C97 dvdd b4_b 2.04749f
C98 b3 b0 0.11624f
C99 auxsu1 bgsu1 7.94465f
C100 dvss b5 1.66902f
C101 vcasp psrg_m3_protected 0.16753f
C102 vbn_sink su_state 0.15202f
C103 vbp_bias vbp_cas 14.5859f
C104 vref rfix1 0.48168f
C105 dvdd rbit4top 5.37254f
C106 vbn_i psrg_m3_feed 1.96377f
C107 net3 vbn_i 0.45093f
C108 dvss b2_b 1.29017f
C109 v1 vsp 10.877f
C110 v2 vnx_bias 0.12642f
C111 vsu psrg_m3_feed 0.14154f
C112 vbn_fold xf2 2.50897f
C113 dvss b0_b 0.68818f
C114 rfix0 rfix1 0.12694f
C115 vbn_sink vbp_tail 2.37557f
C116 vcasp psrg_vnc 15.0148f
C117 vq3 b1 0.61141f
C118 y1 vsua 0.13285f
C119 vsu1 vcasp 0.78354f
C120 dvss rbit6top 0.95852f
C121 vbn_i v2 0.467f
C122 b3 rbit0top 0.53074f
C123 vref vbn_i 0.15089f
C124 v1 vnx_bias 0.13405f
C125 psrg_vnc vbn 14.1477f
C126 vq3 b3_b 0.51249f
C127 y1 vgn2 1.33614f
C128 rb_mid bgsu1 0.10425f
C129 b2 dvdd 2.80824f
C130 b3 b5_b 0.1781f
C131 dvss rbit5top 1.32184f
C132 vbp_i vbn_i 7.64192f
C133 v1 vbn_i 0.26492f
C134 rb_mid vbp_tail 0.50471f
C135 b3 rbit1top 0.38125f
C136 vbp_tail su_state 10.1021f
C137 vnx_bias vgn2 0.6124f
C138 dvdd b1_b 1.71207f
C139 b4 b5 0.42193f
C140 b3 b6 0.90951f
C141 vsua vsu 0.58394f
C142 b3 rbit3top 0.36575f
C143 vbp_cas vgn1 1.53672f
C144 psrg_mf1_protected vbn_i 0.21759f
C145 vbn_i vgn2 1.16074f
C146 vbp_bias su_state 0.55381f
C147 pm2 xf1 0.36394f
C148 b3 b4_b 0.1346f
C149 b4 b0_b 0.21404f
C150 avdd vx2 26.6506f
C151 dvss b6_b 1.414f
C152 b3 rbit4top 2.00367f
C153 pm2 avdd 31.909f
C154 vbp_bias vbp_tail 0.87928f
C155 aux_gate su_state 0.45769f
C156 vq3 vbn_i 0.25936f
C157 auxsu1 vgn1 0.1004f
C158 b0 rbit0top 1.35816f
C159 xf2 v2 11.5641f
C160 iref_gate avdd 20.8364f
C161 vcasp vbn 2.53988f
C162 vref dvdd 4.32753f
C163 b4 rbit5top 0.33512f
C164 v1 xf2 0.85722f
C165 b0 rbit1top 0.95698f
C166 vbn_sink vbn_fold 3.89325f
C167 avdd vaux 4.46554f
C168 b3 b2 0.52826f
C169 dvss b1 1.39119f
C170 vx1 vgn1 3.76652f
C171 b0 rbit3top 0.26929f
C172 aux_gate vbp_bias 1.42034f
C173 vbp_cas psrg_m3_feed 5.05719f
C174 b0 rbit2top 0.53646f
C175 xf2 vgn2 1.39178f
C176 pm1 vbp_cas 9.1631f
C177 xf1 vsp 4.97169f
C178 dvss b3_b 0.44394f
C179 b4 b6_b 0.21254f
C180 b5 b0_b 0.18986f
C181 y1 avdd 49.4663f
C182 avdd vsp 73.61671f
C183 b0 rbit4top 0.27314f
C184 rbit1top rbit0top 17.5675f
C185 b2_b b0_b 0.36378f
C186 b5 rbit6top 0.23277f
C187 su_state vbn_fold 0.56831f
C188 b6 rbit0top 0.37201f
C189 auxsu1 psrg_m3_feed 0.36042f
C190 vbp_cas v2 2.11532f
C191 rbit6top b2_b 0.25905f
C192 rbit3top rbit0top 0.19869f
C193 vsu2 v2 0.34609f
C194 avdd vnx_bias 0.32289f
C195 vq3 dvdd 2.5307f
C196 rbit2top rbit0top 1.75658f
C197 rbit6top b0_b 0.45445f
C198 b5 rbit5top 0.18324f
C199 vx1 vx3 6.5981f
C200 b6 b5_b 0.12061f
C201 vbp_tail vbn_fold 0.49119f
C202 vbp_i vbp_cas 0.41282f
C203 rbit3top b5_b 0.10112f
C204 v1 vbp_cas 2.35797f
C205 psrg_vnc vaux 3.13776f
C206 b6 rbit1top 0.3938f
C207 vsu2 vbp_i 1.91139f
C208 avdd vbn_i 18.1783f
C209 rbit5top b2_b 0.25686f
C210 rbit3top rbit1top 0.12122f
C211 v1 vsu2 0.30365f
C212 b3 vref 0.16929f
C213 rbit2top rbit1top 9.8513f
C214 b0 b2 0.23544f
C215 b5_b b4_b 0.1403f
C216 rbit5top b0_b 0.12174f
C217 vsu avdd 4.032f
C218 vx1 psrg_m3_feed 5.51197f
C219 b6 rbit3top 0.22366f
C220 rbit3top rbit2top 5.74144f
C221 rbit5top rbit6top 1.10162f
C222 vbp_cas vgn2 9.81598f
C223 y1 psrg_vnc 0.72307f
C224 vcasp vx2 5.49219f
C225 aux_gate vgn1 0.11942f
C226 b4 b3_b 0.37929f
C227 b6 b4_b 0.18235f
C228 b0 b1_b 0.11519f
C229 rbit3top b4_b 0.16324f
C230 vsua auxsu1 0.1181f
C231 b6 rbit4top 0.35582f
C232 net3 su_state 7.12065f
C233 aux_gate vbn_fold 4.71041f
C234 vbn_sink vbp_i 18.381f
C235 rbit4top rbit3top 4.12866f
C236 su_state pm1 0.4197f
C237 rbit4top rbit2top 1.33249f
C238 vx1 vref 0.7335f
C239 b2 rbit0top 0.29231f
C240 bgsu1 psrg_m3_feed 12.2716f
C241 psrg_vnc vnx_bias 0.16714f
C242 rbit4top b4_b 0.52889f
C243 auxsu1 vgn2 0.12252f
C244 vsu1 vnx_bias 0.61064f
C245 rb_mid v2 0.17611f
C246 net3 vbp_tail 8.97717f
C247 rbit6top b6_b 0.13315f
C248 vbn_i psrg_vnc 1.64813f
C249 su_state vref 0.11169f
C250 xf2 xf1 13.2025f
C251 b2 rbit1top 0.59167f
C252 vbn_sink vgn2 1.02932f
C253 rb_mid vbp_i 0.19072f
C254 vq2 su_state 0.24593f
C255 avdd xf2 31.138f
C256 v1 rb_mid 0.17038f
C257 net3 vbp_bias 0.21979f
C258 vcasp vaux 3.49991f
C259 vq3 b3 0.73433f
C260 su_state vbp_i 0.19028f
C261 b5_b b1_b 0.24169f
C262 vbp_tail v2 0.24124f
C263 b2 rbit3top 0.28452f
C264 rfix2 rfix1 0.12712f
C265 vbp_tail vref 2.91169f
C266 rbit1top b1_b 1.0224f
C267 b1 b2_b 0.16487f
C268 b2 rbit2top 0.27743f
C269 vq3 vbn_sink 0.20844f
C270 vq2 vbp_tail 0.91017f
C271 aux_gate psrg_m3_feed 0.29788f
C272 b6 b1_b 0.18908f
C273 b5 b3_b 0.14928f
C274 vbp_tail vbp_i 2.50901f
C275 dvss dvdd 5.20602f
C276 v1 vbp_tail 0.39653f
C277 vbp_bias v2 0.40782f
C278 b2 rbit4top 0.11838f
C279 rbit2top b1_b 1.0123f
C280 b2_b b3_b 0.18346f
C281 vbp_bias vref 1.11855f
C282 su_state vgn2 1.80237f
C283 b4_b b1_b 0.13055f
C284 vref rbit0top 2.59934f
C285 vbp_bias vbp_i 0.30346f
C286 v1 vbp_bias 1.3071f
C287 vcasp vnx_bias 0.79919f
C288 aux_gate vref 0.49479f
C289 rbit6top b3_b 0.26035f
C290 vq3 su_state 0.51611f
C291 vgn1 vx3 1.01119f
C292 rbit0top rfix0 0.20304f
C293 vref rbit1top 2.41219f
C294 vcasp vbn_i 0.24227f
C295 avdd vbp_cas 88.6687f
C296 vcasp vsu 0.47883f
C297 vref rbit3top 0.1028f
C298 vsu2 avdd 1.20354f
C299 vq3 vbp_tail 0.35541f
C300 vgn1 psrg_m3_feed 10.93f
C301 vref rbit2top 2.42774f
C302 net3 vbn_fold 0.23177f
C303 vsu2 auxsu2 0.3506f
C304 b4 dvdd 2.36989f
C305 vsu vbn 0.35354f
C306 avdd auxsu1 1.24345f
C307 vref rbit4top 0.22388f
C308 aux_gate vgn2 0.27644f
C309 rbit2top rfix0 0.46931f
C310 vbn_sink xf1 6.46388f
C311 vgn1 v2 1.98185f
C312 vq3 rbit0top 0.43158f
C313 b6_b b3_b 0.10274f
C314 vbn_sink avdd 41.2057f
C315 vref vgn1 1.04938f
C316 iref_gate pm2 0.62637f
C317 auxsu2 auxsu1 0.20281f
C318 dvss b3 1.93871f
C319 rbit4top rfix0 0.5693f
C320 vref vbn_fold 0.54268f
C321 vq3 b5_b 0.20329f
C322 v1 vgn1 2.17754f
C323 psrg_m3_feed vx3 4.77775f
C324 vq3 rbit1top 0.72171f
C325 vx1 avdd 25.4361f
C326 vbn_fold vbp_i 12.8191f
C327 vq3 b6 0.52063f
C328 vsua vbn_fold 0.352f
C329 b2 vref 0.27624f
C330 vq3 rbit3top 1.10979f
C331 rb_mid avdd 1.00229f
C332 vq3 rbit2top 0.51949f
C333 su_state avdd 3.91082f
C334 vgn1 vgn2 5.08749f
C335 psrg_vnc auxsu1 0.21772f
C336 vref vx3 2.39972f
C337 vref b1_b 0.46737f
C338 b1 b3_b 0.19763f
C339 pm2 y1 9.01765f
C340 psrg_mf1_protected vbn_fold 1.13136f
C341 vbn_fold vgn2 2.94054f
C342 vq3 rbit4top 0.25004f
C343 vsu2 bgsu2 0.27649f
C344 b5 dvdd 1.97426f
C345 avdd bgsu1 1.00868f
C346 vbp_tail avdd 36.6034f
C347 net3 v2 0.27754f
C348 dvdd b2_b 2.9187f
C349 psrg_m3_feed v2 0.3215f
C350 vref psrg_m3_feed 2.17415f
C351 net3 vref 0.13987f
C352 iref_gate vsp 0.10696f
C353 dvdd b0_b 4.15922f
C354 auxsu1 bgsu2 0.2998f
C355 dvss b0 1.53675f
C356 b3 b4 2.21325f
C357 vq3 vbn_fold 2.10089f
C358 vbp_i psrg_m3_feed 0.18956f
C359 net3 vbp_i 0.34493f
C360 vbp_bias avdd 71.3381f
C361 v1 psrg_m3_feed 0.24565f
C362 dvdd rbit6top 3.48836f
C363 v1 net3 0.67149f
C364 pm2 vbn_i 0.32466f
C365 aux_gate xf1 0.16199f
C366 rb_mid psrg_vnc 0.26276f
C367 vcasp vbp_cas 3.14978f
C368 vq3 b2 0.53362f
C369 vsu1 rb_mid 0.15385f
C370 aux_gate avdd 12.4002f
C371 dvdd rbit5top 3.45499f
C372 iref_gate vbn_i 0.48017f
C373 vbp_i v2 0.16368f
C374 dvss rbit0top 5.07312f
C375 vaux vnx_bias 0.11873f
C376 psrg_mf1_protected psrg_m3_feed 0.11778f
C377 v1 v2 19.0708f
C378 vref vbp_i 0.26276f
C379 psrg_m3_feed vgn2 0.35919f
C380 psrg_vnc bgsu1 1.55387f
C381 vq3 b1_b 0.46662f
C382 vref rfix0 0.48258f
C383 pm1 vgn2 1.18525f
C384 vcasp auxsu1 0.45235f
C385 dvss b5_b 1.3604f
C386 v1 vq2 0.45838f
C387 v1 vbp_i 0.13259f
C388 dvss rbit1top 6.97969f
C389 vq3 net3 0.64547f
C390 v2 vgn2 2.46456f
C391 dvdd b6_b 0.89872f
C392 b3 b5 0.54286f
C393 bgsu2 bgsu1 0.30326f
C394 dvss b6 1.48043f
C395 auxsu1 vbn 12.9764f
C396 dvss rbit3top 2.46367f
C397 net4 vbn_i 0.44444f
C398 dvss rbit2top 3.44727f
C399 b3 b2_b 0.86019f
C400 vbp_i vgn2 0.21338f
C401 vcasp vx1 5.11514f
C402 pm2 xf2 0.16092f
C403 vbn_fold xf1 4.20325f
C404 avdd vgn1 19.8104f
C405 dvss b4_b 1.03304f
C406 b3 b0_b 0.45596f
C407 v1 vgn2 0.26813f
C408 vq3 vref 35.7254f
C409 dvss rbit4top 2.4366f
C410 avdd vbn_fold 40.6125f
C411 rb_mid vcasp 0.41312f
C412 b3 rbit6top 0.27467f
C413 vq3 vq2 1.40221f
C414 vbn_i vnx_bias 15.854f
C415 vq3 vbp_i 0.39704f
C416 b4 rbit0top 0.33932f
C417 vq3 v1 0.51915f
C418 vq3 rfix0 0.48937f
C419 psrg_mf1_protected vgn2 0.10811f
C420 rb_mid vbn 0.16643f
C421 vcasp bgsu1 0.72817f
C422 b1 dvdd 1.9632f
C423 b4 b5_b 2.31201f
C424 b3 rbit5top 0.31365f
C425 su_state vbn 0.14402f
C426 vcasp vbp_tail 0.53832f
C427 psrg_m3_protected vgn1 0.46888f
C428 b4 rbit1top 0.30293f
C429 rfix2 rbit0top 0.24932f
C430 avdd vx3 25.8418f
C431 dvdd b3_b 0.98607f
C432 b4 b6 0.12575f
C433 dvss b2 1.02449f
C434 bgsu1 vbn 8.43135f
C435 b0 b2_b 0.66587f
C436 psrg_vnc vgn1 0.42514f
C437 b4 rbit2top 0.1416f
C438 xf2 vsp 4.80498f
C439 pm2 vbp_cas 9.40883f
C440 pm1 xf1 0.25666f
C441 b0 b0_b 1.57273f
C442 avdd psrg_m3_feed 54.8926f
C443 b4 b4_b 0.44717f
C444 dvss b1_b 0.40119f
C445 b3 b6_b 0.12306f
C446 net3 avdd 4.40795f
C447 b4 rbit4top 0.15644f
C448 pm1 avdd 32.2079f
C449 b0 rbit6top 0.37638f
C450 iref_gate vbp_cas 0.78455f
C451 xf1 v2 1.25868f
C452 b5 rbit0top 0.32229f
C453 rfix2 rbit2top 0.47492f
C454 avdd v2 19.6802f
C455 aux_gate vbn 0.13619f
C456 vref avdd 28.1483f
C457 b5 b5_b 0.71797f
C458 b0 rbit5top 0.65409f
C459 rbit0top b0_b 2.41895f
C460 v1 xf1 10.8469f
C461 psrg_m3_protected psrg_m3_feed 0.68933f
C462 b5 rbit1top 0.26006f
C463 avdd vbp_i 0.20617p
C464 v1 avdd 19.5682f
C465 rbit6top rbit0top 0.1802f
C466 b4 b2 0.12242f
C467 dvss vref 0.17802f
C468 b5 b6 0.74946f
C469 b3 b1 0.14443f
C470 vsua avdd 0.69736f
C471 b5 rbit3top 0.11617f
C472 vx1 vx2 6.69267f
C473 rbit1top b0_b 2.10517f
C474 vbn_sink iref_gate 0.5317f
C475 psrg_vnc psrg_m3_feed 8.85958f
C476 rbit3top b2_b 1.34317f
C477 b5_b rbit6top 0.17822f
C478 psrg_m3_protected v2 2.23226f
C479 xf1 vgn2 1.58047f
C480 y1 vbp_cas 8.24885f
C481 b6 b0_b 0.231f
C482 b5 b4_b 0.51793f
C483 vcasp vgn1 5.27225f
C484 net4 vsu2 0.26004f
C485 b2_b rbit2top 0.62978f
C486 rbit5top rbit0top 0.19532f
C487 avdd vgn2 19.4907f
C488 vcasp vbn_fold 0.61735f
C489 rbit2top b0_b 0.12093f
C490 b6 rbit6top 0.21217f
C491 su_state pm2 0.32515f
C492 b5_b rbit5top 0.32349f
C493 rbit3top rbit6top 0.73333f
C494 rbit4top b2_b 0.17164f
C495 v1 psrg_m3_protected 0.83811f
C496 psrg_vnc v2 0.52915f
C497 rbit6top rbit2top 0.27768f
C498 rbit4top b0_b 0.10611f
C499 vsu1 v2 0.11888f
C500 vq3 avdd 16.3694f
C501 b6 rbit5top 0.169f
C502 su_state iref_gate 8.37129f
C503 vbp_i psrg_vnc 6.79147f
C504 rbit3top rbit5top 5.74397f
C505 rbit4top rbit6top 0.59917f
C506 v1 psrg_vnc 0.24643f
C507 vsu2 vbn_i 0.12901f
C508 vsu1 vbp_i 0.32765f
C509 rbit5top rbit2top 0.13796f
C510 psrg_m3_protected vgn2 1.6241f
C511 auxsu1 vnx_bias 2.31588f
C512 vq3 dvss 0.88599f
C513 rb_mid vaux 0.24947f
C514 vcasp vx3 5.64491f
C515 b0 b1 0.28169f
C516 b5 b2 0.9131f
C517 b4 vref 0.32122f
C518 rbit5top b4_b 0.64681f
C519 b5_b b6_b 0.12883f
C520 vbp_tail iref_gate 0.8785f
C521 rbit4top rbit5top 2.58032f
C522 b2 b2_b 0.6365f
C523 psrg_mf1_protected psrg_vnc 0.86885f
C524 psrg_vnc vgn2 0.25864f
C525 b6 b6_b 0.46004f
C526 b2 b0_b 0.4976f
C527 vcasp psrg_m3_feed 8.93628f
C528 rbit3top b6_b 0.10124f
C529 vsu auxsu1 0.10019f
C530 aux_gate pm2 1.57445f
C531 rfix2 vref 0.48703f
C532 b2 rbit6top 0.32719f
C533 su_state vsp 0.32471f
C534 b4_b b6_b 0.39921f
C535 vref avss 3.16753p
C536 b1 avss 5.13414f
C537 b2 avss 3.70932f
C538 b6 avss 5.18258f
C539 b5 avss 3.65995f
C540 b0 avss 5.82791f
C541 b4 avss 4.67338f
C542 b3 avss 5.5894f
C543 dvss avss 32.76229f
C544 avdd avss 9.35566p
C545 dvdd avss 0.2317p
C546 psrg_mf1_protected avss 7.47702f
C547 y1 avss 13.991f
C548 pm1 avss 11.15991f
C549 pm2 avss 11.91015f
C550 iref_gate avss 18.31875f
C551 vbn avss 14.44272f
C552 bgsu1 avss 0.20365f
C553 psrg_m3_protected avss 6.94628f
C554 psrg_vnc avss 23.62988f
C555 vbp_cas avss 21.90015f
C556 xf1 avss 27.52707f
C557 xf2 avss 32.01977f
C558 vgn2 avss 0.26258p
C559 vsp avss 8.21093f
C560 v2 avss 34.40762f
C561 vaux avss 6.14062f
C562 vx3 avss 13.77167f
C563 psrg_m3_feed avss 23.8615f
C564 vx2 avss 7.97897f
C565 vgn1 avss 21.97087f
C566 vx1 avss 4.61826f
C567 su_state avss 26.34457f
C568 vbp_tail avss 12.8343f
C569 vbp_bias avss 12.51486f
C570 aux_gate avss 0.83791f
C571 vsu1 avss 8.80972f
C572 vsu2 avss 13.13799f
C573 vbn_sink avss 83.71477f
C574 rfix2 avss 11.172f
C575 rfix1 avss 11.1355f
C576 rfix0 avss 9.6286f
C577 b3_b avss 2.07303f
C578 b1_b avss 1.35365f
C579 b6_b avss 2.11349f
C580 b4_b avss 2.01231f
C581 b0_b avss 2.03142f
C582 rbit0top avss 21.6944f
C583 rbit1top avss 10.55102f
C584 rbit2top avss 11.36365f
C585 b2_b avss 2.27429f
C586 rbit6top avss 16.93471f
C587 rbit5top avss 21.61783f
C588 b5_b avss 6.12732f
C589 rbit3top avss 22.62498f
C590 rbit4top avss 13.6211f
C591 vbn_fold avss 37.06571f
C592 vbn_i avss 40.04003f
C593 vbp_i avss 81.16082f
C594 vbp_i.n0 avss 1.97831f
C595 vbp_i.n1 avss 0.97004f
C596 vbp_i.n2 avss 0.50622f
C597 vbp_i.n3 avss 0.50288f
C598 vbp_i.n4 avss 0.50622f
C599 vbp_i.n5 avss 0.50288f
C600 vbp_i.n6 avss 0.61844f
C601 vbp_i.n7 avss 0.63181f
C602 vbp_i.n8 avss 0.14485f
C603 vbp_i.n9 avss 0.74467f
C604 vbp_i.t0 avss 3.9782f
C605 vbp_i.n10 avss 1.0888f
C606 vbp_i.n11 avss 1.16325f
C607 vbp_i.n12 avss 1.364f
C608 vbp_i.n13 avss 0.75948f
C609 vbp_i.n14 avss 0.75948f
C610 vbp_i.n15 avss 0.75398f
C611 vbp_i.n16 avss 1.36382f
C612 vbp_i.n17 avss 0.7594f
C613 vbp_i.n18 avss 0.7594f
C614 vbp_i.n19 avss 0.7539f
C615 vbp_i.n20 avss 1.36182f
C616 vbp_i.n21 avss 0.75876f
C617 vbp_i.n22 avss 0.72575f
C618 vbp_i.n23 avss 1.36629f
C619 vbp_i.n24 avss 0.76072f
C620 vbp_i.n25 avss 0.76072f
C621 vbp_i.n26 avss 0.75522f
C622 vbp_i.n27 avss 1.36359f
C623 vbp_i.n28 avss 0.75929f
C624 vbp_i.n29 avss 0.75929f
C625 vbp_i.n30 avss 0.75929f
C626 vbp_i.n31 avss 0.81431f
C627 vbp_i.t6 avss 2.89483f
C628 vbp_i.t4 avss 2.89216f
C629 vbp_i.t2 avss 2.89216f
C630 vbp_i.n32 avss 1.29188f
C631 vbp_i.n33 avss 0.21512f
C632 vbp_i.n34 avss 0.72307f
C633 vbp_i.n35 avss 0.69556f
C634 vbp_i.n36 avss 0.21512f
C635 vbp_i.n37 avss 0.66805f
C636 vbp_i.n38 avss 0.32858f
C637 vbp_i.n39 avss 0.82536f
C638 vbp_i.n40 avss 0.75057f
C639 vbp_i.n41 avss 0.75057f
C640 vbp_i.n42 avss 0.69556f
C641 vbp_i.t8 avss 2.90184f
C642 vbp_i.t10 avss 2.88191f
C643 vbp_i.n43 avss 0.25587f
C644 vbp_i.n44 avss 0.14029f
C645 vbp_i.n45 avss 1.07691f
C646 vbp_i.n46 avss 0.60572f
C647 vbp_i.n47 avss 0.11879f
C648 vbp_i.n48 avss 1.16031f
C649 vbp_i.n49 avss 0.64299f
C650 vbp_i.n50 avss 0.78994f
C651 vbp_i.n51 avss 0.25767f
C652 vbp_i.n52 avss 0.76854f
C653 vbp_i.n53 avss 0.2632f
C654 vbp_i.n54 avss 0.74417f
C655 vbn_i.t6 avss 3.69502f
C656 vbn_i.t2 avss 3.77491f
C657 vbn_i.t5 avss 8.58573f
C658 vbn_i.n0 avss 10.7072f
C659 vbn_i.n1 avss 10.0192f
C660 vbn_i.n2 avss 1.29574f
C661 vbn_i.n3 avss 2.0513f
C662 vbn_i.n4 avss 1.43088f
C663 vbn_i.n5 avss 4.35196f
C664 vbn_i.n6 avss 5.84233f
C665 vbn_i.t7 avss 3.70491f
C666 vbn_i.n7 avss 1.33699f
C667 vbn_i.t4 avss 3.71214f
C668 vbn_i.n8 avss 1.77676f
C669 vbn_i.t0 avss 3.71214f
C670 vbn_i.n9 avss 2.33646f
C671 vbn_i.t3 avss 3.69701f
C672 vbn_fold.t13 avss 2.07353f
C673 vbn_fold.n0 avss 4.83316f
C674 vbn_fold.n1 avss 6.06758f
C675 vbn_fold.t4 avss 3.83712f
C676 vbn_fold.t10 avss 3.92128f
C677 vbn_fold.t11 avss 3.83657f
C678 vbn_fold.n2 avss 0.8893f
C679 vbn_fold.t6 avss 3.82882f
C680 vbn_fold.n3 avss 0.62223f
C681 vbn_fold.t5 avss 3.83657f
C682 vbn_fold.n4 avss 0.62756f
C683 vbn_fold.t7 avss 3.82882f
C684 vbn_fold.n5 avss 0.61317f
C685 vbn_fold.n6 avss 0.85032f
C686 vbn_fold.t9 avss 3.81983f
C687 vbn_fold.n7 avss 0.6469f
C688 vbn_fold.t8 avss 3.82928f
C689 vbn_fold.n8 avss 0.80041f
C690 vbn_fold.t3 avss 3.83702f
C691 vbn_fold.n9 avss 0.62774f
C692 vbn_fold.t2 avss 3.82928f
C693 vbn_fold.n10 avss 0.62204f
C694 vbn_fold.t1 avss 3.83702f
C695 vbn_fold.n11 avss 0.61892f
C696 vbn_fold.t0 avss 3.86747f
C697 vbn_fold.n12 avss 11.9428f
C698 vbn_fold.n13 avss 11.3925f
C699 rbit4top.t0 avss 1.67294f
C700 rbit4top.t5 avss 1.38252f
C701 rbit4top.t1 avss 0.70629f
C702 rbit4top.n0 avss 2.8405f
C703 rbit4top.n1 avss 2.82487f
C704 rbit4top.t4 avss 2.13366f
C705 rbit4top.t3 avss 0.70355f
C706 rbit4top.n2 avss 4.69513f
C707 rbit4top.n3 avss 3.45141f
C708 rbit4top.t2 avss 3.08743f
C709 rbit3top.t1 avss 2.06861f
C710 rbit3top.t0 avss 1.47531f
C711 rbit3top.t6 avss 0.45547f
C712 rbit3top.t2 avss 2.00725f
C713 rbit3top.n0 avss 18.9553f
C714 rbit3top.t7 avss 1.02071f
C715 rbit3top.t3 avss 1.43233f
C716 rbit3top.n1 avss 0.74958f
C717 rbit3top.t4 avss 1.44372f
C718 rbit3top.n2 avss 0.19498f
C719 rbit3top.n3 avss 1.84197f
C720 rbit3top.t5 avss 1.43838f
C721 rbit3top.n4 avss 0.67448f
C722 rbit3top.n5 avss 1.73532f
C723 b5_b.t1 avss 0.38088f
C724 b5_b.t0 avss 0.83044f
C725 b5_b.n0 avss 3.82696f
C726 rbit5top.t2 avss 0.71781f
C727 rbit5top.t3 avss 0.61456f
C728 rbit5top.n0 avss 0.5985f
C729 rbit5top.t5 avss 2.52575f
C730 rbit5top.t4 avss 0.56374f
C731 rbit5top.n1 avss 5.06153f
C732 rbit5top.n2 avss 4.43689f
C733 rbit5top.t0 avss 0.88518f
C734 rbit5top.t1 avss 1.42693f
C735 rbit6top.n0 avss 2.57827f
C736 rbit6top.n1 avss 1.03141f
C737 rbit6top.t1 avss 0.3207f
C738 rbit6top.t0 avss 1.66045f
C739 rbit6top.t3 avss 1.32515f
C740 rbit6top.n2 avss 4.21135f
C741 rbit6top.t5 avss 0.12984f
C742 rbit6top.t4 avss 0.36246f
C743 rbit6top.n3 avss 2.01283f
C744 rbit6top.t2 avss 0.64233f
C745 b2_b.t1 avss 0.17731f
C746 b2_b.t0 avss 0.87773f
C747 b2_b.n0 avss 3.08323f
C748 b2_b.n1 avss 2.87926f
C749 b2_b.n2 avss 0.77103f
C750 rbit2top.t7 avss 4.75965f
C751 rbit2top.t6 avss 4.85286f
C752 rbit2top.t1 avss 0.85548f
C753 rbit2top.t5 avss 1.79691f
C754 rbit2top.n0 avss 5.62065f
C755 rbit2top.n1 avss 3.76127f
C756 rbit2top.t9 avss 4.84132f
C757 rbit2top.n2 avss 0.52075f
C758 rbit2top.t8 avss 4.828f
C759 rbit2top.n3 avss 0.40845f
C760 rbit2top.t2 avss 2.51938f
C761 rbit2top.t4 avss 2.5064f
C762 rbit2top.t3 avss 2.52816f
C763 rbit2top.n4 avss 0.63858f
C764 rbit2top.n5 avss 1.72865f
C765 rbit2top.t0 avss 2.567f
C766 rbit2top.n6 avss 3.23095f
C767 rbit2top.n7 avss 1.9111f
C768 rbit1top.t1 avss 4.78197f
C769 rbit1top.t7 avss 4.91793f
C770 rbit1top.t8 avss 4.93306f
C771 rbit1top.n0 avss 1.97115f
C772 rbit1top.t2 avss 4.85568f
C773 rbit1top.t3 avss 4.85146f
C774 rbit1top.t4 avss 4.85262f
C775 rbit1top.t5 avss 4.85597f
C776 rbit1top.t10 avss 4.93784f
C777 rbit1top.t0 avss 0.87321f
C778 rbit1top.t9 avss 1.13905f
C779 rbit1top.n1 avss 4.84025f
C780 rbit1top.n2 avss 4.91707f
C781 rbit1top.t11 avss 4.88842f
C782 rbit1top.n3 avss 0.49064f
C783 rbit1top.t13 avss 4.88297f
C784 rbit1top.n4 avss 0.4517f
C785 rbit1top.t12 avss 4.88892f
C786 rbit1top.n5 avss 0.4206f
C787 rbit1top.t6 avss 4.84936f
C788 rbit1top.n6 avss 0.38685f
C789 rbit1top.n7 avss 0.4036f
C790 rbit1top.n8 avss 0.37565f
C791 rbit1top.n9 avss 0.38495f
C792 rbit1top.n10 avss 0.39865f
C793 rbit1top.n11 avss 1.67858f
C794 rbit0top.t3 avss 3.69556f
C795 rbit0top.t8 avss 3.78029f
C796 rbit0top.t9 avss 3.76442f
C797 rbit0top.n0 avss 4.79405f
C798 rbit0top.t4 avss 3.70053f
C799 rbit0top.t6 avss 3.69764f
C800 rbit0top.t7 avss 3.67954f
C801 rbit0top.t0 avss 3.0188f
C802 rbit0top.t1 avss 1.03183f
C803 rbit0top.n1 avss 7.58739f
C804 rbit0top.n2 avss 2.63183f
C805 rbit0top.t2 avss 3.70607f
C806 rbit0top.n3 avss 0.43229f
C807 rbit0top.n4 avss 0.31049f
C808 rbit0top.n5 avss 0.26655f
C809 rbit0top.n6 avss 7.78279f
C810 rbit0top.n7 avss 0.28447f
C811 rbit0top.t5 avss 3.64558f
C812 b0_b.t0 avss 0.69243f
C813 b0_b.t1 avss 0.19304f
C814 b0_b.n0 avss 2.20437f
C815 b0_b.n1 avss 1.31409f
C816 b0_b.n2 avss 0.7179f
C817 b0_b.n3 avss 0.70441f
C818 b0_b.n4 avss 0.69738f
C819 b0_b.n5 avss 0.8116f
C820 b4_b.t1 avss 1.00545f
C821 b4_b.t0 avss 0.71834f
C822 b4_b.n0 avss 4.04722f
C823 b6_b.t1 avss 0.5761f
C824 b6_b.t0 avss 1.02432f
C825 b6_b.n0 avss 3.10602f
C826 b1_b.t1 avss 0.19992f
C827 b1_b.t0 avss 0.52623f
C828 b1_b.n0 avss 1.96891f
C829 b1_b.n1 avss 1.64693f
C830 b1_b.n2 avss 0.83191f
C831 b3_b.t1 avss 0.23652f
C832 b3_b.t0 avss 1.1013f
C833 b3_b.n0 avss 1.9112f
C834 vbn_sink.n0 avss 1.09574f
C835 vbn_sink.n1 avss 0.61621f
C836 vbn_sink.n2 avss 0.6184f
C837 vbn_sink.n3 avss 0.61095f
C838 vbn_sink.n4 avss 1.09534f
C839 vbn_sink.n5 avss 0.61601f
C840 vbn_sink.n6 avss 0.61821f
C841 vbn_sink.n7 avss 0.61601f
C842 vbn_sink.t18 avss 1.89855f
C843 vbn_sink.t16 avss 1.89787f
C844 vbn_sink.t6 avss 2.92844f
C845 vbn_sink.t13 avss 2.89307f
C846 vbn_sink.t14 avss 2.89067f
C847 vbn_sink.t9 avss 2.89307f
C848 vbn_sink.t10 avss 2.89067f
C849 vbn_sink.t5 avss 2.88979f
C850 vbn_sink.t20 avss 2.94389f
C851 vbn_sink.t7 avss 2.8872f
C852 vbn_sink.n8 avss 0.27948f
C853 vbn_sink.t8 avss 2.88962f
C854 vbn_sink.n9 avss 0.19513f
C855 vbn_sink.t4 avss 2.8872f
C856 vbn_sink.n10 avss 0.19065f
C857 vbn_sink.n11 avss 0.26446f
C858 vbn_sink.t19 avss 2.88602f
C859 vbn_sink.n12 avss 0.16674f
C860 vbn_sink.t1 avss 2.94395f
C861 vbn_sink.t2 avss 2.89161f
C862 vbn_sink.n13 avss 0.27771f
C863 vbn_sink.t3 avss 2.88921f
C864 vbn_sink.n14 avss 0.19415f
C865 vbn_sink.t11 avss 2.89161f
C866 vbn_sink.n15 avss 0.19581f
C867 vbn_sink.t12 avss 2.88921f
C868 vbn_sink.n16 avss 0.19133f
C869 vbn_sink.n17 avss 0.25835f
C870 vbn_sink.t0 avss 2.69821f
C871 vbn_sink.n18 avss 0.19827f
C872 vbn_sink.n19 avss 0.25028f
C873 vbn_sink.n20 avss 0.19655f
C874 vbn_sink.n21 avss 0.19477f
C875 vbn_sink.n22 avss 0.1938f
C876 vbn_sink.n23 avss 1.48938f
C877 vbn_sink.n24 avss 1.70695f
C878 vbn_sink.n25 avss 0.17911f
C879 vbn_sink.n26 avss 0.38594f
C880 vbn_sink.n27 avss 1.39969f
C881 vbn_sink.n28 avss 1.84122f
C882 vbn_sink.n29 avss 0.22973f
C883 vbn_sink.n30 avss 0.24086f
C884 vbp_bias.t5 avss 3.25348f
C885 vbp_bias.t6 avss 3.29127f
C886 vbp_bias.t7 avss 3.2876f
C887 vbp_bias.t8 avss 3.29127f
C888 vbp_bias.t9 avss 3.39055f
C889 vbp_bias.n0 avss 0.4165f
C890 vbp_bias.n1 avss 0.29269f
C891 vbp_bias.n2 avss 0.25282f
C892 vbp_bias.t1 avss 3.24754f
C893 vbp_bias.t3 avss 3.32177f
C894 vbp_bias.t2 avss 3.25878f
C895 vbp_bias.n3 avss 0.42472f
C896 vbp_bias.t0 avss 3.27366f
C897 vbp_bias.t17 avss 4.25212f
C898 vbp_bias.n4 avss 1.96188f
C899 vbp_bias.t27 avss 4.28131f
C900 vbp_bias.n5 avss 1.16699f
C901 vbp_bias.t25 avss 4.28014f
C902 vbp_bias.n6 avss 0.1547f
C903 vbp_bias.n7 avss 1.11254f
C904 vbp_bias.t23 avss 4.28905f
C905 vbp_bias.n8 avss 0.25487f
C906 vbp_bias.t21 avss 4.23677f
C907 vbp_bias.n9 avss 0.20483f
C908 vbp_bias.n10 avss 0.23224f
C909 vbp_bias.t19 avss 4.23464f
C910 vbp_bias.n11 avss 0.15397f
C911 vbp_bias.t11 avss 4.28475f
C912 vbp_bias.n12 avss 1.96172f
C913 vbp_bias.t15 avss 4.28184f
C914 vbp_bias.n13 avss 1.16681f
C915 vbp_bias.t13 avss 4.23263f
C916 vbp_bias.n14 avss 0.15329f
C917 vbp_bias.n15 avss 0.22793f
C918 vbp_bias.n16 avss 0.2445f
C919 vbp_bias.n17 avss 1.11319f
C920 vbp_bias.n18 avss 1.04256f
C921 vbp_bias.n19 avss 0.22793f
C922 vbp_bias.n20 avss 0.47225f
C923 vbp_bias.n21 avss 0.40534f
C924 vbp_bias.n22 avss 0.18073f
C925 vbp_bias.n23 avss 0.28836f
C926 vbp_bias.n24 avss 0.31836f
C927 vbp_bias.n25 avss 0.27838f
C928 vbp_bias.t4 avss 3.24496f
C929 vbp_tail.n0 avss 2.80711f
C930 vbp_tail.n1 avss 1.49304f
C931 vbp_tail.n2 avss 1.49365f
C932 vbp_tail.n3 avss 1.5001f
C933 vbp_tail.n4 avss 1.63178f
C934 vbp_tail.n5 avss 0.64887f
C935 vbp_tail.t6 avss 6.0926f
C936 vbp_tail.t1 avss 2.39397f
C937 vbp_tail.n6 avss 0.84116f
C938 vbp_tail.n7 avss 0.13224f
C939 vbp_tail.t3 avss 2.38447f
C940 vbp_tail.n8 avss 0.16796f
C941 vbp_tail.t5 avss 2.39339f
C942 vbp_tail.n9 avss 0.20043f
C943 vbp_tail.n10 avss 3.39323f
C944 vbp_tail.n11 avss 3.13914f
C945 su_state.t0 avss 4.93601f
C946 su_state.t1 avss 11.19009f
C947 su_state.n0 avss 21.6001f
C948 su_state.t2 avss 0.34198f
C949 vx1.t7 avss 2.13719f
C950 vx1.t6 avss 3.40347f
C951 vx1.n0 avss 3.19988f
C952 vx1.t8 avss 2.13644f
C953 vx1.n1 avss 1.81333f
C954 vx1.t9 avss 2.16672f
C955 vx1.n2 avss 2.61103f
C956 vx1.t1 avss 3.79264f
C957 vx1.t0 avss 3.78888f
C958 vx1.n3 avss 1.18299f
C959 vx1.t3 avss 4.0629f
C960 vx1.t2 avss 4.0393f
C961 vx1.n4 avss 2.37083f
C962 vx1.n5 avss 2.18523f
C963 vx1.t5 avss 3.90159f
C964 vx1.t4 avss 3.89387f
C965 vx1.n6 avss 1.55394f
C966 vx1.n7 avss 6.62194f
C967 vx1.n8 avss 6.1341f
C968 vx1.t10 avss 2.07425f
C969 vgn1.t4 avss 1.49564f
C970 vgn1.t6 avss 2.0506f
C971 vgn1.n0 avss 2.62594f
C972 vgn1.t7 avss 1.49494f
C973 vgn1.n1 avss 1.19313f
C974 vgn1.t8 avss 1.49423f
C975 vgn1.n2 avss 0.91383f
C976 vgn1.t1 avss 4.97531f
C977 vgn1.t9 avss 18.56095f
C978 vgn1.t3 avss 5.0121f
C979 vgn1.n3 avss 14.3903f
C980 vgn1.n4 avss 0.65842f
C981 vgn1.n5 avss 1.58101f
C982 vgn1.n6 avss 5.88988f
C983 vgn1.n7 avss 6.0545f
C984 vgn1.t5 avss 1.43986f
C985 vx2.t8 avss 1.87948f
C986 vx2.t7 avss 2.18076f
C987 vx2.t6 avss 2.90138f
C988 vx2.n0 avss 3.87815f
C989 vx2.n1 avss 2.28589f
C990 vx2.t9 avss 1.8788f
C991 vx2.n2 avss 2.21513f
C992 vx2.t1 avss 3.67442f
C993 vx2.t0 avss 3.64609f
C994 vx2.n3 avss 1.89961f
C995 vx2.t3 avss 3.57099f
C996 vx2.t2 avss 3.51708f
C997 vx2.n4 avss 0.62859f
C998 vx2.n5 avss 1.97546f
C999 vx2.t5 avss 3.71456f
C1000 vx2.t4 avss 3.67786f
C1001 vx2.n6 avss 2.00574f
C1002 vx2.n7 avss 5.07747f
C1003 vx2.n8 avss 5.87978f
C1004 vx2.t10 avss 1.83394f
C1005 psrg_m3_feed.t5 avss 1.25755f
C1006 psrg_m3_feed.t7 avss 7.61502f
C1007 psrg_m3_feed.n0 avss 11.5027f
C1008 psrg_m3_feed.n1 avss 12.5007f
C1009 psrg_m3_feed.n2 avss 1.04053f
C1010 psrg_m3_feed.n3 avss 0.97204f
C1011 psrg_m3_feed.n4 avss 1.09434f
C1012 psrg_m3_feed.n5 avss 1.15205f
C1013 psrg_m3_feed.n6 avss 1.41103f
C1014 psrg_m3_feed.n7 avss 1.9095f
C1015 psrg_m3_feed.n8 avss 0.96445f
C1016 psrg_m3_feed.n9 avss 1.08601f
C1017 psrg_m3_feed.n10 avss 1.14446f
C1018 psrg_m3_feed.n11 avss 0.9117f
C1019 psrg_m3_feed.t0 avss 4.04724f
C1020 psrg_m3_feed.t1 avss 4.22405f
C1021 psrg_m3_feed.n12 avss 0.93275f
C1022 psrg_m3_feed.n13 avss 1.61185f
C1023 psrg_m3_feed.n14 avss 1.03736f
C1024 psrg_m3_feed.n15 avss 1.03736f
C1025 psrg_m3_feed.n16 avss 1.03736f
C1026 psrg_m3_feed.n17 avss 1.03736f
C1027 psrg_m3_feed.n18 avss 1.23874f
C1028 psrg_m3_feed.t3 avss 1.19789f
C1029 psrg_m3_feed.t4 avss 1.66663f
C1030 psrg_m3_feed.n19 avss 2.09407f
C1031 psrg_m3_feed.n20 avss 2.36697f
C1032 psrg_m3_feed.n21 avss 2.22922f
C1033 psrg_m3_feed.n22 avss 1.69571f
C1034 psrg_m3_feed.n23 avss 1.75623f
C1035 psrg_m3_feed.t6 avss 1.19664f
C1036 psrg_m3_feed.n24 avss 1.15487f
C1037 psrg_m3_feed.t2 avss 1.16221f
C1038 vx3.t3 avss 3.84592f
C1039 vx3.t2 avss 3.86591f
C1040 vx3.n0 avss 2.71209f
C1041 vx3.t9 avss 3.71054f
C1042 vx3.t0 avss 3.72528f
C1043 vx3.n1 avss 1.40575f
C1044 vx3.n2 avss 2.03376f
C1045 vx3.t1 avss 3.70921f
C1046 vx3.t10 avss 3.67779f
C1047 vx3.n3 avss 0.72208f
C1048 vx3.n4 avss 4.52855f
C1049 vx3.t4 avss 3.93617f
C1050 vx3.t5 avss 17.29673f
C1051 vx3.n5 avss 2.64102f
C1052 vx3.t6 avss 2.00185f
C1053 vx3.n6 avss 1.70704f
C1054 vx3.t7 avss 2.03022f
C1055 vx3.n7 avss 3.06277f
C1056 vx3.t8 avss 1.94357f
C1057 vaux.t2 avss 5.48531f
C1058 vaux.t0 avss 2.09654f
C1059 vaux.n0 avss 7.41041f
C1060 vaux.t1 avss 2.06087f
C1061 v2.n0 avss 0.43607f
C1062 v2.n1 avss 10.6358f
C1063 v2.n2 avss 1.96233f
C1064 v2.n3 avss 1.96596f
C1065 v2.n4 avss 2.22958f
C1066 v2.n5 avss 3.3131f
C1067 v2.t0 avss 0.12901f
C1068 v2.n6 avss 1.59053f
C1069 v2.n7 avss 0.46664f
C1070 v2.n8 avss 13.9042f
C1071 v2.n9 avss 4.45372f
C1072 v2.t2 avss 0.57726f
C1073 v2.n10 avss 0.72798f
C1074 v2.n11 avss 0.40826f
C1075 v2.t1 avss 0.54215f
C1076 vsp.t8 avss 9.88472f
C1077 vsp.t14 avss 9.98496f
C1078 vsp.t9 avss 9.88416f
C1079 vsp.t10 avss 9.87749f
C1080 vsp.t1 avss 10.04752f
C1081 vsp.t2 avss 10.05424f
C1082 vsp.t11 avss 9.87749f
C1083 vsp.t4 avss 6.99786f
C1084 vsp.t13 avss 7.37273f
C1085 vsp.t5 avss 7.24458f
C1086 vsp.n0 avss 1.33645f
C1087 vsp.t6 avss 7.25576f
C1088 vsp.n1 avss 0.89731f
C1089 vsp.t15 avss 7.25662f
C1090 vsp.n2 avss 0.89747f
C1091 vsp.t3 avss 7.24471f
C1092 vsp.n3 avss 0.90839f
C1093 vsp.n4 avss 5.13924f
C1094 vsp.t0 avss 10.04752f
C1095 vsp.n5 avss 5.01077f
C1096 vsp.t12 avss 9.90653f
C1097 vsp.n6 avss 0.78674f
C1098 vsp.n7 avss 0.78203f
C1099 vsp.n8 avss 0.78674f
C1100 vsp.n9 avss 3.18801f
C1101 vsp.n10 avss 3.13751f
C1102 vsp.n11 avss 0.78674f
C1103 vsp.n12 avss 0.78203f
C1104 vsp.n13 avss 1.12116f
C1105 vsp.t7 avss 9.89214f
C1106 vgn2.t1 avss 3.13194f
C1107 vgn2.t4 avss 3.12514f
C1108 vgn2.t5 avss 3.12317f
C1109 vgn2.t2 avss 3.12639f
C1110 vgn2.t3 avss 3.12623f
C1111 vgn2.n0 avss 0.12594f
C1112 vgn2.t0 avss 5.54006f
C1113 vgn2.n1 avss 0.43801f
C1114 vgn2.n2 avss 0.38687f
C1115 vgn2.t6 avss 3.16834f
C1116 vgn2.n3 avss 0.21896f
C1117 vgn2.n4 avss 0.14552f
C1118 vgn2.n7 avss 0.90207f
C1119 vgn2.n8 avss 0.90742f
C1120 xf2.t9 avss 8.60707f
C1121 xf2.t2 avss 8.74315f
C1122 xf2.t0 avss 9.26887f
C1123 xf2.t3 avss 4.19398f
C1124 xf2.t11 avss 3.68684f
C1125 xf2.t5 avss 3.68427f
C1126 xf2.t4 avss 3.7599f
C1127 xf2.n0 avss 1.48512f
C1128 xf2.t7 avss 4.00411f
C1129 xf2.n1 avss 2.19404f
C1130 xf2.t10 avss 3.66097f
C1131 xf2.n2 avss 0.59332f
C1132 xf2.n3 avss 1.36725f
C1133 xf2.n4 avss 5.33677f
C1134 xf2.n5 avss 11.8573f
C1135 xf2.t1 avss 8.71877f
C1136 xf2.n6 avss 5.18609f
C1137 xf2.t6 avss 8.72328f
C1138 xf2.n7 avss 0.94189f
C1139 xf2.n8 avss 2.50915f
C1140 xf2.n9 avss 3.95159f
C1141 xf2.t8 avss 8.60591f
C1142 xf1.t10 avss 8.66453f
C1143 xf1.t0 avss 8.64153f
C1144 xf1.t2 avss 3.71928f
C1145 xf1.t1 avss 3.79652f
C1146 xf1.n0 avss 1.51728f
C1147 xf1.t3 avss 4.11477f
C1148 xf1.t4 avss 3.71806f
C1149 xf1.n1 avss 2.1468f
C1150 xf1.t5 avss 3.72115f
C1151 xf1.n2 avss 1.59279f
C1152 xf1.n3 avss 1.37068f
C1153 xf1.t11 avss 3.53532f
C1154 xf1.n4 avss 4.53579f
C1155 xf1.n5 avss 11.8476f
C1156 xf1.t9 avss 8.63649f
C1157 xf1.n6 avss 5.02211f
C1158 xf1.t8 avss 8.68944f
C1159 xf1.n7 avss 2.91345f
C1160 xf1.n8 avss 3.36669f
C1161 xf1.t7 avss 8.6951f
C1162 xf1.n9 avss 1.52244f
C1163 xf1.t6 avss 8.61467f
C1164 vbp_cas.n0 avss 1.76086f
C1165 vbp_cas.n1 avss 1.07882f
C1166 vbp_cas.n2 avss 1.01982f
C1167 vbp_cas.n3 avss 0.97816f
C1168 vbp_cas.n4 avss 1.75281f
C1169 vbp_cas.n5 avss 0.966f
C1170 vbp_cas.n6 avss 0.9637f
C1171 vbp_cas.n7 avss 0.966f
C1172 vbp_cas.n8 avss 1.16825f
C1173 vbp_cas.t13 avss 3.11919f
C1174 vbp_cas.t11 avss 3.11652f
C1175 vbp_cas.t15 avss 3.11919f
C1176 vbp_cas.t5 avss 3.08403f
C1177 vbp_cas.t3 avss 3.14515f
C1178 vbp_cas.t7 avss 3.08384f
C1179 vbp_cas.n9 avss 0.24541f
C1180 vbp_cas.n10 avss 1.43592f
C1181 vbp_cas.n11 avss 0.17059f
C1182 vbp_cas.t9 avss 3.08651f
C1183 vbp_cas.n12 avss 0.12067f
C1184 vbp_cas.t20 avss 0.76668f
C1185 vbp_cas.n13 avss 1.22346f
C1186 vbp_cas.n14 avss 0.79713f
C1187 vbp_cas.n15 avss 0.1738f
C1188 vbp_cas.n16 avss 0.1801f
C1189 vbp_cas.n17 avss 0.80798f
C1190 vbp_cas.n18 avss 0.76243f
C1191 vbp_cas.t17 avss 3.10416f
C1192 vbp_cas.n19 avss 0.24975f
C1193 vbp_cas.t19 avss 3.08508f
C1194 vbp_cas.n20 avss 0.12116f
C1195 vbp_cas.n21 avss 0.81306f
C1196 vbp_cas.t1 avss 3.11652f
C1197 vbp_cas.n22 avss 0.11331f
C1198 vbp_cas.n23 avss 0.81941f
C1199 vbp_cas.n24 avss 0.12116f
C1200 vbp_cas.n25 avss 0.81306f
C1201 vbp_cas.n26 avss 0.11331f
C1202 vbp_cas.n27 avss 0.81941f
C1203 vbp_cas.n28 avss 2.02041f
C1204 vbp_cas.n29 avss 2.42792f
C1205 psrg_vnc.t2 avss 2.56585f
C1206 psrg_vnc.t3 avss 2.53221f
C1207 psrg_vnc.n0 avss 0.75533f
C1208 psrg_vnc.t4 avss 2.52744f
C1209 psrg_vnc.n1 avss 0.50672f
C1210 psrg_vnc.t5 avss 2.53221f
C1211 psrg_vnc.n2 avss 0.51068f
C1212 psrg_vnc.t6 avss 2.52744f
C1213 psrg_vnc.n3 avss 0.49654f
C1214 psrg_vnc.t0 avss 2.51367f
C1215 psrg_vnc.n4 avss 11.82f
C1216 psrg_vnc.n5 avss 0.73221f
C1217 psrg_vnc.t1 avss 2.51642f
C1218 psrg_vnc.n6 avss 0.84942f
C1219 psrg_vnc.t8 avss 2.11603f
C1220 psrg_vnc.n7 avss 0.88057f
C1221 psrg_vnc.n8 avss 2.69224f
C1222 psrg_vnc.n9 avss 4.20426f
C1223 psrg_m3_protected.t2 avss 4.07418f
C1224 psrg_m3_protected.t3 avss 4.02111f
C1225 psrg_m3_protected.n0 avss 1.50856f
C1226 psrg_m3_protected.t0 avss 1.6212f
C1227 psrg_m3_protected.n1 avss 1.73564f
C1228 psrg_m3_protected.t1 avss 1.11608f
C1229 vbn.t3 avss 10.2555f
C1230 vbn.n0 avss 16.1518f
C1231 vbn.t2 avss 2.08733f
C1232 vbn.n1 avss 2.5023f
C1233 vbn.n2 avss 0.70766f
C1234 vbn.t1 avss 2.97456f
C1235 iref_gate.t2 avss 9.23896f
C1236 iref_gate.n0 avss 18.8699f
C1237 iref_gate.t1 avss 2.18219f
C1238 iref_gate.n1 avss 2.38976f
C1239 iref_gate.t0 avss 9.16427f
C1240 pm2.t1 avss 5.59119f
C1241 pm2.t2 avss 6.12538f
C1242 pm2.n0 avss 2.66936f
C1243 pm2.t0 avss 5.5935f
C1244 pm2.n1 avss 2.18723f
C1245 pm2.t9 avss 5.6527f
C1246 pm2.t3 avss 4.66953f
C1247 pm2.t5 avss 4.72582f
C1248 pm2.t4 avss 4.67586f
C1249 pm2.n2 avss 1.75963f
C1250 pm2.n3 avss 2.05477f
C1251 pm2.t6 avss 4.6898f
C1252 pm2.t7 avss 4.68259f
C1253 pm2.t8 avss 5.00263f
C1254 pm2.n4 avss 2.01305f
C1255 pm2.n5 avss 1.45519f
C1256 pm2.n6 avss 6.67221f
C1257 pm2.n7 avss 5.70787f
C1258 pm2.n8 avss 1.72316f
C1259 pm2.t10 avss 5.58499f
C1260 pm2.n9 avss 1.56459f
C1261 pm2.t11 avss 5.53224f
C1262 pm1.t10 avss 5.80368f
C1263 pm1.t11 avss 5.56082f
C1264 pm1.n0 avss 1.55182f
C1265 pm1.t1 avss 5.64122f
C1266 pm1.t4 avss 4.73751f
C1267 pm1.t5 avss 4.72982f
C1268 pm1.t6 avss 4.91493f
C1269 pm1.t8 avss 4.75273f
C1270 pm1.t9 avss 4.79871f
C1271 pm1.t7 avss 4.97008f
C1272 pm1.n1 avss 3.51396f
C1273 pm1.n2 avss 2.14076f
C1274 pm1.n3 avss 0.7344f
C1275 pm1.n4 avss 5.39201f
C1276 pm1.n5 avss 6.34022f
C1277 pm1.t2 avss 5.65894f
C1278 pm1.n6 avss 2.35103f
C1279 pm1.t3 avss 5.68595f
C1280 pm1.n7 avss 2.14232f
C1281 pm1.n8 avss 2.62689f
C1282 pm1.t0 avss 5.36817f
C1283 y1.t3 avss 3.93177f
C1284 y1.n0 avss 1.93779f
C1285 y1.n1 avss 1.04636f
C1286 y1.n2 avss 1.04028f
C1287 y1.n3 avss 1.04636f
C1288 y1.t4 avss 11.84726f
C1289 y1.n4 avss 2.13394f
C1290 y1.n5 avss 0.43087f
C1291 y1.n6 avss 1.93057f
C1292 y1.n7 avss 1.04236f
C1293 y1.n8 avss 1.0369f
C1294 y1.n9 avss 1.04236f
C1295 y1.n10 avss 0.93988f
C1296 y1.n11 avss 1.72919f
C1297 y1.t1 avss 3.97464f
C1298 y1.n12 avss 1.91022f
C1299 y1.t2 avss 3.93158f
C1300 y1.n13 avss 0.65271f
C1301 y1.n14 avss 0.53393f
C1302 y1.t6 avss 3.83054f
C1303 y1.t5 avss 4.02896f
C1304 y1.n15 avss 0.60302f
C1305 y1.n16 avss 0.92367f
C1306 y1.t0 avss 3.67217f
C1307 psrg_mf1_protected.t1 avss 11.85403f
C1308 psrg_mf1_protected.t0 avss 5.81064f
C1309 dvdd.n0 avss 0.2915f
C1310 dvdd.n1 avss 2.73374f
C1311 dvdd.n2 avss 0.28061f
C1312 dvdd.t5 avss 0.73618f
C1313 dvdd.n3 avss 1.41232f
C1314 dvdd.n4 avss 1.37733f
C1315 dvdd.t16 avss 1.73089f
C1316 dvdd.n5 avss 2.34674f
C1317 dvdd.t25 avss 0.23477f
C1318 dvdd.t10 avss 0.44171f
C1319 dvdd.t11 avss 0.20905f
C1320 dvdd.n6 avss 0.16106f
C1321 dvdd.n7 avss 0.97261f
C1322 dvdd.t17 avss 0.38942f
C1323 dvdd.n8 avss 1.0321f
C1324 dvdd.n9 avss 0.1563f
C1325 dvdd.t24 avss 0.37023f
C1326 dvdd.n10 avss 0.9191f
C1327 dvdd.t27 avss 0.25058f
C1328 dvdd.t26 avss 0.44446f
C1329 dvdd.n11 avss 0.90531f
C1330 dvdd.t29 avss 0.25647f
C1331 dvdd.t28 avss 0.44295f
C1332 dvdd.t2 avss 3.60796f
C1333 dvdd.n12 avss 2.32521f
C1334 dvdd.t1 avss 0.26448f
C1335 dvdd.t0 avss 0.40748f
C1336 dvdd.n13 avss 0.8941f
C1337 dvdd.n14 avss 0.10099f
C1338 dvdd.t6 avss 0.44162f
C1339 dvdd.t8 avss 0.44244f
C1340 dvdd.t19 avss 5.14682f
C1341 dvdd.t22 avss 5.07936f
C1342 dvdd.n15 avss 4.51408f
C1343 dvdd.t3 avss 5.07932f
C1344 dvdd.n16 avss 2.30794f
C1345 dvdd.t18 avss 5.0828f
C1346 dvdd.n17 avss 2.28868f
C1347 dvdd.t14 avss 5.15705f
C1348 dvdd.t13 avss 5.08365f
C1349 dvdd.n18 avss 4.5046f
C1350 dvdd.t12 avss 5.07931f
C1351 dvdd.n19 avss 2.314f
C1352 dvdd.t21 avss 5.08407f
C1353 dvdd.n20 avss 2.32032f
C1354 dvdd.t15 avss 5.07938f
C1355 dvdd.n21 avss 2.28066f
C1356 dvdd.n22 avss 1.39465f
C1357 dvdd.n23 avss 2.33085f
C1358 dvdd.t4 avss 1.63073f
C1359 dvdd.n24 avss 1.94575f
C1360 dvdd.n25 avss 0.84987f
C1361 dvdd.t9 avss 0.24545f
C1362 dvdd.t7 avss 0.23343f
C1363 dvdd.n28 avss 0.10513f
C1364 dvdd.n29 avss 0.93488f
C1365 dvdd.n30 avss 1.68228f
C1366 dvdd.n31 avss 0.68248f
C1367 dvdd.n32 avss 0.87261f
C1368 dvdd.n33 avss 0.12421f
C1369 dvdd.n34 avss 0.17757f
C1370 dvdd.n35 avss 1.85806f
C1371 dvdd.n36 avss 1.83721f
C1372 dvdd.t20 avss 2.24739f
C1373 dvdd.n37 avss 1.82884f
C1374 dvdd.t23 avss 2.24576f
C1375 dvdd.n38 avss 1.78695f
C1376 dvdd.n39 avss 0.329f
C1377 dvdd.n40 avss 2.6342f
C1378 avdd.n0 avss 2.49483f
C1379 avdd.n1 avss 1.00618f
C1380 avdd.n2 avss 0.57007f
C1381 avdd.n4 avss 1.70374f
C1382 avdd.n5 avss 0.58002f
C1383 avdd.n6 avss 0.58002f
C1384 avdd.n7 avss 0.88437f
C1385 avdd.n8 avss 0.8719f
C1386 avdd.n9 avss 1.84246f
C1387 avdd.n10 avss 1.09746f
C1388 avdd.n12 avss 0.69204f
C1389 avdd.n13 avss 0.68605f
C1390 avdd.n14 avss 0.68605f
C1391 avdd.n15 avss 0.68605f
C1392 avdd.n16 avss 1.28115f
C1393 avdd.n17 avss 1.20193f
C1394 avdd.n18 avss 1.21639f
C1395 avdd.n19 avss 2.2411f
C1396 avdd.n20 avss 2.25866f
C1397 avdd.n21 avss 2.25873f
C1398 avdd.n22 avss 1.65937f
C1399 avdd.n23 avss 1.65903f
C1400 avdd.n25 avss 0.13605f
C1401 avdd.n26 avss 0.70554f
C1402 avdd.n28 avss 1.7771f
C1403 avdd.n29 avss 0.60683f
C1404 avdd.n30 avss 0.3601f
C1405 avdd.n31 avss 0.60683f
C1406 avdd.n32 avss 0.3601f
C1407 avdd.n33 avss 0.60683f
C1408 avdd.n34 avss 0.3601f
C1409 avdd.n35 avss 0.60683f
C1410 avdd.n36 avss 0.3601f
C1411 avdd.n37 avss 0.60683f
C1412 avdd.n38 avss 0.3601f
C1413 avdd.n39 avss 0.60683f
C1414 avdd.n40 avss 0.27815f
C1415 avdd.n41 avss 0.60683f
C1416 avdd.n42 avss 0.4022f
C1417 avdd.n43 avss 0.60683f
C1418 avdd.n44 avss 0.27811f
C1419 avdd.n45 avss 0.60683f
C1420 avdd.n46 avss 0.35981f
C1421 avdd.n47 avss 0.60683f
C1422 avdd.n48 avss 0.27835f
C1423 avdd.n49 avss 0.60683f
C1424 avdd.n50 avss 0.27811f
C1425 avdd.n51 avss 0.60683f
C1426 avdd.n52 avss 0.35981f
C1427 avdd.n53 avss 0.60683f
C1428 avdd.n54 avss 0.35981f
C1429 avdd.n55 avss 0.60683f
C1430 avdd.n56 avss 0.35981f
C1431 avdd.n57 avss 0.60683f
C1432 avdd.n58 avss 0.27764f
C1433 avdd.n59 avss 0.60683f
C1434 avdd.n60 avss 0.40264f
C1435 avdd.n61 avss 0.60683f
C1436 avdd.n62 avss 0.27763f
C1437 avdd.n63 avss 0.60683f
C1438 avdd.n64 avss 0.37408f
C1439 avdd.n65 avss 0.60683f
C1440 avdd.n66 avss 0.37384f
C1441 avdd.n67 avss 0.60683f
C1442 avdd.n68 avss 0.27763f
C1443 avdd.n69 avss 0.60683f
C1444 avdd.n70 avss 0.27815f
C1445 avdd.n71 avss 0.60683f
C1446 avdd.n72 avss 0.27815f
C1447 avdd.n73 avss 1.52575f
C1448 avdd.t525 avss 0.45963f
C1449 avdd.t526 avss 0.45963f
C1450 avdd.n74 avss 2.41466f
C1451 avdd.n75 avss 1.52575f
C1452 avdd.t521 avss 0.45963f
C1453 avdd.t522 avss 0.45963f
C1454 avdd.n76 avss 2.41466f
C1455 avdd.n77 avss 1.52575f
C1456 avdd.t517 avss 0.45963f
C1457 avdd.t518 avss 0.45963f
C1458 avdd.n78 avss 2.41466f
C1459 avdd.n79 avss 1.52575f
C1460 avdd.t513 avss 0.45963f
C1461 avdd.t514 avss 0.45963f
C1462 avdd.n80 avss 2.41466f
C1463 avdd.n81 avss 1.52575f
C1464 avdd.t509 avss 0.45963f
C1465 avdd.t510 avss 0.45963f
C1466 avdd.n82 avss 2.41466f
C1467 avdd.n83 avss 1.52575f
C1468 avdd.t505 avss 0.45963f
C1469 avdd.t506 avss 0.45963f
C1470 avdd.n84 avss 2.41466f
C1471 avdd.n85 avss 1.52575f
C1472 avdd.t501 avss 0.45963f
C1473 avdd.t502 avss 0.45963f
C1474 avdd.n86 avss 2.41466f
C1475 avdd.n87 avss 1.52575f
C1476 avdd.t497 avss 0.45963f
C1477 avdd.t498 avss 0.45963f
C1478 avdd.n88 avss 2.41466f
C1479 avdd.n89 avss 1.52575f
C1480 avdd.t493 avss 0.45963f
C1481 avdd.t494 avss 0.45963f
C1482 avdd.n90 avss 2.41466f
C1483 avdd.n91 avss 1.52575f
C1484 avdd.t489 avss 0.45963f
C1485 avdd.t490 avss 0.45963f
C1486 avdd.n92 avss 2.41466f
C1487 avdd.n93 avss 1.52575f
C1488 avdd.t485 avss 0.45963f
C1489 avdd.t486 avss 0.45963f
C1490 avdd.n94 avss 2.41466f
C1491 avdd.n95 avss 1.52575f
C1492 avdd.t481 avss 0.45963f
C1493 avdd.t482 avss 0.45963f
C1494 avdd.n96 avss 2.41466f
C1495 avdd.n97 avss 1.52575f
C1496 avdd.t477 avss 0.45963f
C1497 avdd.t478 avss 0.45963f
C1498 avdd.n98 avss 2.41466f
C1499 avdd.n99 avss 1.00175f
C1500 avdd.n100 avss 0.78942f
C1501 avdd.n101 avss 1.00175f
C1502 avdd.n102 avss 0.59796f
C1503 avdd.n103 avss 1.00175f
C1504 avdd.n104 avss 0.59796f
C1505 avdd.n105 avss 1.00175f
C1506 avdd.n106 avss 0.59796f
C1507 avdd.n107 avss 1.00175f
C1508 avdd.n108 avss 0.59796f
C1509 avdd.n109 avss 1.00175f
C1510 avdd.n110 avss 0.59796f
C1511 avdd.n111 avss 1.00175f
C1512 avdd.n112 avss 0.59796f
C1513 avdd.n113 avss 1.00175f
C1514 avdd.n114 avss 0.59796f
C1515 avdd.n115 avss 1.00175f
C1516 avdd.n116 avss 0.79559f
C1517 avdd.n117 avss 1.00175f
C1518 avdd.n118 avss 0.78942f
C1519 avdd.n119 avss 1.00175f
C1520 avdd.n120 avss 0.59796f
C1521 avdd.n121 avss 1.00175f
C1522 avdd.n122 avss 0.59796f
C1523 avdd.n123 avss 1.00175f
C1524 avdd.n124 avss 0.78942f
C1525 avdd.n125 avss 1.00175f
C1526 avdd.n126 avss 0.59796f
C1527 avdd.n127 avss 1.00175f
C1528 avdd.n128 avss 0.59796f
C1529 avdd.n129 avss 1.00175f
C1530 avdd.n130 avss 0.59796f
C1531 avdd.n131 avss 1.00175f
C1532 avdd.n132 avss 0.59796f
C1533 avdd.n133 avss 1.00175f
C1534 avdd.n134 avss 0.80326f
C1535 avdd.n135 avss 1.00175f
C1536 avdd.n136 avss 0.80486f
C1537 avdd.n137 avss 1.00175f
C1538 avdd.n138 avss 0.59796f
C1539 avdd.t705 avss 3.32959f
C1540 avdd.n139 avss 1.52575f
C1541 avdd.t661 avss 0.45963f
C1542 avdd.t662 avss 0.45963f
C1543 avdd.n140 avss 2.41466f
C1544 avdd.n141 avss 2.62695f
C1545 avdd.t665 avss 0.45963f
C1546 avdd.t666 avss 0.45963f
C1547 avdd.n142 avss 2.41466f
C1548 avdd.n143 avss 1.52575f
C1549 avdd.t669 avss 0.45963f
C1550 avdd.t670 avss 0.45963f
C1551 avdd.n144 avss 2.41466f
C1552 avdd.n145 avss 1.52575f
C1553 avdd.t752 avss 0.45963f
C1554 avdd.t753 avss 0.45963f
C1555 avdd.n146 avss 2.41466f
C1556 avdd.n147 avss 1.52575f
C1557 avdd.t748 avss 0.45963f
C1558 avdd.t749 avss 0.45963f
C1559 avdd.n148 avss 2.41466f
C1560 avdd.n149 avss 1.52575f
C1561 avdd.t744 avss 0.45963f
C1562 avdd.t745 avss 0.45963f
C1563 avdd.n150 avss 2.41466f
C1564 avdd.n151 avss 1.52575f
C1565 avdd.t740 avss 0.45963f
C1566 avdd.t741 avss 0.45963f
C1567 avdd.n152 avss 2.41466f
C1568 avdd.n153 avss 1.52575f
C1569 avdd.t736 avss 0.45963f
C1570 avdd.t737 avss 0.45963f
C1571 avdd.n154 avss 2.41466f
C1572 avdd.n155 avss 1.52575f
C1573 avdd.t732 avss 0.45963f
C1574 avdd.t733 avss 0.45963f
C1575 avdd.n156 avss 2.41466f
C1576 avdd.n157 avss 1.52575f
C1577 avdd.t728 avss 0.45963f
C1578 avdd.t729 avss 0.45963f
C1579 avdd.n158 avss 2.41466f
C1580 avdd.n159 avss 1.52575f
C1581 avdd.t724 avss 0.45963f
C1582 avdd.t725 avss 0.45963f
C1583 avdd.n160 avss 2.41466f
C1584 avdd.n161 avss 1.52575f
C1585 avdd.t720 avss 0.45963f
C1586 avdd.t721 avss 0.45963f
C1587 avdd.n162 avss 2.41466f
C1588 avdd.n163 avss 1.52575f
C1589 avdd.t716 avss 0.45963f
C1590 avdd.t717 avss 0.45963f
C1591 avdd.n164 avss 2.41466f
C1592 avdd.n165 avss 1.52575f
C1593 avdd.t712 avss 0.45963f
C1594 avdd.t713 avss 0.45963f
C1595 avdd.n166 avss 2.41466f
C1596 avdd.n167 avss 1.52575f
C1597 avdd.t708 avss 0.45963f
C1598 avdd.t709 avss 0.45963f
C1599 avdd.n168 avss 2.41466f
C1600 avdd.n169 avss 0.82056f
C1601 avdd.n170 avss 0.48169f
C1602 avdd.n171 avss 0.82056f
C1603 avdd.n172 avss 0.48169f
C1604 avdd.n173 avss 0.82056f
C1605 avdd.n174 avss 0.48169f
C1606 avdd.n175 avss 0.82056f
C1607 avdd.n176 avss 0.48169f
C1608 avdd.n177 avss 0.82056f
C1609 avdd.n178 avss 0.48169f
C1610 avdd.n179 avss 0.82056f
C1611 avdd.n180 avss 0.48169f
C1612 avdd.n181 avss 0.82056f
C1613 avdd.n182 avss 0.48169f
C1614 avdd.n183 avss 0.82056f
C1615 avdd.n184 avss 0.48169f
C1616 avdd.n185 avss 0.82056f
C1617 avdd.n186 avss 0.48169f
C1618 avdd.n187 avss 0.82056f
C1619 avdd.n188 avss 0.48213f
C1620 avdd.n189 avss 0.82056f
C1621 avdd.n190 avss 0.48169f
C1622 avdd.n191 avss 0.82056f
C1623 avdd.n192 avss 0.48169f
C1624 avdd.n193 avss 0.82056f
C1625 avdd.n194 avss 0.48169f
C1626 avdd.n195 avss 0.82056f
C1627 avdd.n196 avss 0.48169f
C1628 avdd.n197 avss 0.82056f
C1629 avdd.n198 avss 0.48169f
C1630 avdd.n199 avss 0.82056f
C1631 avdd.n200 avss 0.48169f
C1632 avdd.n201 avss 0.82056f
C1633 avdd.n202 avss 0.48169f
C1634 avdd.n203 avss 0.82056f
C1635 avdd.n204 avss 0.48169f
C1636 avdd.n205 avss 0.82056f
C1637 avdd.n206 avss 0.48169f
C1638 avdd.n207 avss 0.82056f
C1639 avdd.n208 avss 0.82056f
C1640 avdd.n209 avss 0.63356f
C1641 avdd.n210 avss 0.82056f
C1642 avdd.n211 avss 0.48169f
C1643 avdd.n212 avss 0.82056f
C1644 avdd.n213 avss 0.48169f
C1645 avdd.n214 avss 0.82056f
C1646 avdd.n215 avss 0.48169f
C1647 avdd.n216 avss 0.82056f
C1648 avdd.n217 avss 0.48169f
C1649 avdd.n218 avss 0.82056f
C1650 avdd.n219 avss 0.48169f
C1651 avdd.n220 avss 0.82056f
C1652 avdd.n221 avss 0.48459f
C1653 avdd.n222 avss 0.82056f
C1654 avdd.n223 avss 0.48169f
C1655 avdd.n224 avss 0.82056f
C1656 avdd.n225 avss 0.48169f
C1657 avdd.n226 avss 0.82056f
C1658 avdd.n227 avss 0.48442f
C1659 avdd.n228 avss 0.82056f
C1660 avdd.n229 avss 0.48169f
C1661 avdd.n230 avss 0.82056f
C1662 avdd.n231 avss 0.48169f
C1663 avdd.n232 avss 0.82056f
C1664 avdd.n233 avss 0.48169f
C1665 avdd.n234 avss 0.82056f
C1666 avdd.n235 avss 0.48169f
C1667 avdd.n236 avss 0.52832f
C1668 avdd.n237 avss 0.60888f
C1669 avdd.n238 avss 1.71655f
C1670 avdd.n239 avss 1.41794f
C1671 avdd.n240 avss 1.69691f
C1672 avdd.n241 avss 1.41794f
C1673 avdd.n242 avss 1.01748f
C1674 avdd.n243 avss 1.41794f
C1675 avdd.n244 avss 1.01748f
C1676 avdd.n245 avss 1.41794f
C1677 avdd.n246 avss 1.01748f
C1678 avdd.n247 avss 1.41794f
C1679 avdd.n248 avss 1.01748f
C1680 avdd.n249 avss 1.41794f
C1681 avdd.n250 avss 1.5231f
C1682 avdd.n251 avss 1.41794f
C1683 avdd.n252 avss 1.70576f
C1684 avdd.n253 avss 1.41794f
C1685 avdd.n254 avss 1.01748f
C1686 avdd.n255 avss 1.41794f
C1687 avdd.n256 avss 1.01748f
C1688 avdd.n257 avss 1.41794f
C1689 avdd.n258 avss 1.01748f
C1690 avdd.n259 avss 1.41794f
C1691 avdd.n260 avss 1.01748f
C1692 avdd.n261 avss 1.41794f
C1693 avdd.n262 avss 1.01748f
C1694 avdd.n263 avss 1.41794f
C1695 avdd.n264 avss 1.01748f
C1696 avdd.n265 avss 1.41794f
C1697 avdd.n266 avss 1.01748f
C1698 avdd.n267 avss 1.41794f
C1699 avdd.n268 avss 1.70576f
C1700 avdd.n269 avss 1.41794f
C1701 avdd.n270 avss 1.01951f
C1702 avdd.n271 avss 1.41794f
C1703 avdd.n272 avss 1.41794f
C1704 avdd.n273 avss 1.70069f
C1705 avdd.n274 avss 1.41794f
C1706 avdd.n275 avss 1.01748f
C1707 avdd.n276 avss 1.41794f
C1708 avdd.n277 avss 1.01748f
C1709 avdd.n278 avss 1.41794f
C1710 avdd.n279 avss 1.01748f
C1711 avdd.n280 avss 1.41794f
C1712 avdd.n281 avss 1.01748f
C1713 avdd.n282 avss 1.41794f
C1714 avdd.n283 avss 1.01748f
C1715 avdd.n284 avss 1.41794f
C1716 avdd.n285 avss 1.01748f
C1717 avdd.n286 avss 1.41794f
C1718 avdd.n287 avss 1.01748f
C1719 avdd.n288 avss 1.41794f
C1720 avdd.n289 avss 1.01748f
C1721 avdd.n290 avss 1.41794f
C1722 avdd.n291 avss 1.01748f
C1723 avdd.n292 avss 1.41794f
C1724 avdd.n293 avss 1.01748f
C1725 avdd.n294 avss 1.41794f
C1726 avdd.n295 avss 1.43327f
C1727 avdd.n296 avss 1.02962f
C1728 avdd.n297 avss 1.43072f
C1729 avdd.n298 avss 1.54322f
C1730 avdd.n299 avss 1.43072f
C1731 avdd.n300 avss 1.71792f
C1732 avdd.n301 avss 1.43072f
C1733 avdd.n302 avss 1.0276f
C1734 avdd.n303 avss 1.43072f
C1735 avdd.n304 avss 1.72034f
C1736 avdd.n305 avss 1.64085f
C1737 avdd.n306 avss 1.74353f
C1738 avdd.n307 avss 1.64085f
C1739 avdd.n308 avss 1.19267f
C1740 avdd.n309 avss 1.64085f
C1741 avdd.n310 avss 1.19267f
C1742 avdd.n311 avss 1.64085f
C1743 avdd.n312 avss 1.19267f
C1744 avdd.n313 avss 1.64085f
C1745 avdd.n314 avss 1.19267f
C1746 avdd.n315 avss 1.64085f
C1747 avdd.n316 avss 1.19267f
C1748 avdd.n317 avss 1.64085f
C1749 avdd.n318 avss 1.19267f
C1750 avdd.n319 avss 1.64085f
C1751 avdd.n320 avss 1.19837f
C1752 avdd.n321 avss 1.64085f
C1753 avdd.n322 avss 1.19267f
C1754 avdd.n323 avss 1.64085f
C1755 avdd.n324 avss 1.19267f
C1756 avdd.n325 avss 1.64085f
C1757 avdd.n326 avss 1.7735f
C1758 avdd.n327 avss 1.64085f
C1759 avdd.n328 avss 1.19267f
C1760 avdd.n329 avss 1.64085f
C1761 avdd.n330 avss 1.74737f
C1762 avdd.n331 avss 1.64085f
C1763 avdd.n332 avss 1.19267f
C1764 avdd.n333 avss 1.64085f
C1765 avdd.n334 avss 1.19267f
C1766 avdd.n335 avss 1.64085f
C1767 avdd.n336 avss 1.19267f
C1768 avdd.n337 avss 1.64085f
C1769 avdd.n338 avss 1.19267f
C1770 avdd.n339 avss 1.64085f
C1771 avdd.n340 avss 1.19267f
C1772 avdd.n341 avss 1.64085f
C1773 avdd.n342 avss 1.19267f
C1774 avdd.n343 avss 1.64085f
C1775 avdd.n344 avss 1.19267f
C1776 avdd.n345 avss 1.43072f
C1777 avdd.n346 avss 1.70999f
C1778 avdd.n347 avss 1.43072f
C1779 avdd.n348 avss 1.0276f
C1780 avdd.n349 avss 1.43072f
C1781 avdd.n350 avss 1.0276f
C1782 avdd.n351 avss 1.43072f
C1783 avdd.n352 avss 1.0276f
C1784 avdd.n353 avss 1.43072f
C1785 avdd.n354 avss 1.0276f
C1786 avdd.n355 avss 1.43072f
C1787 avdd.n356 avss 1.0276f
C1788 avdd.n357 avss 1.43072f
C1789 avdd.n358 avss 1.0276f
C1790 avdd.n359 avss 1.43072f
C1791 avdd.n360 avss 1.0276f
C1792 avdd.n361 avss 1.43072f
C1793 avdd.n362 avss 1.03244f
C1794 avdd.n363 avss 1.43072f
C1795 avdd.n364 avss 1.72237f
C1796 avdd.n365 avss 1.43072f
C1797 avdd.n366 avss 1.72237f
C1798 avdd.n367 avss 1.43072f
C1799 avdd.n368 avss 1.71792f
C1800 avdd.n369 avss 1.43072f
C1801 avdd.n370 avss 1.0276f
C1802 avdd.n371 avss 1.43072f
C1803 avdd.n372 avss 1.0276f
C1804 avdd.n373 avss 1.43072f
C1805 avdd.n374 avss 1.0276f
C1806 avdd.n375 avss 1.43072f
C1807 avdd.n376 avss 1.0276f
C1808 avdd.n377 avss 1.43072f
C1809 avdd.n378 avss 1.0276f
C1810 avdd.n379 avss 1.43072f
C1811 avdd.n380 avss 1.0276f
C1812 avdd.n381 avss 1.43072f
C1813 avdd.n382 avss 1.02956f
C1814 avdd.n384 avss 1.43327f
C1815 avdd.n385 avss 0.47674f
C1816 avdd.n386 avss 1.43327f
C1817 avdd.n387 avss 1.02962f
C1818 avdd.n388 avss 1.43327f
C1819 avdd.n389 avss 1.02962f
C1820 avdd.n390 avss 1.43327f
C1821 avdd.n391 avss 1.02962f
C1822 avdd.n392 avss 1.43327f
C1823 avdd.n393 avss 1.02962f
C1824 avdd.n394 avss 1.43327f
C1825 avdd.n395 avss 1.02962f
C1826 avdd.n396 avss 1.43327f
C1827 avdd.n397 avss 1.02962f
C1828 avdd.n398 avss 1.43327f
C1829 avdd.n399 avss 1.02962f
C1830 avdd.n400 avss 1.43327f
C1831 avdd.n401 avss 1.02962f
C1832 avdd.n402 avss 1.43327f
C1833 avdd.n403 avss 1.02962f
C1834 avdd.n404 avss 1.43327f
C1835 avdd.n405 avss 1.02962f
C1836 avdd.n406 avss 1.43327f
C1837 avdd.n407 avss 1.02962f
C1838 avdd.n408 avss 1.43327f
C1839 avdd.n409 avss 1.02962f
C1840 avdd.n410 avss 1.43327f
C1841 avdd.n411 avss 1.02962f
C1842 avdd.n412 avss 1.43327f
C1843 avdd.n413 avss 1.02962f
C1844 avdd.n414 avss 1.43327f
C1845 avdd.n415 avss 1.02962f
C1846 avdd.n416 avss 1.43327f
C1847 avdd.n417 avss 1.02962f
C1848 avdd.n418 avss 1.43327f
C1849 avdd.n419 avss 1.2283f
C1850 avdd.n420 avss 1.43327f
C1851 avdd.n421 avss 1.02962f
C1852 avdd.t264 avss 0.50874f
C1853 avdd.t265 avss 0.29964f
C1854 avdd.t266 avss 0.29964f
C1855 avdd.t33 avss 2.52671f
C1856 avdd.t35 avss 2.52379f
C1857 avdd.t32 avss 0.58074f
C1858 avdd.t61 avss 2.52396f
C1859 avdd.t71 avss 2.52693f
C1860 avdd.t55 avss 2.52426f
C1861 avdd.t348 avss 0.50784f
C1862 avdd.t349 avss 0.29902f
C1863 avdd.t350 avss 0.29902f
C1864 avdd.t48 avss 0.58057f
C1865 avdd.n422 avss 2.23284f
C1866 avdd.t68 avss 0.60431f
C1867 avdd.n423 avss 0.67396f
C1868 avdd.t49 avss 2.5707f
C1869 avdd.t69 avss 2.52426f
C1870 avdd.t70 avss 0.60431f
C1871 avdd.n426 avss 0.67028f
C1872 avdd.t54 avss 0.60431f
C1873 avdd.n427 avss 0.66664f
C1874 avdd.t18 avss 0.58057f
C1875 avdd.t344 avss 0.50784f
C1876 avdd.t345 avss 0.29902f
C1877 avdd.t346 avss 0.29902f
C1878 avdd.t352 avss 0.50784f
C1879 avdd.t353 avss 0.29902f
C1880 avdd.t354 avss 0.29902f
C1881 avdd.t1024 avss 3.6913f
C1882 avdd.t1022 avss 3.64741f
C1883 avdd.t1023 avss 0.61498f
C1884 avdd.t1021 avss 0.60139f
C1885 avdd.n428 avss 1.296f
C1886 avdd.t82 avss 3.66704f
C1887 avdd.t968 avss 0.61738f
C1888 avdd.t967 avss 0.60371f
C1889 avdd.n429 avss 1.32198f
C1890 avdd.t973 avss 0.60371f
C1891 avdd.n430 avss 0.67347f
C1892 avdd.t1043 avss 0.60371f
C1893 avdd.n431 avss 0.66546f
C1894 avdd.t17 avss 1.16363f
C1895 avdd.t16 avss 0.35937f
C1896 avdd.t707 avss 0.7927f
C1897 avdd.n432 avss 2.21535f
C1898 avdd.t930 avss 1.30444f
C1899 avdd.t27 avss 1.30482f
C1900 avdd.n434 avss 0.49456f
C1901 avdd.t1020 avss 1.27679f
C1902 avdd.t1027 avss 1.27679f
C1903 avdd.t664 avss 0.7927f
C1904 avdd.t65 avss 1.27679f
C1905 avdd.t751 avss 0.7927f
C1906 avdd.t747 avss 0.7927f
C1907 avdd.t743 avss 0.7927f
C1908 avdd.t739 avss 0.7927f
C1909 avdd.t735 avss 0.7927f
C1910 avdd.t731 avss 0.7927f
C1911 avdd.t727 avss 0.7927f
C1912 avdd.t723 avss 0.7927f
C1913 avdd.t719 avss 0.7927f
C1914 avdd.t715 avss 0.7927f
C1915 avdd.t711 avss 0.7927f
C1916 avdd.n435 avss 2.21535f
C1917 avdd.n436 avss 2.21535f
C1918 avdd.n437 avss 2.21535f
C1919 avdd.n438 avss 2.21535f
C1920 avdd.n439 avss 2.21535f
C1921 avdd.n440 avss 2.21535f
C1922 avdd.n441 avss 2.21535f
C1923 avdd.n442 avss 2.21535f
C1924 avdd.n443 avss 2.21535f
C1925 avdd.n444 avss 2.21535f
C1926 avdd.t700 avss 0.58179f
C1927 avdd.t701 avss 0.34832f
C1928 avdd.t702 avss 0.34832f
C1929 avdd.t696 avss 0.58179f
C1930 avdd.t697 avss 0.34832f
C1931 avdd.t698 avss 0.34832f
C1932 avdd.n445 avss 3.05527f
C1933 avdd.t692 avss 0.58179f
C1934 avdd.t693 avss 0.34832f
C1935 avdd.t694 avss 0.34832f
C1936 avdd.n446 avss 1.80816f
C1937 avdd.t688 avss 0.58179f
C1938 avdd.t689 avss 0.34832f
C1939 avdd.t690 avss 0.34832f
C1940 avdd.n447 avss 1.80816f
C1941 avdd.t684 avss 0.58179f
C1942 avdd.t685 avss 0.34832f
C1943 avdd.t686 avss 0.34832f
C1944 avdd.n448 avss 1.80816f
C1945 avdd.t680 avss 0.58179f
C1946 avdd.t681 avss 0.34832f
C1947 avdd.t682 avss 0.34832f
C1948 avdd.n449 avss 1.80816f
C1949 avdd.t676 avss 0.58179f
C1950 avdd.t677 avss 0.34832f
C1951 avdd.t678 avss 0.34832f
C1952 avdd.n450 avss 1.80795f
C1953 avdd.t672 avss 0.58179f
C1954 avdd.t673 avss 0.34832f
C1955 avdd.t674 avss 0.34832f
C1956 avdd.n451 avss 1.95332f
C1957 avdd.t87 avss 0.10604f
C1958 avdd.t88 avss 1.08476f
C1959 avdd.n452 avss 0.20505f
C1960 avdd.t879 avss 0.32891f
C1961 avdd.t880 avss 0.1778f
C1962 avdd.t881 avss 0.1778f
C1963 avdd.t875 avss 0.32891f
C1964 avdd.t876 avss 0.1778f
C1965 avdd.t877 avss 0.1778f
C1966 avdd.n453 avss 1.52041f
C1967 avdd.t871 avss 0.32891f
C1968 avdd.t872 avss 0.1778f
C1969 avdd.t873 avss 0.1778f
C1970 avdd.n454 avss 0.85921f
C1971 avdd.t867 avss 0.32891f
C1972 avdd.t868 avss 0.1778f
C1973 avdd.t869 avss 0.1778f
C1974 avdd.n455 avss 0.85921f
C1975 avdd.t863 avss 0.32891f
C1976 avdd.t864 avss 0.1778f
C1977 avdd.t865 avss 0.1778f
C1978 avdd.n456 avss 0.85921f
C1979 avdd.t859 avss 0.32891f
C1980 avdd.t860 avss 0.1778f
C1981 avdd.t861 avss 0.1778f
C1982 avdd.n457 avss 0.85921f
C1983 avdd.t855 avss 0.32891f
C1984 avdd.t856 avss 0.1778f
C1985 avdd.t857 avss 0.1778f
C1986 avdd.n458 avss 0.85921f
C1987 avdd.t851 avss 0.32891f
C1988 avdd.t852 avss 0.1778f
C1989 avdd.t853 avss 0.1778f
C1990 avdd.n459 avss 0.86084f
C1991 avdd.n460 avss 0.1176f
C1992 avdd.t902 avss 0.41436f
C1993 avdd.n462 avss 0.11612f
C1994 avdd.n464 avss 0.12685f
C1995 avdd.t847 avss 0.32891f
C1996 avdd.t848 avss 0.1778f
C1997 avdd.t849 avss 0.1778f
C1998 avdd.t923 avss 0.41918f
C1999 avdd.n465 avss 1.12817f
C2000 avdd.t921 avss 0.44581f
C2001 avdd.n466 avss 0.46561f
C2002 avdd.t927 avss 0.44638f
C2003 avdd.n467 avss 0.46031f
C2004 avdd.t925 avss 0.44581f
C2005 avdd.n468 avss 0.46015f
C2006 avdd.t975 avss 0.44638f
C2007 avdd.n469 avss 0.46031f
C2008 avdd.t945 avss 0.44581f
C2009 avdd.n470 avss 0.45433f
C2010 avdd.t791 avss 0.32891f
C2011 avdd.t792 avss 0.1778f
C2012 avdd.t793 avss 0.1778f
C2013 avdd.t787 avss 0.32891f
C2014 avdd.t788 avss 0.1778f
C2015 avdd.t789 avss 0.1778f
C2016 avdd.n471 avss 1.52041f
C2017 avdd.t783 avss 0.32891f
C2018 avdd.t784 avss 0.1778f
C2019 avdd.t785 avss 0.1778f
C2020 avdd.n472 avss 0.85921f
C2021 avdd.t779 avss 0.32891f
C2022 avdd.t780 avss 0.1778f
C2023 avdd.t781 avss 0.1778f
C2024 avdd.t775 avss 0.32891f
C2025 avdd.t776 avss 0.1778f
C2026 avdd.t777 avss 0.1778f
C2027 avdd.t771 avss 0.32891f
C2028 avdd.t772 avss 0.1778f
C2029 avdd.t773 avss 0.1778f
C2030 avdd.t767 avss 0.32891f
C2031 avdd.t768 avss 0.1778f
C2032 avdd.t769 avss 0.1778f
C2033 avdd.t763 avss 0.32891f
C2034 avdd.t764 avss 0.1778f
C2035 avdd.t765 avss 0.1778f
C2036 avdd.n473 avss 1.52041f
C2037 avdd.n474 avss 0.85921f
C2038 avdd.n475 avss 0.85905f
C2039 avdd.t948 avss 2.33542f
C2040 avdd.t950 avss 2.30607f
C2041 avdd.t952 avss 2.3083f
C2042 avdd.t959 avss 2.30675f
C2043 avdd.t961 avss 2.3083f
C2044 avdd.t963 avss 2.30879f
C2045 avdd.t807 avss 0.32891f
C2046 avdd.t808 avss 0.1778f
C2047 avdd.t809 avss 0.1778f
C2048 avdd.t947 avss 0.41942f
C2049 avdd.n481 avss 1.13012f
C2050 avdd.t949 avss 0.44629f
C2051 avdd.n482 avss 0.46572f
C2052 avdd.t951 avss 0.44663f
C2053 avdd.n483 avss 0.46065f
C2054 avdd.t958 avss 0.44629f
C2055 avdd.n484 avss 0.46026f
C2056 avdd.t960 avss 0.44663f
C2057 avdd.n485 avss 0.45483f
C2058 avdd.t803 avss 0.32891f
C2059 avdd.t804 avss 0.1778f
C2060 avdd.t805 avss 0.1778f
C2061 avdd.t962 avss 0.41909f
C2062 avdd.n487 avss 1.14957f
C2063 avdd.t926 avss 2.30791f
C2064 avdd.t928 avss 2.30983f
C2065 avdd.t922 avss 2.30791f
C2066 avdd.t924 avss 2.3372f
C2067 avdd.t976 avss 2.30983f
C2068 avdd.t946 avss 2.24485f
C2069 avdd.t843 avss 0.32891f
C2070 avdd.t844 avss 0.1778f
C2071 avdd.t845 avss 0.1778f
C2072 avdd.n495 avss 0.86153f
C2073 avdd.n499 avss 0.18337f
C2074 avdd.n500 avss 0.20482f
C2075 avdd.t932 avss 8.51319f
C2076 avdd.n502 avss 0.1039f
C2077 avdd.t759 avss 0.58179f
C2078 avdd.t760 avss 0.34832f
C2079 avdd.t761 avss 0.34832f
C2080 avdd.n503 avss 1.8849f
C2081 avdd.t954 avss 0.67756f
C2082 avdd.n504 avss 0.76864f
C2083 avdd.t955 avss 0.70668f
C2084 avdd.n505 avss 0.75445f
C2085 avdd.t956 avss 0.67756f
C2086 avdd.n506 avss 0.76847f
C2087 avdd.t964 avss 0.70668f
C2088 avdd.n507 avss 0.75445f
C2089 avdd.t965 avss 0.67756f
C2090 avdd.n508 avss 0.76949f
C2091 avdd.t966 avss 0.67697f
C2092 avdd.n509 avss 0.78194f
C2093 avdd.t755 avss 0.58179f
C2094 avdd.t756 avss 0.34832f
C2095 avdd.t757 avss 0.34832f
C2096 avdd.t799 avss 0.58179f
C2097 avdd.t800 avss 0.34832f
C2098 avdd.t801 avss 0.34832f
C2099 avdd.t971 avss 0.67756f
C2100 avdd.n510 avss 1.98671f
C2101 avdd.t977 avss 0.70689f
C2102 avdd.n511 avss 0.75325f
C2103 avdd.t978 avss 0.70727f
C2104 avdd.n512 avss 0.74655f
C2105 avdd.t979 avss 0.70689f
C2106 avdd.n513 avss 0.7462f
C2107 avdd.t980 avss 0.70727f
C2108 avdd.n514 avss 0.74655f
C2109 avdd.t953 avss 0.70689f
C2110 avdd.n515 avss 0.74622f
C2111 avdd.t795 avss 0.58179f
C2112 avdd.t796 avss 0.34832f
C2113 avdd.t797 avss 0.34832f
C2114 avdd.t839 avss 0.58179f
C2115 avdd.t840 avss 0.34832f
C2116 avdd.t841 avss 0.34832f
C2117 avdd.t835 avss 0.58179f
C2118 avdd.t836 avss 0.34832f
C2119 avdd.t837 avss 0.34832f
C2120 avdd.n516 avss 3.05143f
C2121 avdd.t831 avss 0.58179f
C2122 avdd.t832 avss 0.34832f
C2123 avdd.t833 avss 0.34832f
C2124 avdd.n517 avss 1.80816f
C2125 avdd.t827 avss 0.58179f
C2126 avdd.t828 avss 0.34832f
C2127 avdd.t829 avss 0.34832f
C2128 avdd.n518 avss 1.80816f
C2129 avdd.t823 avss 0.58179f
C2130 avdd.t824 avss 0.34832f
C2131 avdd.t825 avss 0.34832f
C2132 avdd.n519 avss 1.80816f
C2133 avdd.t819 avss 0.58179f
C2134 avdd.t820 avss 0.34832f
C2135 avdd.t821 avss 0.34832f
C2136 avdd.n520 avss 1.80816f
C2137 avdd.t815 avss 0.58179f
C2138 avdd.t816 avss 0.34832f
C2139 avdd.t817 avss 0.34832f
C2140 avdd.n521 avss 1.81082f
C2141 avdd.t811 avss 0.58179f
C2142 avdd.t812 avss 0.34832f
C2143 avdd.t813 avss 0.34832f
C2144 avdd.n522 avss 0.57651f
C2145 avdd.t668 avss 0.7927f
C2146 avdd.n523 avss 2.20528f
C2147 avdd.t64 avss 1.35896f
C2148 avdd.n524 avss 0.76906f
C2149 avdd.t1029 avss 1.35984f
C2150 avdd.n525 avss 0.761f
C2151 avdd.t1028 avss 1.35896f
C2152 avdd.n526 avss 0.76116f
C2153 avdd.t882 avss 1.35984f
C2154 avdd.n527 avss 0.76646f
C2155 avdd.n528 avss 0.85651f
C2156 avdd.n529 avss 1.12762f
C2157 avdd.n530 avss 0.83483f
C2158 avdd.t1026 avss 1.35984f
C2159 avdd.n531 avss 0.76285f
C2160 avdd.t1040 avss 1.35896f
C2161 avdd.n532 avss 0.76116f
C2162 avdd.t1025 avss 1.35984f
C2163 avdd.n533 avss 0.76646f
C2164 avdd.n534 avss 0.84934f
C2165 avdd.t660 avss 0.7927f
C2166 avdd.n535 avss 2.19872f
C2167 avdd.n536 avss 0.10629f
C2168 avdd.n537 avss 0.67759f
C2169 avdd.t704 avss 0.7927f
C2170 avdd.n538 avss 0.43226f
C2171 avdd.n539 avss 2.05199f
C2172 avdd.t929 avss 1.46158f
C2173 avdd.n540 avss 0.39977f
C2174 avdd.t26 avss 1.46108f
C2175 avdd.n541 avss 0.40009f
C2176 avdd.t28 avss 0.37961f
C2177 avdd.n542 avss 0.42471f
C2178 avdd.t42 avss 0.3799f
C2179 avdd.n543 avss 0.42006f
C2180 avdd.t44 avss 0.37961f
C2181 avdd.n544 avss 0.41962f
C2182 avdd.t939 avss 0.3799f
C2183 avdd.n545 avss 0.42006f
C2184 avdd.t941 avss 0.37961f
C2185 avdd.n546 avss 0.41962f
C2186 avdd.t14 avss 0.3799f
C2187 avdd.n547 avss 0.42079f
C2188 avdd.t942 avss 1.16144f
C2189 avdd.t29 avss 1.16341f
C2190 avdd.t43 avss 1.16334f
C2191 avdd.t45 avss 1.16212f
C2192 avdd.t940 avss 1.16334f
C2193 avdd.t15 avss 1.16334f
C2194 avdd.n554 avss 0.4425f
C2195 avdd.t1006 avss 0.40458f
C2196 avdd.n556 avss 0.42154f
C2197 avdd.t970 avss 0.60371f
C2198 avdd.n558 avss 0.66983f
C2199 avdd.t974 avss 0.60371f
C2200 avdd.n559 avss 0.68234f
C2201 avdd.t957 avss 0.61736f
C2202 avdd.t969 avss 0.60369f
C2203 avdd.n560 avss 1.32155f
C2204 avdd.t1044 avss 0.60369f
C2205 avdd.n561 avss 0.67471f
C2206 avdd.t972 avss 0.57999f
C2207 avdd.n563 avss 0.69028f
C2208 avdd.t6 avss 0.61504f
C2209 avdd.t905 avss 0.60138f
C2210 avdd.n564 avss 1.30333f
C2211 avdd.t903 avss 0.60136f
C2212 avdd.n565 avss 0.66524f
C2213 avdd.t81 avss 0.57802f
C2214 avdd.n567 avss 0.6701f
C2215 avdd.t904 avss 3.64815f
C2216 avdd.t906 avss 3.64778f
C2217 avdd.t910 avss 3.69343f
C2218 avdd.t912 avss 3.69529f
C2219 avdd.t1034 avss 0.79443f
C2220 avdd.t943 avss 0.77421f
C2221 avdd.n568 avss 1.38423f
C2222 avdd.t987 avss 0.77433f
C2223 avdd.n569 avss 0.70615f
C2224 avdd.t1041 avss 0.77459f
C2225 avdd.n570 avss 0.70611f
C2226 avdd.t913 avss 0.77415f
C2227 avdd.n571 avss 0.70032f
C2228 avdd.t78 avss 4.20128f
C2229 avdd.t1035 avss 3.85683f
C2230 avdd.n572 avss 0.33099f
C2231 avdd.t944 avss 3.8086f
C2232 avdd.t988 avss 3.8095f
C2233 avdd.t1042 avss 3.81062f
C2234 avdd.t914 avss 3.80817f
C2235 avdd.t916 avss 3.5597f
C2236 avdd.t915 avss 0.73244f
C2237 avdd.n579 avss 0.80427f
C2238 avdd.t524 avss 0.7927f
C2239 avdd.n580 avss 2.26415f
C2240 avdd.t520 avss 0.7927f
C2241 avdd.n581 avss 2.21535f
C2242 avdd.t516 avss 0.7927f
C2243 avdd.n582 avss 2.21535f
C2244 avdd.t512 avss 0.7927f
C2245 avdd.n583 avss 2.21535f
C2246 avdd.t508 avss 0.7927f
C2247 avdd.n584 avss 2.21535f
C2248 avdd.t504 avss 0.7927f
C2249 avdd.n585 avss 2.21535f
C2250 avdd.t500 avss 0.7927f
C2251 avdd.n586 avss 2.21535f
C2252 avdd.t496 avss 0.7927f
C2253 avdd.n587 avss 2.21535f
C2254 avdd.t492 avss 0.7927f
C2255 avdd.n588 avss 2.21535f
C2256 avdd.t488 avss 0.7927f
C2257 avdd.n589 avss 2.21535f
C2258 avdd.t484 avss 0.7927f
C2259 avdd.n590 avss 2.21535f
C2260 avdd.t480 avss 0.7927f
C2261 avdd.n591 avss 2.22415f
C2262 avdd.t476 avss 0.7927f
C2263 avdd.n592 avss 2.22814f
C2264 avdd.t911 avss 0.60144f
C2265 avdd.n593 avss 0.6939f
C2266 avdd.t909 avss 0.60166f
C2267 avdd.n594 avss 0.66905f
C2268 avdd.t7 avss 3.70055f
C2269 avdd.t989 avss 0.1101f
C2270 avdd.t920 avss 1.97054f
C2271 avdd.t1037 avss 1.97668f
C2272 avdd.t917 avss 0.37416f
C2273 avdd.t919 avss 0.36652f
C2274 avdd.n603 avss 0.8715f
C2275 avdd.t472 avss 0.1827f
C2276 avdd.t444 avss 0.1827f
C2277 avdd.t440 avss 0.26993f
C2278 avdd.t441 avss 0.14191f
C2279 avdd.t442 avss 0.14191f
C2280 avdd.t436 avss 0.26993f
C2281 avdd.t437 avss 0.14191f
C2282 avdd.t438 avss 0.14191f
C2283 avdd.t996 avss 0.33125f
C2284 avdd.t396 avss 0.26993f
C2285 avdd.t397 avss 0.14191f
C2286 avdd.t398 avss 0.14191f
C2287 avdd.t392 avss 0.26993f
C2288 avdd.t393 avss 0.14191f
C2289 avdd.t394 avss 0.14191f
C2290 avdd.t388 avss 0.26993f
C2291 avdd.t389 avss 0.14191f
C2292 avdd.t390 avss 0.14191f
C2293 avdd.t384 avss 0.26993f
C2294 avdd.t385 avss 0.14191f
C2295 avdd.t386 avss 0.14191f
C2296 avdd.n604 avss 1.21494f
C2297 avdd.n605 avss 0.68668f
C2298 avdd.t992 avss 0.33127f
C2299 avdd.t897 avss 0.16781f
C2300 avdd.t899 avss 0.16479f
C2301 avdd.n606 avss 0.43527f
C2302 avdd.t898 avss 1.04823f
C2303 avdd.t91 avss 0.10565f
C2304 avdd.t92 avss 0.5892f
C2305 avdd.n607 avss 0.21319f
C2306 avdd.t900 avss 1.05798f
C2307 avdd.n610 avss 0.16355f
C2308 avdd.n611 avss 0.27035f
C2309 avdd.t404 avss 0.26993f
C2310 avdd.t405 avss 0.14191f
C2311 avdd.t406 avss 0.14191f
C2312 avdd.t400 avss 0.26993f
C2313 avdd.t401 avss 0.14191f
C2314 avdd.t402 avss 0.14191f
C2315 avdd.n612 avss 0.6866f
C2316 avdd.n613 avss 0.68646f
C2317 avdd.t408 avss 0.26993f
C2318 avdd.t409 avss 0.14191f
C2319 avdd.t410 avss 0.14191f
C2320 avdd.n614 avss 0.6789f
C2321 avdd.n616 avss 0.10577f
C2322 avdd.n617 avss 0.23158f
C2323 avdd.t424 avss 0.26993f
C2324 avdd.t425 avss 0.14122f
C2325 avdd.t426 avss 0.14122f
C2326 avdd.n618 avss 0.20111f
C2327 avdd.n619 avss 0.20448f
C2328 avdd.t420 avss 0.26993f
C2329 avdd.t421 avss 0.14191f
C2330 avdd.t422 avss 0.14191f
C2331 avdd.n620 avss 0.6871f
C2332 avdd.t993 avss 0.33127f
C2333 avdd.n621 avss 0.42076f
C2334 avdd.n622 avss 0.41841f
C2335 avdd.t416 avss 0.26993f
C2336 avdd.t417 avss 0.14191f
C2337 avdd.t418 avss 0.14191f
C2338 avdd.n624 avss 0.68816f
C2339 avdd.t991 avss 0.33127f
C2340 avdd.n625 avss 0.42299f
C2341 avdd.t412 avss 0.26993f
C2342 avdd.t413 avss 0.14191f
C2343 avdd.t414 avss 0.14191f
C2344 avdd.n626 avss 0.76188f
C2345 avdd.t428 avss 0.26993f
C2346 avdd.t429 avss 0.14191f
C2347 avdd.t430 avss 0.14191f
C2348 avdd.t528 avss 0.26993f
C2349 avdd.t529 avss 0.14191f
C2350 avdd.t530 avss 0.14191f
C2351 avdd.t532 avss 0.26993f
C2352 avdd.t533 avss 0.14191f
C2353 avdd.t534 avss 0.14191f
C2354 avdd.n627 avss 0.69153f
C2355 avdd.t552 avss 0.26993f
C2356 avdd.t553 avss 0.14191f
C2357 avdd.t554 avss 0.14191f
C2358 avdd.t556 avss 0.26993f
C2359 avdd.t557 avss 0.14191f
C2360 avdd.t558 avss 0.14191f
C2361 avdd.n628 avss 0.60747f
C2362 avdd.t576 avss 0.26993f
C2363 avdd.t577 avss 0.14191f
C2364 avdd.t578 avss 0.14191f
C2365 avdd.t580 avss 0.26993f
C2366 avdd.t581 avss 0.14191f
C2367 avdd.t582 avss 0.14191f
C2368 avdd.n629 avss 0.50703f
C2369 avdd.t600 avss 0.26993f
C2370 avdd.t601 avss 0.14191f
C2371 avdd.t602 avss 0.14191f
C2372 avdd.t656 avss 0.1827f
C2373 avdd.t652 avss 0.1827f
C2374 avdd.n630 avss 0.27177f
C2375 avdd.t648 avss 0.1827f
C2376 avdd.n631 avss 0.13048f
C2377 avdd.t644 avss 0.1827f
C2378 avdd.n632 avss 0.19867f
C2379 avdd.t640 avss 0.1827f
C2380 avdd.n633 avss 0.19739f
C2381 avdd.t636 avss 0.1827f
C2382 avdd.n634 avss 0.12581f
C2383 avdd.t632 avss 0.1827f
C2384 avdd.n635 avss 0.12021f
C2385 avdd.t588 avss 0.26993f
C2386 avdd.t589 avss 0.14191f
C2387 avdd.t590 avss 0.14191f
C2388 avdd.t1005 avss 0.33118f
C2389 avdd.t584 avss 0.26993f
C2390 avdd.t585 avss 0.14191f
C2391 avdd.t586 avss 0.14191f
C2392 avdd.t1004 avss 0.33118f
C2393 avdd.t1003 avss 0.35122f
C2394 avdd.n636 avss 0.5875f
C2395 avdd.n637 avss 0.41526f
C2396 avdd.n638 avss 0.60881f
C2397 avdd.n639 avss 0.49945f
C2398 avdd.n640 avss 0.53281f
C2399 avdd.t596 avss 0.1827f
C2400 avdd.t1030 avss 0.25134f
C2401 avdd.n641 avss 0.3833f
C2402 avdd.t93 avss 0.27231f
C2403 avdd.n642 avss 0.29814f
C2404 avdd.t30 avss 0.27231f
C2405 avdd.n643 avss 0.29058f
C2406 avdd.t1038 avss 0.25134f
C2407 avdd.n644 avss 0.31334f
C2408 avdd.t1047 avss 0.27231f
C2409 avdd.n645 avss 0.29814f
C2410 avdd.t1014 avss 0.27231f
C2411 avdd.n646 avss 0.29254f
C2412 avdd.t564 avss 0.26993f
C2413 avdd.t565 avss 0.14191f
C2414 avdd.t566 avss 0.14191f
C2415 avdd.t1000 avss 0.33121f
C2416 avdd.n647 avss 0.51103f
C2417 avdd.t1001 avss 0.33121f
C2418 avdd.n648 avss 0.4174f
C2419 avdd.t1002 avss 0.35124f
C2420 avdd.n649 avss 0.40081f
C2421 avdd.t560 avss 0.26993f
C2422 avdd.t561 avss 0.14191f
C2423 avdd.t562 avss 0.14191f
C2424 avdd.n650 avss 0.69208f
C2425 avdd.n651 avss 0.53271f
C2426 avdd.t540 avss 0.26993f
C2427 avdd.t541 avss 0.14191f
C2428 avdd.t542 avss 0.14191f
C2429 avdd.t999 avss 0.33123f
C2430 avdd.t998 avss 0.33123f
C2431 avdd.t997 avss 0.30871f
C2432 avdd.n652 avss 0.44097f
C2433 avdd.t536 avss 0.26993f
C2434 avdd.t537 avss 0.14191f
C2435 avdd.t538 avss 0.14191f
C2436 avdd.n653 avss 0.69418f
C2437 avdd.n654 avss 0.41672f
C2438 avdd.n655 avss 0.42373f
C2439 avdd.n656 avss 0.53289f
C2440 avdd.t984 avss 1.63623f
C2441 avdd.t986 avss 1.63505f
C2442 avdd.n657 avss 0.1019f
C2443 avdd.t884 avss 1.63505f
C2444 avdd.t886 avss 1.63505f
C2445 avdd.t888 avss 1.63505f
C2446 avdd.t896 avss 1.63505f
C2447 avdd.n661 avss 0.10057f
C2448 avdd.t548 avss 0.1827f
C2449 avdd.t983 avss 0.27233f
C2450 avdd.n662 avss 0.39524f
C2451 avdd.t985 avss 0.27233f
C2452 avdd.n663 avss 0.29361f
C2453 avdd.t883 avss 0.27233f
C2454 avdd.n664 avss 0.29073f
C2455 avdd.t885 avss 0.25136f
C2456 avdd.n665 avss 0.3135f
C2457 avdd.t887 avss 0.27233f
C2458 avdd.n666 avss 0.30298f
C2459 avdd.t895 avss 0.25136f
C2460 avdd.n667 avss 0.30968f
C2461 avdd.t544 avss 0.1827f
C2462 avdd.n668 avss 0.30688f
C2463 avdd.t572 avss 0.1827f
C2464 avdd.t1016 avss 0.2725f
C2465 avdd.n670 avss 0.39518f
C2466 avdd.t1018 avss 0.2725f
C2467 avdd.n671 avss 0.29379f
C2468 avdd.t0 avss 0.2725f
C2469 avdd.n672 avss 0.29091f
C2470 avdd.t2 avss 0.25152f
C2471 avdd.n673 avss 0.31369f
C2472 avdd.t4 avss 0.2725f
C2473 avdd.n674 avss 0.30316f
C2474 avdd.t981 avss 0.25152f
C2475 avdd.n675 avss 0.30972f
C2476 avdd.t1017 avss 1.64887f
C2477 avdd.t1019 avss 1.63445f
C2478 avdd.n676 avss 0.1019f
C2479 avdd.t1 avss 1.63445f
C2480 avdd.t3 avss 1.59505f
C2481 avdd.t5 avss 1.63445f
C2482 avdd.t982 avss 1.63445f
C2483 avdd.n681 avss 0.1544f
C2484 avdd.t568 avss 0.1827f
C2485 avdd.n683 avss 0.23207f
C2486 avdd.t1031 avss 1.63682f
C2487 avdd.t94 avss 1.63563f
C2488 avdd.n685 avss 0.1019f
C2489 avdd.t31 avss 1.63563f
C2490 avdd.t1039 avss 1.59587f
C2491 avdd.t1048 avss 1.63563f
C2492 avdd.t1015 avss 1.63563f
C2493 avdd.n690 avss 0.1543f
C2494 avdd.t592 avss 0.1827f
C2495 avdd.n693 avss 0.2646f
C2496 avdd.t628 avss 0.1827f
C2497 avdd.n694 avss 0.24395f
C2498 avdd.t624 avss 0.26993f
C2499 avdd.t625 avss 0.14191f
C2500 avdd.t626 avss 0.14191f
C2501 avdd.n695 avss 0.69812f
C2502 avdd.t620 avss 0.26993f
C2503 avdd.t621 avss 0.14191f
C2504 avdd.t622 avss 0.14191f
C2505 avdd.n696 avss 0.68672f
C2506 avdd.t616 avss 0.26993f
C2507 avdd.t617 avss 0.14191f
C2508 avdd.t618 avss 0.14191f
C2509 avdd.n697 avss 0.6904f
C2510 avdd.t612 avss 0.26993f
C2511 avdd.t613 avss 0.14191f
C2512 avdd.t614 avss 0.14191f
C2513 avdd.n698 avss 0.68441f
C2514 avdd.t608 avss 0.26993f
C2515 avdd.t609 avss 0.14191f
C2516 avdd.t610 avss 0.14191f
C2517 avdd.n699 avss 0.68668f
C2518 avdd.t604 avss 0.26993f
C2519 avdd.t605 avss 0.14191f
C2520 avdd.t606 avss 0.14191f
C2521 avdd.n700 avss 0.68655f
C2522 avdd.n701 avss 0.60305f
C2523 avdd.t994 avss 0.33125f
C2524 avdd.n702 avss 0.4205f
C2525 avdd.t995 avss 0.35129f
C2526 avdd.n703 avss 0.39882f
C2527 avdd.t432 avss 0.26993f
C2528 avdd.t433 avss 0.14191f
C2529 avdd.t434 avss 0.14191f
C2530 avdd.n704 avss 0.68918f
C2531 avdd.n705 avss 0.42319f
C2532 avdd.n706 avss 0.68719f
C2533 avdd.n707 avss 0.63491f
C2534 avdd.n708 avss 0.27383f
C2535 avdd.t448 avss 0.1827f
C2536 avdd.n709 avss 0.19737f
C2537 avdd.t452 avss 0.1827f
C2538 avdd.n710 avss 0.12551f
C2539 avdd.t456 avss 0.1827f
C2540 avdd.n711 avss 0.12083f
C2541 avdd.t460 avss 0.1827f
C2542 avdd.n712 avss 0.12083f
C2543 avdd.t464 avss 0.1827f
C2544 avdd.n713 avss 0.12083f
C2545 avdd.t468 avss 0.1827f
C2546 avdd.n714 avss 0.12551f
C2547 avdd.n715 avss 0.24967f
C2548 avdd.t1036 avss 0.33483f
C2549 avdd.n716 avss 0.52922f
C2550 avdd.t918 avss 1.97966f
C2551 avdd.n721 avss 0.21365f
C2552 avdd.t9 avss 3.70829f
C2553 avdd.t8 avss 0.57804f
C2554 avdd.n723 avss 0.67484f
C2555 avdd.t380 avss 0.50784f
C2556 avdd.t381 avss 0.29902f
C2557 avdd.t382 avss 0.29902f
C2558 avdd.t376 avss 0.50784f
C2559 avdd.t377 avss 0.29902f
C2560 avdd.t378 avss 0.29902f
C2561 avdd.n727 avss 3.79827f
C2562 avdd.t372 avss 0.50784f
C2563 avdd.t373 avss 0.29902f
C2564 avdd.t374 avss 0.29902f
C2565 avdd.n728 avss 2.24543f
C2566 avdd.t368 avss 0.50784f
C2567 avdd.t369 avss 0.29902f
C2568 avdd.t370 avss 0.29902f
C2569 avdd.n729 avss 2.24543f
C2570 avdd.t364 avss 0.50784f
C2571 avdd.t365 avss 0.29902f
C2572 avdd.t366 avss 0.29902f
C2573 avdd.n730 avss 2.24535f
C2574 avdd.t360 avss 0.50784f
C2575 avdd.t361 avss 0.29902f
C2576 avdd.t362 avss 0.29902f
C2577 avdd.t356 avss 0.50784f
C2578 avdd.t357 avss 0.29902f
C2579 avdd.t358 avss 0.29902f
C2580 avdd.n731 avss 2.24523f
C2581 avdd.n732 avss 2.08104f
C2582 avdd.n733 avss 2.39096f
C2583 avdd.n734 avss 0.68747f
C2584 avdd.t57 avss 2.52456f
C2585 avdd.t19 avss 2.3396f
C2586 avdd.t56 avss 0.60431f
C2587 avdd.n737 avss 0.663f
C2588 avdd.t340 avss 0.50784f
C2589 avdd.t341 avss 0.29902f
C2590 avdd.t342 avss 0.29902f
C2591 avdd.t20 avss 0.58073f
C2592 avdd.n741 avss 2.23092f
C2593 avdd.t22 avss 0.60447f
C2594 avdd.n742 avss 0.67408f
C2595 avdd.t21 avss 2.57031f
C2596 avdd.t23 avss 2.52396f
C2597 avdd.t24 avss 0.60447f
C2598 avdd.n745 avss 0.6704f
C2599 avdd.t60 avss 0.60447f
C2600 avdd.n746 avss 0.68172f
C2601 avdd.t62 avss 0.58073f
C2602 avdd.t935 avss 0.58073f
C2603 avdd.t336 avss 0.50784f
C2604 avdd.t337 avss 0.29902f
C2605 avdd.t338 avss 0.29902f
C2606 avdd.n747 avss 2.23824f
C2607 avdd.n748 avss 0.68868f
C2608 avdd.t25 avss 2.52731f
C2609 avdd.t63 avss 2.52501f
C2610 avdd.t936 avss 2.53069f
C2611 avdd.t332 avss 0.50784f
C2612 avdd.t333 avss 0.29902f
C2613 avdd.t334 avss 0.29902f
C2614 avdd.t328 avss 0.50784f
C2615 avdd.t329 avss 0.29902f
C2616 avdd.t330 avss 0.29902f
C2617 avdd.n754 avss 3.79086f
C2618 avdd.t937 avss 0.58074f
C2619 avdd.n755 avss 0.68665f
C2620 avdd.t938 avss 2.56609f
C2621 avdd.t50 avss 0.60448f
C2622 avdd.n757 avss 0.6704f
C2623 avdd.t52 avss 0.60448f
C2624 avdd.n758 avss 0.66677f
C2625 avdd.t51 avss 2.53178f
C2626 avdd.t53 avss 2.52312f
C2627 avdd.n762 avss 0.6865f
C2628 avdd.t34 avss 0.58074f
C2629 avdd.n763 avss 0.69051f
C2630 avdd.t324 avss 0.50784f
C2631 avdd.t325 avss 0.29902f
C2632 avdd.t326 avss 0.29902f
C2633 avdd.n764 avss 1.72984f
C2634 avdd.t320 avss 0.50784f
C2635 avdd.t321 avss 0.29902f
C2636 avdd.t322 avss 0.29902f
C2637 avdd.t316 avss 0.50784f
C2638 avdd.t317 avss 0.29902f
C2639 avdd.t318 avss 0.29902f
C2640 avdd.n767 avss 3.79034f
C2641 avdd.t312 avss 0.50784f
C2642 avdd.t313 avss 0.29902f
C2643 avdd.t314 avss 0.29902f
C2644 avdd.n768 avss 2.24543f
C2645 avdd.t308 avss 0.50784f
C2646 avdd.t309 avss 0.29902f
C2647 avdd.t310 avss 0.29902f
C2648 avdd.n769 avss 2.24543f
C2649 avdd.t304 avss 0.50784f
C2650 avdd.t305 avss 0.29902f
C2651 avdd.t306 avss 0.29902f
C2652 avdd.n770 avss 2.24543f
C2653 avdd.t300 avss 0.50784f
C2654 avdd.t301 avss 0.29902f
C2655 avdd.t302 avss 0.29902f
C2656 avdd.n771 avss 2.24543f
C2657 avdd.t296 avss 0.50784f
C2658 avdd.t297 avss 0.29902f
C2659 avdd.t298 avss 0.29902f
C2660 avdd.t292 avss 0.50784f
C2661 avdd.t293 avss 0.29902f
C2662 avdd.t294 avss 0.29902f
C2663 avdd.n772 avss 2.17031f
C2664 avdd.t260 avss 0.50874f
C2665 avdd.t261 avss 0.29964f
C2666 avdd.t262 avss 0.29964f
C2667 avdd.n773 avss 1.16517f
C2668 avdd.t83 avss 0.58199f
C2669 avdd.t85 avss 0.58199f
C2670 avdd.t252 avss 0.50874f
C2671 avdd.t253 avss 0.29964f
C2672 avdd.t254 avss 0.29964f
C2673 avdd.t79 avss 0.58174f
C2674 avdd.t75 avss 2.53617f
C2675 avdd.t67 avss 2.52748f
C2676 avdd.n778 avss 0.11277f
C2677 avdd.t891 avss 0.60556f
C2678 avdd.t176 avss 0.50874f
C2679 avdd.t177 avss 0.29964f
C2680 avdd.t178 avss 0.29964f
C2681 avdd.t172 avss 0.50874f
C2682 avdd.t173 avss 0.29964f
C2683 avdd.t174 avss 0.29964f
C2684 avdd.t168 avss 0.50874f
C2685 avdd.t169 avss 0.29964f
C2686 avdd.t170 avss 0.29964f
C2687 avdd.t164 avss 0.50874f
C2688 avdd.t165 avss 0.29964f
C2689 avdd.t166 avss 0.29964f
C2690 avdd.n780 avss 1.20326f
C2691 avdd.t160 avss 0.50874f
C2692 avdd.t161 avss 0.29964f
C2693 avdd.t162 avss 0.29964f
C2694 avdd.n781 avss 1.20562f
C2695 avdd.t156 avss 0.50874f
C2696 avdd.t157 avss 0.29964f
C2697 avdd.t158 avss 0.29964f
C2698 avdd.t152 avss 0.50874f
C2699 avdd.t153 avss 0.29964f
C2700 avdd.t154 avss 0.29964f
C2701 avdd.t80 avss 2.53109f
C2702 avdd.t59 avss 2.52817f
C2703 avdd.t148 avss 0.50874f
C2704 avdd.t149 avss 0.29964f
C2705 avdd.t150 avss 0.29964f
C2706 avdd.n784 avss 1.21865f
C2707 avdd.n785 avss 0.67158f
C2708 avdd.n786 avss 1.12081f
C2709 avdd.n787 avss 0.67805f
C2710 avdd.n788 avss 0.5831f
C2711 avdd.n789 avss 0.65607f
C2712 avdd.n790 avss 1.20193f
C2713 avdd.n791 avss 1.20193f
C2714 avdd.t889 avss 0.58174f
C2715 avdd.n792 avss 0.68653f
C2716 avdd.t196 avss 0.50874f
C2717 avdd.t197 avss 0.29964f
C2718 avdd.t198 avss 0.29964f
C2719 avdd.n793 avss 1.195f
C2720 avdd.n794 avss 1.02583f
C2721 avdd.t256 avss 0.50874f
C2722 avdd.t257 avss 0.29964f
C2723 avdd.t258 avss 0.29964f
C2724 avdd.t10 avss 0.58199f
C2725 avdd.t40 avss 0.6058f
C2726 avdd.n795 avss 0.66771f
C2727 avdd.t38 avss 0.6058f
C2728 avdd.n796 avss 0.67135f
C2729 avdd.t11 avss 2.57433f
C2730 avdd.t13 avss 2.52793f
C2731 avdd.t12 avss 0.6058f
C2732 avdd.n799 avss 0.67503f
C2733 avdd.n800 avss 0.69132f
C2734 avdd.n801 avss 1.195f
C2735 avdd.n802 avss 0.97876f
C2736 avdd.n803 avss 0.34091f
C2737 avdd.n804 avss 0.91622f
C2738 avdd.t288 avss 0.50874f
C2739 avdd.t289 avss 0.29964f
C2740 avdd.t290 avss 0.29964f
C2741 avdd.n805 avss 1.19908f
C2742 avdd.t284 avss 0.50874f
C2743 avdd.t285 avss 0.29964f
C2744 avdd.t286 avss 0.29964f
C2745 avdd.t280 avss 0.50874f
C2746 avdd.t281 avss 0.29964f
C2747 avdd.t282 avss 0.29964f
C2748 avdd.t276 avss 0.50874f
C2749 avdd.t277 avss 0.29964f
C2750 avdd.t278 avss 0.29964f
C2751 avdd.t272 avss 0.50874f
C2752 avdd.t273 avss 0.29964f
C2753 avdd.t274 avss 0.29964f
C2754 avdd.n806 avss 1.20889f
C2755 avdd.n807 avss 1.04916f
C2756 avdd.n808 avss 1.0396f
C2757 avdd.n809 avss 1.20896f
C2758 avdd.n810 avss 1.20783f
C2759 avdd.n811 avss 1.20774f
C2760 avdd.n812 avss 0.9177f
C2761 avdd.n813 avss 0.2501f
C2762 avdd.n814 avss 0.14873f
C2763 avdd.n815 avss 0.84229f
C2764 avdd.n816 avss 0.34286f
C2765 avdd.n817 avss 0.12078f
C2766 avdd.n818 avss 0.11277f
C2767 avdd.n819 avss 0.67225f
C2768 avdd.t890 avss 2.57377f
C2769 avdd.t892 avss 2.52748f
C2770 avdd.t74 avss 0.60556f
C2771 avdd.n822 avss 0.67593f
C2772 avdd.t66 avss 0.60556f
C2773 avdd.t39 avss 2.53051f
C2774 avdd.t41 avss 2.52793f
C2775 avdd.n825 avss 0.6873f
C2776 avdd.n826 avss 0.16524f
C2777 avdd.n828 avss 0.68742f
C2778 avdd.t58 avss 0.58174f
C2779 avdd.n829 avss 0.69142f
C2780 avdd.t192 avss 0.50874f
C2781 avdd.t193 avss 0.29964f
C2782 avdd.t194 avss 0.29964f
C2783 avdd.n831 avss 1.18841f
C2784 avdd.n832 avss 1.37129f
C2785 avdd.n833 avss 0.88245f
C2786 avdd.n834 avss 0.56595f
C2787 avdd.t86 avss 2.52862f
C2788 avdd.t84 avss 2.53153f
C2789 avdd.t188 avss 0.50331f
C2790 avdd.t189 avss 0.29593f
C2791 avdd.t190 avss 0.29593f
C2792 avdd.t76 avss 0.57497f
C2793 avdd.t184 avss 0.50331f
C2794 avdd.t185 avss 0.29593f
C2795 avdd.t186 avss 0.29593f
C2796 avdd.n835 avss 2.20682f
C2797 avdd.t77 avss 2.50154f
C2798 avdd.t144 avss 0.50331f
C2799 avdd.t145 avss 0.29593f
C2800 avdd.t146 avss 0.29593f
C2801 avdd.t140 avss 0.50331f
C2802 avdd.t141 avss 0.29593f
C2803 avdd.t142 avss 0.29593f
C2804 avdd.n836 avss 3.75487f
C2805 avdd.t136 avss 0.50331f
C2806 avdd.t137 avss 0.29593f
C2807 avdd.t138 avss 0.29593f
C2808 avdd.n837 avss 2.22224f
C2809 avdd.t132 avss 0.50331f
C2810 avdd.t133 avss 0.29593f
C2811 avdd.t134 avss 0.29593f
C2812 avdd.n838 avss 2.22224f
C2813 avdd.t128 avss 0.50331f
C2814 avdd.t129 avss 0.29593f
C2815 avdd.t130 avss 0.29593f
C2816 avdd.n839 avss 2.22224f
C2817 avdd.t124 avss 0.50331f
C2818 avdd.t125 avss 0.29593f
C2819 avdd.t126 avss 0.29593f
C2820 avdd.t120 avss 0.50331f
C2821 avdd.t121 avss 0.29593f
C2822 avdd.t122 avss 0.29593f
C2823 avdd.t116 avss 0.50331f
C2824 avdd.t117 avss 0.29593f
C2825 avdd.t118 avss 0.29593f
C2826 avdd.t112 avss 0.50331f
C2827 avdd.t113 avss 0.29593f
C2828 avdd.t114 avss 0.29593f
C2829 avdd.t108 avss 0.50331f
C2830 avdd.t109 avss 0.29593f
C2831 avdd.t110 avss 0.29593f
C2832 avdd.t104 avss 0.50331f
C2833 avdd.t105 avss 0.29593f
C2834 avdd.t106 avss 0.29593f
C2835 avdd.t100 avss 0.50331f
C2836 avdd.t101 avss 0.29593f
C2837 avdd.t102 avss 0.29593f
C2838 avdd.t96 avss 0.50331f
C2839 avdd.t97 avss 0.29593f
C2840 avdd.t98 avss 0.29593f
C2841 avdd.t73 avss 2.53847f
C2842 avdd.t934 avss 2.50301f
C2843 avdd.t933 avss 0.60287f
C2844 avdd.n840 avss 0.67736f
C2845 avdd.t89 avss 0.59836f
C2846 avdd.n841 avss 0.66708f
C2847 avdd.t36 avss 0.57497f
C2848 avdd.n842 avss 0.68176f
C2849 avdd.t90 avss 2.50927f
C2850 avdd.t37 avss 2.50051f
C2851 avdd.t46 avss 0.59836f
C2852 avdd.n845 avss 0.66585f
C2853 avdd.t72 avss 0.57497f
C2854 avdd.t180 avss 0.50331f
C2855 avdd.t181 avss 0.29593f
C2856 avdd.t182 avss 0.29593f
C2857 avdd.n846 avss 2.20464f
C2858 avdd.t47 avss 2.50277f
C2859 avdd.n850 avss 1.71773f
C2860 avdd.n851 avss 2.21507f
C2861 avdd.n852 avss 2.22224f
C2862 avdd.n853 avss 2.22224f
C2863 avdd.n854 avss 2.22224f
C2864 avdd.n855 avss 2.22224f
C2865 avdd.n856 avss 2.22217f
C2866 avdd.t1046 avss 2.50076f
C2867 avdd.t1045 avss 0.59836f
C2868 avdd.n860 avss 0.65857f
C2869 avdd.t908 avss 2.5089f
C2870 avdd.t907 avss 0.59836f
C2871 avdd.n862 avss 0.65785f
C2872 avdd.t1033 avss 2.50924f
C2873 avdd.t1032 avss 0.59836f
C2874 avdd.n864 avss 0.65857f
C2875 avdd.t894 avss 2.5089f
C2876 avdd.t893 avss 0.59836f
C2877 avdd.n866 avss 1.29033f
C2878 avdd.n867 avss 1.58384f
C2879 avdd.t249 avss 0.29592f
C2880 avdd.t250 avss 0.29592f
C2881 avdd.t248 avss 0.50331f
C2882 avdd.t240 avss 0.50331f
C2883 avdd.t241 avss 0.29593f
C2884 avdd.t242 avss 0.29593f
C2885 avdd.t236 avss 0.50331f
C2886 avdd.t237 avss 0.29593f
C2887 avdd.t238 avss 0.29593f
C2888 avdd.t232 avss 0.50331f
C2889 avdd.t233 avss 0.29593f
C2890 avdd.t234 avss 0.29593f
C2891 avdd.t228 avss 0.50331f
C2892 avdd.t229 avss 0.29593f
C2893 avdd.t230 avss 0.29593f
C2894 avdd.t224 avss 0.50331f
C2895 avdd.t225 avss 0.29593f
C2896 avdd.t226 avss 0.29593f
C2897 avdd.t220 avss 0.50331f
C2898 avdd.t221 avss 0.29593f
C2899 avdd.t222 avss 0.29593f
C2900 avdd.t216 avss 0.50331f
C2901 avdd.t217 avss 0.29593f
C2902 avdd.t218 avss 0.29593f
C2903 avdd.t212 avss 0.50331f
C2904 avdd.t213 avss 0.29593f
C2905 avdd.t214 avss 0.29593f
C2906 avdd.t208 avss 0.50331f
C2907 avdd.t209 avss 0.29593f
C2908 avdd.t210 avss 0.29593f
C2909 avdd.t204 avss 0.50331f
C2910 avdd.t205 avss 0.29593f
C2911 avdd.t206 avss 0.29593f
C2912 avdd.t200 avss 0.50331f
C2913 avdd.t201 avss 0.29593f
C2914 avdd.t202 avss 0.29593f
C2915 avdd.n868 avss 3.75109f
C2916 avdd.n869 avss 2.22224f
C2917 avdd.n870 avss 2.22224f
C2918 avdd.n871 avss 2.22224f
C2919 avdd.n872 avss 2.22224f
C2920 avdd.n873 avss 2.22224f
C2921 avdd.n874 avss 2.22224f
C2922 avdd.n875 avss 2.22224f
C2923 avdd.n876 avss 2.22224f
C2924 avdd.n877 avss 3.17931f
C2925 avdd.t244 avss 0.50331f
C2926 avdd.t245 avss 0.29592f
C2927 avdd.t246 avss 0.29592f
C2928 avdd.n878 avss 1.78741f
C2929 avdd.n879 avss 0.6465f
C2930 avdd.n883 avss 0.69152f
C2931 avdd.n884 avss 0.68752f
C2932 avdd.t269 avss 0.29939f
C2933 avdd.t270 avss 0.29939f
C2934 avdd.t268 avss 0.50874f
C2935 avdd.n886 avss 0.66203f
C2936 avdd.n887 avss 0.66445f
C2937 avdd.n888 avss 0.52458f
C2938 avdd.n889 avss 0.14737f
C2939 avdd.n890 avss 1.20956f
C2940 b3.n0 avss 7.76294f
C2941 b3.n1 avss 4.24691f
C2942 b4.n0 avss 5.26023f
C2943 b4.n1 avss 4.50944f
C2944 b0.n0 avss 1.60796f
C2945 b0.n1 avss 0.72349f
C2946 b0.n2 avss 3.82959f
C2947 b5.n0 avss 2.49044f
C2948 b5.n1 avss 4.56065f
C2949 b6.n0 avss 2.15469f
C2950 b6.n1 avss 4.05252f
C2951 vq3.t1 avss 0.23496f
C2952 vq3.n0 avss 0.72052f
C2953 vq3.n1 avss 20.2152f
C2954 vq3.t0 avss 0.35332f
C2955 vq3.n2 avss 43.1618f
C2956 b2.n0 avss 3.27124f
C2957 b2.n1 avss 4.30162f
C2958 b1.n0 avss 2.34196f
C2959 b1.n1 avss 4.88354f
C2960 vref.n0 avss 0.12202f
C2961 vref.n1 avss 0.60683f
C2962 vref.n3 avss 4.38739f
C2963 vref.t2 avss 1.13881f
C2964 vref.t0 avss 15.36427f
C2965 vref.n17 avss 0.53468f
C2966 net3.t0 avss 11.31f
C2967 vq2.t0 avss 0.49557f
C2968 net4.t0 avss 4.42717f
C2969 v1.n0 avss 3.17657f
C2970 v1.n1 avss 13.6422f
C2971 v1.t1 avss 3.99646f
C2972 v1.t0 avss 4.03829f
C2973 v1.n2 avss 3.34074f
C2974 v1.n3 avss 0.79531f
C2975 v1.n4 avss 1.84209f
C2976 v1.n5 avss 3.54314f
C2977 v1.n6 avss 2.01315f
C2978 v1.n7 avss 0.64328f
C2979 v1.n8 avss 7.94004f
C2980 v1.n9 avss 2.39183f
C2981 v1.n10 avss 1.13691f
C2982 net4 avss 2.84043f
C2983 net3 avss 27.9332f
C2984 vq2 avss 7.84877f
C2985 v1 avss 37.04678f
C2986 vq3 avss 0.13949p
.ends
