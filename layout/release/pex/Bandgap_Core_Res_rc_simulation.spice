* NGSPICE file created from Bandgap_Core_Res.ext - technology: gf180mcuD

.subckt Bandgap_Core_Res avdd avss vref b0 b1 b2 b3 b4 b5 b6 dvss dvdd
Xpnp_05p00x05p00_0 avss avss vq3 pnp_05p00x05p00
Xpnp_05p00x05p00_1 avss avss vq2 pnp_05p00x05p00
Xpnp_05p00x05p00_2 avss avss vq2 pnp_05p00x05p00
Xpnp_05p00x05p00_4 avss avss vq2 pnp_05p00x05p00
Xpnp_05p00x05p00_3 avss avss vq2 pnp_05p00x05p00
Xpnp_05p00x05p00_5 avss avss v1 pnp_05p00x05p00
Xpnp_05p00x05p00_6 avss avss vq2 pnp_05p00x05p00
Xpnp_05p00x05p00_7 avss avss vq2 pnp_05p00x05p00
Xpnp_05p00x05p00_8 avss avss vq2 pnp_05p00x05p00
Xpnp_05p00x05p00_9 avss avss vq2 pnp_05p00x05p00
Xnwell_0 net3 net4 avss nwell r_length=20.19u r_width=2u
X0 rbit0top.t9 b0.t2 rbit1top.t13 dvss nfet_03v3 ad=17.6p pd=80.88u as=17.6p ps=80.88u w=40u l=0.28u
X1 vref.t1 vcasp vx3.t1 avdd.t26 pfet_05v0 ad=7.2248p pd=33.72u as=7.2248p ps=33.72u w=16.42u l=4u
X2 vx2.t7 psrg_m3_feed.t14 avdd.t67 avdd.t66 pfet_05v0 ad=7.37p pd=34.38u as=7.37p ps=34.38u w=16.75u l=2u
X3 vbn_sink.t14 vbn_sink.t13 avss avss nfet_05v0 ad=5.4164p pd=25.5u as=5.4164p ps=25.5u w=12.31u l=8u
X4 vbn_fold.t3 vbp_i.t14 avdd.t148 avdd.t147 pfet_05v0 ad=8.3556p pd=38.86u as=8.3556p ps=38.86u w=18.99u l=8u
X5 vx3.t8 psrg_m3_feed.t26 avdd.t84 avdd.t83 pfet_05v0 ad=7.37p pd=34.38u as=7.37p ps=34.38u w=16.75u l=2u
X6 vbp_bias.t14 vbp_bias.t13 avdd.t132 avdd.t131 pfet_03v3 ad=8.3864p pd=39u as=8.3864p ps=39u w=19.06u l=8u
X7 vgn2.t7 avss cap_mim_2f0fF c_width=59u c_length=59u
X8 vbn_sink.t10 vbp_i.t24 avdd.t197 avdd.t196 pfet_05v0 ad=8.338p pd=38.78u as=8.338p ps=38.78u w=18.95u l=8u
X9 b3_b.t0 b3.t0 dvdd.t19 dvdd.t18 pfet_03v3 ad=1.32p pd=6.88u as=1.32p ps=6.88u w=3u l=0.5u
X10 vref.t2 vcasp vx3.t3 avdd.t31 pfet_05v0 ad=7.2248p pd=33.72u as=7.2248p ps=33.72u w=16.42u l=4u
X11 vbn_sink.t6 vbp_i.t25 avdd.t120 avdd.t119 pfet_05v0 ad=8.338p pd=38.78u as=8.338p ps=38.78u w=18.95u l=8u
X12 vref.t7 avss cap_mim_2f0fF c_width=70.7u c_length=70.7u
X13 su_state.t0 vbp_tail.t7 avdd.t1 avdd.t0 pfet_05v0 ad=0.44p pd=2.88u as=0.44p ps=2.88u w=1u l=8u
X14 vbn_i.t2 vbp_i.t40 avdd.t102 avdd.t101 pfet_05v0 ad=8.25p pd=38.38u as=8.25p ps=38.38u w=18.75u l=8u
X15 rbit3top.t3 b2_b.t3 rbit2top.t3 dvdd.t17 pfet_03v3 ad=8.8p pd=40.88u as=8.8p ps=40.88u w=20u l=0.28u
X16 xf2.t11 vbn_sink.t32 avss avss nfet_05v0 ad=7.1896p pd=33.56u as=7.1896p ps=33.56u w=16.34u l=8u
X17 rbit6top.t0 b5_b.t2 rbit5top.t0 dvdd.t0 pfet_03v3 ad=3.3p pd=15.88u as=3.3p ps=15.88u w=7.5u l=0.28u
X18 rbit4top.t0 rbit3top.t1 avss ppolyf_u_1k r_width=6.6u r_length=16u
X19 vbp_bias.t10 vbp_bias.t9 avdd.t65 avdd.t64 pfet_03v3 ad=8.3864p pd=39u as=8.3864p ps=39u w=19.06u l=8u
X20 rb_mid rb_mid avss avss nfet_05v0 ad=0.2376p pd=1.96u as=0.2376p ps=1.96u w=0.54u l=20u
X21 vgn1.t2 vcasp vx1.t1 avdd.t28 pfet_05v0 ad=7.2248p pd=33.72u as=7.2248p ps=33.72u w=16.42u l=4u
X22 xf1.t1 v1.t2 vsp.t0 avdd.t48 pfet_05v0 ad=24.1516p pd=0.11066m as=24.1516p ps=0.11066m w=54.89u l=4u
X23 rfix2 rfix1 avss ppolyf_u_1k r_width=6.6u r_length=0.128m
X24 vx3.t6 psrg_m3_feed.t25 avdd.t45 avdd.t44 pfet_05v0 ad=7.37p pd=34.38u as=7.37p ps=34.38u w=16.75u l=2u
X25 vgn2.t2 vbp_cas.t21 pm2.t8 avdd.t81 pfet_05v0 ad=9.7724p pd=45.3u as=9.7724p ps=45.3u w=22.21u l=8u
X26 vbp_bias.t22 vbp_bias.t21 avdd.t258 avdd.t257 pfet_03v3 ad=8.3864p pd=39u as=8.3864p ps=39u w=19.06u l=8u
X27 aux_gate vcasp avdd.t24 avdd.t23 pfet_05v0 ad=0.22p pd=1.88u as=0.22p ps=1.88u w=0.5u l=10u
X28 xf2.t10 v2.t5 vsp.t14 avdd.t242 pfet_05v0 ad=24.1516p pd=0.11066m as=24.1516p ps=0.11066m w=54.89u l=4u
X29 vsu vsu bgsu1 avss nfet_05v0 ad=0.44p pd=2.88u as=0.44p ps=2.88u w=1u l=2u
X30 vbp_cas.t17 vbp_cas.t16 vbp_bias.t5 avdd.t130 pfet_05v0 ad=8.3292p pd=38.74u as=8.3292p ps=38.74u w=18.93u l=8u
X31 rbit6top.t3 rbit5top.t1 avss ppolyf_u_1k r_width=6.6u r_length=64u
X32 vx1.t7 psrg_m3_feed.t16 avdd.t77 avdd.t76 pfet_05v0 ad=7.37p pd=34.38u as=7.37p ps=34.38u w=16.75u l=2u
X33 psrg_m3_feed.t2 vcasp vx2.t2 avdd.t33 pfet_05v0 ad=7.2248p pd=33.72u as=7.2248p ps=33.72u w=16.42u l=4u
X34 vbp_bias.t12 vbp_bias.t11 avdd.t50 avdd.t49 pfet_03v3 ad=8.3864p pd=39u as=8.3864p ps=39u w=19.06u l=8u
X35 xf1.t8 vbn_sink.t26 avss avss nfet_05v0 ad=7.1896p pd=33.56u as=7.1896p ps=33.56u w=16.34u l=8u
X36 xf1.t9 vbn_sink.t27 avss avss nfet_05v0 ad=7.1896p pd=33.56u as=7.1896p ps=33.56u w=16.34u l=8u
X37 vbp_cas.t15 vbp_cas.t14 vbp_bias.t4 avdd.t129 pfet_05v0 ad=8.3292p pd=38.74u as=8.3292p ps=38.74u w=18.93u l=8u
X38 su_state.t2 vsu avdd.t222 avdd.t221 pfet_05v0 ad=0.44p pd=2.88u as=0.44p ps=2.88u w=1u l=8u
X39 vx2.t1 psrg_m3_feed.t23 avdd.t14 avdd.t13 pfet_05v0 ad=7.37p pd=34.38u as=7.37p ps=34.38u w=16.75u l=2u
X40 psrg_vnc.t5 vbp_i.t50 avdd.t156 avdd.t155 pfet_05v0 ad=7.8056p pd=36.36u as=7.8056p ps=36.36u w=17.74u l=4u
X41 pm1.t1 y1.t16 avdd.t167 avdd.t166 pfet_05v0 ad=9.1344p pd=42.4u as=9.1344p ps=42.4u w=20.76u l=4u
X42 vsu psrg_m3_feed.t8 avdd.t205 avdd.t204 pfet_05v0 ad=0.88p pd=4.88u as=0.88p ps=4.88u w=2u l=2u
X43 vbp_cas.t13 vbp_cas.t12 vbp_bias.t0 avdd.t6 pfet_05v0 ad=8.3292p pd=38.74u as=8.3292p ps=38.74u w=18.93u l=8u
X44 vbn_sink.t7 vbp_i.t26 avdd.t122 avdd.t121 pfet_05v0 ad=8.338p pd=38.78u as=8.338p ps=38.78u w=18.95u l=8u
X45 b2_b.t0 b2.t0 dvdd.t23 dvdd.t22 pfet_03v3 ad=1.32p pd=6.88u as=1.32p ps=6.88u w=3u l=0.5u
X46 vbn_sink.t2 vbp_i.t27 avdd.t92 avdd.t91 pfet_05v0 ad=8.338p pd=38.78u as=8.338p ps=38.78u w=18.95u l=8u
X47 b5_b.t0 b5.t0 dvdd.t14 dvdd.t13 pfet_03v3 ad=1.32p pd=6.88u as=1.32p ps=6.88u w=3u l=0.5u
X48 psrg_m3_feed.t0 vcasp vx2.t5 avdd.t25 pfet_05v0 ad=7.2248p pd=33.72u as=7.2248p ps=33.72u w=16.42u l=4u
X49 vgn2.t1 vbp_cas.t25 pm2.t7 avdd.t43 pfet_05v0 ad=9.7724p pd=45.3u as=9.7724p ps=45.3u w=22.21u l=8u
X50 xf2.t2 vbn_sink.t21 avss avss nfet_05v0 ad=7.1896p pd=33.56u as=7.1896p ps=33.56u w=16.34u l=8u
X51 vbp_cas.t11 vbp_cas.t10 vbp_bias.t6 avdd.t216 pfet_05v0 ad=8.3292p pd=38.74u as=8.3292p ps=38.74u w=18.93u l=8u
X52 vx1.t10 psrg_m3_feed.t13 avdd.t246 avdd.t245 pfet_05v0 ad=7.37p pd=34.38u as=7.37p ps=34.38u w=16.75u l=2u
X53 vref.t15 avss cap_mim_2f0fF c_width=70.7u c_length=70.7u
X54 vref.t4 vcasp vx3.t2 avdd.t30 pfet_05v0 ad=7.2248p pd=33.72u as=7.2248p ps=33.72u w=16.42u l=4u
X55 rbit1top.t7 b0_b.t3 rbit0top.t6 dvdd.t4 pfet_03v3 ad=17.6p pd=80.88u as=17.6p ps=80.88u w=40u l=0.28u
X56 vbp_i.t7 vbp_i.t6 avdd.t254 avdd.t253 pfet_05v0 ad=8.25p pd=38.38u as=8.25p ps=38.38u w=18.75u l=8u
X57 y1.t1 psrg_vnc.t9 psrg_mf1_protected.t0 avss nfet_05v0 ad=8.1356p pd=37.86u as=8.1356p ps=37.86u w=18.49u l=6u
X58 rbit0top.t0 rfix2 avss ppolyf_u_1k r_width=6.6u r_length=0.128m
X59 vbn_fold.t4 vbp_i.t19 avdd.t150 avdd.t149 pfet_05v0 ad=8.3556p pd=38.86u as=8.3556p ps=38.86u w=18.99u l=8u
X60 rbit4top.t4 b3_b.t2 rbit3top.t6 dvdd.t1 pfet_03v3 ad=13.2p pd=60.88u as=13.2p ps=60.88u w=30u l=0.28u
X61 rbit5top.t4 b4_b.t2 rbit4top.t3 dvdd.t10 pfet_03v3 ad=6.6p pd=30.88u as=6.6p ps=30.88u w=15u l=0.28u
X62 xf2.t1 vbn_sink.t29 avss avss nfet_05v0 ad=7.1896p pd=33.56u as=7.1896p ps=33.56u w=16.34u l=8u
X63 vbp_i.t3 vbp_i.t2 avdd.t256 avdd.t255 pfet_05v0 ad=8.25p pd=38.38u as=8.25p ps=38.38u w=18.75u l=8u
X64 rbit2top.t5 b1_b.t4 rbit1top.t9 dvdd.t5 pfet_03v3 ad=17.6p pd=80.88u as=17.6p ps=80.88u w=40u l=0.28u
X65 xf2.t8 v2.t4 vsp.t11 avdd.t185 pfet_05v0 ad=24.1516p pd=0.11066m as=24.1516p ps=0.11066m w=54.89u l=4u
X66 rbit4top.t5 b4.t2 rbit5top.t5 dvss nfet_03v3 ad=2.2p pd=10.88u as=2.2p ps=10.88u w=5u l=0.28u
X67 vbp_bias.t8 vbp_bias.t7 avdd.t136 avdd.t135 pfet_03v3 ad=8.3864p pd=39u as=8.3864p ps=39u w=19.06u l=8u
X68 vbn.t3 vbn.t2 avss avss nfet_05v0 ad=3.322p pd=15.98u as=3.322p ps=15.98u w=7.55u l=4u
X69 vbn_fold.t10 vbp_i.t16 avdd.t231 avdd.t230 pfet_05v0 ad=8.3556p pd=38.86u as=8.3556p ps=38.86u w=18.99u l=8u
X70 vsp.t9 vbp_tail.t9 avdd.t160 avdd.t159 pfet_03v3 ad=12.7204p pd=58.7u as=12.7204p ps=58.7u w=28.91u l=6u
X71 vx1.t9 psrg_m3_feed.t24 avdd.t211 avdd.t210 pfet_05v0 ad=7.37p pd=34.38u as=7.37p ps=34.38u w=16.75u l=2u
X72 vref.t6 avss cap_mim_2f0fF c_width=70.7u c_length=70.7u
X73 vbp_cas.t7 vbp_cas.t6 vbp_bias.t25 avdd.t217 pfet_05v0 ad=8.3292p pd=38.74u as=8.3292p ps=38.74u w=18.93u l=8u
X74 xf1.t11 v1.t3 vsp.t15 avdd.t261 pfet_05v0 ad=24.1516p pd=0.11066m as=24.1516p ps=0.11066m w=54.89u l=4u
X75 vaux.t2 psrg_m3_feed.t21 avdd.t215 avdd.t214 pfet_05v0 ad=4.4p pd=20.88u as=4.4p ps=20.88u w=10u l=2u
X76 vbp_tail.t0 vbn_i.t10 avss avss nfet_05v0 ad=6.138p pd=28.78u as=6.138p ps=28.78u w=13.95u l=8u
X77 xf1.t7 vbn_sink.t23 avss avss nfet_05v0 ad=7.1896p pd=33.56u as=7.1896p ps=33.56u w=16.34u l=8u
X78 y1.t5 vbp_cas.t26 pm1.t10 avdd.t218 pfet_05v0 ad=9.7724p pd=45.3u as=9.7724p ps=45.3u w=22.21u l=8u
X79 pm1.t3 y1.t12 avdd.t140 avdd.t139 pfet_05v0 ad=9.1344p pd=42.4u as=9.1344p ps=42.4u w=20.76u l=4u
X80 vbn_i.t0 vbp_i.t41 avdd.t60 avdd.t59 pfet_05v0 ad=8.25p pd=38.38u as=8.25p ps=38.38u w=18.75u l=8u
X81 vbp_cas.t9 vbp_cas.t8 vbp_bias.t2 avdd.t103 pfet_05v0 ad=8.3292p pd=38.74u as=8.3292p ps=38.74u w=18.93u l=8u
X82 psrg_vnc.t8 psrg_vnc.t7 rb_mid avss nfet_05v0 ad=0.3124p pd=2.3u as=0.3124p ps=2.3u w=0.71u l=20u
X83 psrg_vnc.t0 vbp_i.t51 avdd.t16 avdd.t15 pfet_05v0 ad=7.8056p pd=36.36u as=7.8056p ps=36.36u w=17.74u l=4u
X84 rfix0 vref.t5 avss ppolyf_u_1k r_width=6.6u r_length=0.128m
X85 vsp.t3 vbp_tail.t13 avdd.t75 avdd.t74 pfet_03v3 ad=12.7204p pd=58.7u as=12.7204p ps=58.7u w=28.91u l=6u
X86 vbp_cas.t5 vbp_cas.t4 vbp_bias.t26 avdd.t223 pfet_05v0 ad=8.3292p pd=38.74u as=8.3292p ps=38.74u w=18.93u l=8u
X87 pm2.t3 y1.t11 avdd.t138 avdd.t137 pfet_05v0 ad=9.1344p pd=42.4u as=9.1344p ps=42.4u w=20.76u l=4u
X88 vbp_cas.t3 vbp_cas.t2 vbp_bias.t1 avdd.t61 pfet_05v0 ad=8.3292p pd=38.74u as=8.3292p ps=38.74u w=18.93u l=8u
X89 vref.t14 avss cap_mim_2f0fF c_width=70.7u c_length=70.7u
X90 vbn_fold.t11 vbp_i.t21 avdd.t233 avdd.t232 pfet_05v0 ad=8.3556p pd=38.86u as=8.3556p ps=38.86u w=18.99u l=8u
X91 rbit3top.t0 rbit2top.t0 avss ppolyf_u_1k r_width=6.6u r_length=8u
X92 psrg_m3_feed.t7 psrg_vnc.t10 psrg_m3_protected.t1 avss nfet_05v0 ad=6.424p pd=30.08u as=6.424p ps=30.08u w=14.6u l=4u
X93 vbn_fold.t8 vbn_fold.t7 vnx_bias avss nfet_05v0 ad=2.0328p pd=10.12u as=2.0328p ps=10.12u w=4.62u l=6u
X94 vx3.t10 psrg_m3_feed.t12 avdd.t244 avdd.t243 pfet_05v0 ad=7.37p pd=34.38u as=7.37p ps=34.38u w=16.75u l=2u
X95 vbn_sink.t5 vbp_i.t34 avdd.t98 avdd.t97 pfet_05v0 ad=8.338p pd=38.78u as=8.338p ps=38.78u w=18.95u l=8u
X96 vbn_sink.t8 vbp_i.t47 avdd.t173 avdd.t172 pfet_05v0 ad=8.338p pd=38.78u as=8.338p ps=38.78u w=18.95u l=8u
X97 pm1.t2 y1.t13 avdd.t142 avdd.t141 pfet_05v0 ad=9.1344p pd=42.4u as=9.1344p ps=42.4u w=20.76u l=4u
X98 iref_gate.t2 vbp_i.t42 vsu1 avss nfet_05v0 ad=0.22p pd=1.88u as=0.22p ps=1.88u w=0.5u l=50u
X99 vbp_tail.t2 vbp_tail.t1 avdd.t184 avdd.t183 pfet_03v3 ad=6.05p pd=28.38u as=6.05p ps=28.38u w=13.75u l=6u
X100 vbp_i.t9 vbp_i.t8 avdd.t209 avdd.t208 pfet_05v0 ad=8.25p pd=38.38u as=8.25p ps=38.38u w=18.75u l=8u
X101 vbn_fold.t2 vbp_i.t18 avdd.t90 avdd.t89 pfet_05v0 ad=8.3556p pd=38.86u as=8.3556p ps=38.86u w=18.99u l=8u
X102 rfix1 rfix0 avss ppolyf_u_1k r_width=6.6u r_length=0.128m
X103 vbn_fold.t0 vbp_i.t11 avdd.t86 avdd.t85 pfet_05v0 ad=8.3556p pd=38.86u as=8.3556p ps=38.86u w=18.99u l=8u
X104 xf2.t0 vbn_sink.t28 avss avss nfet_05v0 ad=7.1896p pd=33.56u as=7.1896p ps=33.56u w=16.34u l=8u
X105 y1.t2 vbp_cas.t22 pm1.t7 avdd.t82 pfet_05v0 ad=9.7724p pd=45.3u as=9.7724p ps=45.3u w=22.21u l=8u
X106 vbp_bias.t18 vbp_bias.t17 avdd.t227 avdd.t226 pfet_03v3 ad=8.3864p pd=39u as=8.3864p ps=39u w=19.06u l=8u
X107 vref.t8 avss cap_mim_2f0fF c_width=70.7u c_length=70.7u
X108 rbit3top.t5 b3.t2 rbit4top.t1 dvss nfet_03v3 ad=4.4p pd=20.88u as=4.4p ps=20.88u w=10u l=0.28u
X109 vx2.t10 psrg_m3_feed.t20 avdd.t213 avdd.t212 pfet_05v0 ad=7.37p pd=34.38u as=7.37p ps=34.38u w=16.75u l=2u
X110 vx3.t9 psrg_m3_feed.t11 avdd.t193 avdd.t192 pfet_05v0 ad=7.37p pd=34.38u as=7.37p ps=34.38u w=16.75u l=2u
X111 y1.t0 vbp_cas.t23 pm1.t6 avdd.t41 pfet_05v0 ad=9.7724p pd=45.3u as=9.7724p ps=45.3u w=22.21u l=8u
X112 bgsu1 bgsu1 bgsu2 avss nfet_03v3 ad=0.44p pd=2.88u as=0.44p ps=2.88u w=1u l=2u
X113 vbp_cas.t1 vbp_cas.t0 vbp_bias.t3 avdd.t123 pfet_05v0 ad=8.3292p pd=38.74u as=8.3292p ps=38.74u w=18.93u l=8u
X114 rbit1top.t3 b0_b.t7 rbit0top.t2 dvdd.t3 pfet_03v3 ad=17.6p pd=80.88u as=17.6p ps=80.88u w=40u l=0.28u
X115 rbit1top.t6 b0_b.t4 rbit0top.t3 dvdd.t16 pfet_03v3 ad=17.6p pd=80.88u as=17.6p ps=80.88u w=40u l=0.28u
X116 vref.t12 avss cap_mim_2f0fF c_width=70.7u c_length=70.7u
X117 xf2.t4 v2.t3 vsp.t6 avdd.t112 pfet_05v0 ad=24.1516p pd=0.11066m as=24.1516p ps=0.11066m w=54.89u l=4u
X118 b3_b.t1 b3.t1 dvss dvss nfet_03v3 ad=0.44p pd=2.88u as=0.44p ps=2.88u w=1u l=0.5u
X119 y1.t6 vbp_cas.t27 pm1.t11 avdd.t219 pfet_05v0 ad=9.7724p pd=45.3u as=9.7724p ps=45.3u w=22.21u l=8u
X120 xf1.t6 vbn_sink.t22 avss avss nfet_05v0 ad=7.1896p pd=33.56u as=7.1896p ps=33.56u w=16.34u l=8u
X121 xf1.t10 vbn_sink.t31 avss avss nfet_05v0 ad=7.1896p pd=33.56u as=7.1896p ps=33.56u w=16.34u l=8u
X122 vbn_sink.t0 vbp_i.t29 avdd.t52 avdd.t51 pfet_05v0 ad=8.338p pd=38.78u as=8.338p ps=38.78u w=18.95u l=8u
X123 vx2.t9 psrg_m3_feed.t9 avdd.t177 avdd.t176 pfet_05v0 ad=7.37p pd=34.38u as=7.37p ps=34.38u w=16.75u l=2u
X124 vgn1.t6 vgn1.t5 v1.t1 avss nfet_05v0 ad=6.424p pd=30.08u as=6.424p ps=30.08u w=14.6u l=4u
X125 vbp_i.t1 vbp_i.t0 avdd.t5 avdd.t4 pfet_05v0 ad=8.25p pd=38.38u as=8.25p ps=38.38u w=18.75u l=8u
X126 iref_gate.t1 vbp_i.t36 avdd.t58 avdd.t57 pfet_05v0 ad=35.2p pd=0.16088m as=35.2p ps=0.16088m w=80u l=1u
X127 vsp.t13 vbp_tail.t11 avdd.t189 avdd.t188 pfet_03v3 ad=12.7204p pd=58.7u as=12.7204p ps=58.7u w=28.91u l=6u
X128 su_state.t1 vgn2.t8 avss avss nfet_05v0 ad=1.76p pd=8.88u as=1.76p ps=8.88u w=4u l=1u
X129 b5_b.t1 b5.t2 dvss dvss nfet_03v3 ad=0.44p pd=2.88u as=0.44p ps=2.88u w=1u l=0.5u
X130 b6_b.t0 b6.t0 dvdd.t12 dvdd.t11 pfet_03v3 ad=1.32p pd=6.88u as=1.32p ps=6.88u w=3u l=0.5u
X131 psrg_m3_feed.t3 vcasp vx2.t3 avdd.t37 pfet_05v0 ad=7.2248p pd=33.72u as=7.2248p ps=33.72u w=16.42u l=4u
X132 vbn_sink.t17 vbp_i.t43 avdd.t237 avdd.t236 pfet_05v0 ad=8.338p pd=38.78u as=8.338p ps=38.78u w=18.95u l=8u
X133 psrg_m3_feed.t6 psrg_vnc.t11 psrg_m3_protected.t0 avss nfet_05v0 ad=6.424p pd=30.08u as=6.424p ps=30.08u w=14.6u l=4u
X134 pm1.t4 y1.t9 avdd.t144 avdd.t143 pfet_05v0 ad=9.1344p pd=42.4u as=9.1344p ps=42.4u w=20.76u l=4u
X135 vbn_sink.t1 vbp_i.t30 avdd.t54 avdd.t53 pfet_05v0 ad=8.338p pd=38.78u as=8.338p ps=38.78u w=18.95u l=8u
X136 vbp_tail.t6 vbp_tail.t5 avdd.t134 avdd.t133 pfet_03v3 ad=6.05p pd=28.38u as=6.05p ps=28.38u w=13.75u l=6u
X137 vbn_fold.t5 vbp_i.t20 avdd.t152 avdd.t151 pfet_05v0 ad=8.3556p pd=38.86u as=8.3556p ps=38.86u w=18.99u l=8u
X138 vbn_sink.t18 vbp_i.t44 avdd.t239 avdd.t238 pfet_05v0 ad=8.338p pd=38.78u as=8.338p ps=38.78u w=18.95u l=8u
X139 xf2.t9 vbn_sink.t25 avss avss nfet_05v0 ad=7.1896p pd=33.56u as=7.1896p ps=33.56u w=16.34u l=8u
X140 vbn_sink.t19 vbp_i.t31 avdd.t249 avdd.t248 pfet_05v0 ad=8.338p pd=38.78u as=8.338p ps=38.78u w=18.95u l=8u
X141 b1_b.t0 b1.t2 dvdd.t21 dvdd.t20 pfet_03v3 ad=1.32p pd=6.88u as=1.32p ps=6.88u w=3u l=0.5u
X142 vq3.t0 b6_b.t2 rbit6top.t1 dvdd.t7 pfet_03v3 ad=1.65p pd=8.38u as=1.65p ps=8.38u w=3.75u l=0.28u
X143 vq3.t2 rbit6top.t5 avss ppolyf_u_1k r_width=6.6u r_length=0.128m
X144 psrg_vnc.t6 vbp_i.t48 avdd.t175 avdd.t174 pfet_05v0 ad=7.8056p pd=36.36u as=7.8056p ps=36.36u w=17.74u l=4u
X145 y1.t4 vbp_cas.t31 pm1.t9 avdd.t182 pfet_05v0 ad=9.7724p pd=45.3u as=9.7724p ps=45.3u w=22.21u l=8u
X146 rbit3top.t2 b2_b.t4 rbit2top.t1 dvdd.t15 pfet_03v3 ad=8.8p pd=40.88u as=8.8p ps=40.88u w=20u l=0.28u
X147 vgn2.t4 vbn_fold.t15 xf2.t3 avss nfet_05v0 ad=8.1356p pd=37.86u as=8.1356p ps=37.86u w=18.49u l=6u
X148 vgn2.t0 vbp_cas.t24 pm2.t6 avdd.t42 pfet_05v0 ad=9.7724p pd=45.3u as=9.7724p ps=45.3u w=22.21u l=8u
X149 vbn_i.t1 vbp_i.t39 avdd.t100 avdd.t99 pfet_05v0 ad=8.25p pd=38.38u as=8.25p ps=38.38u w=18.75u l=8u
X150 vbp_tail.t4 vbp_tail.t3 avdd.t47 avdd.t46 pfet_03v3 ad=6.05p pd=28.38u as=6.05p ps=28.38u w=13.75u l=6u
X151 vbp_i.t5 vbp_i.t4 avdd.t207 avdd.t206 pfet_05v0 ad=8.25p pd=38.38u as=8.25p ps=38.38u w=18.75u l=8u
X152 vbn.t0 vcasp vaux.t1 avdd.t40 pfet_05v0 ad=7.04p pd=32.88u as=7.04p ps=32.88u w=16u l=4u
X153 vsua vcasp avdd.t22 avdd.t21 pfet_05v0 ad=0.88p pd=4.88u as=0.88p ps=4.88u w=2u l=2u
X154 rbit2top.t8 b2.t2 rbit3top.t7 dvss nfet_03v3 ad=8.8p pd=40.88u as=8.8p ps=40.88u w=20u l=0.28u
X155 pm2.t0 y1.t18 avdd.t171 avdd.t170 pfet_05v0 ad=9.1344p pd=42.4u as=9.1344p ps=42.4u w=20.76u l=4u
X156 vx2.t0 psrg_m3_feed.t28 avdd.t3 avdd.t2 pfet_05v0 ad=7.37p pd=34.38u as=7.37p ps=34.38u w=16.75u l=2u
X157 vsp.t12 vbp_tail.t10 avdd.t187 avdd.t186 pfet_03v3 ad=12.7204p pd=58.7u as=12.7204p ps=58.7u w=28.91u l=6u
X158 rbit5top.t2 b5.t1 rbit6top.t4 dvss nfet_03v3 ad=1.1p pd=5.88u as=1.1p ps=5.88u w=2.5u l=0.28u
X159 rbit1top.t1 rbit0top.t1 avss ppolyf_u_1k r_width=6.6u r_length=2u
X160 vx1.t8 psrg_m3_feed.t10 avdd.t191 avdd.t190 pfet_05v0 ad=7.37p pd=34.38u as=7.37p ps=34.38u w=16.75u l=2u
X161 vx1.t0 psrg_m3_feed.t19 avdd.t10 avdd.t9 pfet_05v0 ad=7.37p pd=34.38u as=7.37p ps=34.38u w=16.75u l=2u
X162 vaux.t0 psrg_m3_feed.t22 avdd.t12 avdd.t11 pfet_05v0 ad=4.4p pd=20.88u as=4.4p ps=20.88u w=10u l=2u
X163 vsp.t1 vbp_tail.t8 avdd.t71 avdd.t70 pfet_03v3 ad=12.7204p pd=58.7u as=12.7204p ps=58.7u w=28.91u l=6u
X164 b4_b.t0 b4.t0 dvdd.t27 dvdd.t26 pfet_03v3 ad=1.32p pd=6.88u as=1.32p ps=6.88u w=3u l=0.5u
X165 vbn_sink.t11 vbp_i.t45 avdd.t199 avdd.t198 pfet_05v0 ad=8.338p pd=38.78u as=8.338p ps=38.78u w=18.95u l=8u
X166 vbn_sink.t20 vbp_i.t32 avdd.t251 avdd.t250 pfet_05v0 ad=8.338p pd=38.78u as=8.338p ps=38.78u w=18.95u l=8u
X167 rbit2top.t7 b1_b.t2 rbit1top.t10 dvdd.t8 pfet_03v3 ad=17.6p pd=80.88u as=17.6p ps=80.88u w=40u l=0.28u
X168 pm1.t5 y1.t8 avdd.t128 avdd.t127 pfet_05v0 ad=9.1344p pd=42.4u as=9.1344p ps=42.4u w=20.76u l=4u
X169 pm2.t2 y1.t14 avdd.t163 avdd.t162 pfet_05v0 ad=9.1344p pd=42.4u as=9.1344p ps=42.4u w=20.76u l=4u
X170 vbn_sink.t12 vbp_i.t46 avdd.t201 avdd.t200 pfet_05v0 ad=8.338p pd=38.78u as=8.338p ps=38.78u w=18.95u l=8u
X171 vbp_bias.t16 vbp_bias.t15 avdd.t225 avdd.t224 pfet_03v3 ad=8.3864p pd=39u as=8.3864p ps=39u w=19.06u l=8u
X172 vbn_fold.t6 vbp_i.t13 avdd.t203 avdd.t202 pfet_05v0 ad=8.3556p pd=38.86u as=8.3556p ps=38.86u w=18.99u l=8u
X173 vbn_sink.t4 vbp_i.t33 avdd.t96 avdd.t95 pfet_05v0 ad=8.338p pd=38.78u as=8.338p ps=38.78u w=18.95u l=8u
X174 b1_b.t1 b1.t1 dvss dvss nfet_03v3 ad=0.44p pd=2.88u as=0.44p ps=2.88u w=1u l=0.5u
X175 vgn2.t6 vbp_cas.t32 pm2.t11 avdd.t252 pfet_05v0 ad=9.7724p pd=45.3u as=9.7724p ps=45.3u w=22.21u l=8u
X176 xf1.t0 vbn_sink.t30 avss avss nfet_05v0 ad=7.1896p pd=33.56u as=7.1896p ps=33.56u w=16.34u l=8u
X177 rbit1top.t2 b1.t0 rbit2top.t4 dvss nfet_03v3 ad=17.6p pd=80.88u as=17.6p ps=80.88u w=40u l=0.28u
X178 vq2 v2.t0 avss ppolyf_u_1k r_width=4u r_length=42.1u
X179 psrg_m3_feed.t1 vcasp vx2.t4 avdd.t27 pfet_05v0 ad=7.2248p pd=33.72u as=7.2248p ps=33.72u w=16.42u l=4u
X180 b4_b.t1 b4.t1 dvss dvss nfet_03v3 ad=0.44p pd=2.88u as=0.44p ps=2.88u w=1u l=0.5u
X181 xf2.t7 v2.t6 vsp.t10 avdd.t161 pfet_05v0 ad=24.1516p pd=0.11066m as=24.1516p ps=0.11066m w=54.89u l=4u
X182 pm2.t4 y1.t10 avdd.t146 avdd.t145 pfet_05v0 ad=9.1344p pd=42.4u as=9.1344p ps=42.4u w=20.76u l=4u
X183 vref.t0 vcasp vx3.t5 avdd.t39 pfet_05v0 ad=7.2248p pd=33.72u as=7.2248p ps=33.72u w=16.42u l=4u
X184 vref.t10 avss cap_mim_2f0fF c_width=70.7u c_length=70.7u
X185 vref.t11 avss cap_mim_2f0fF c_width=70.7u c_length=70.7u
X186 vgn1.t0 vcasp vx1.t3 avdd.t32 pfet_05v0 ad=7.2248p pd=33.72u as=7.2248p ps=33.72u w=16.42u l=4u
X187 vbn_i.t5 iref_gate.t3 avdd.t158 avdd.t157 pfet_05v0 ad=0.22p pd=1.88u as=0.22p ps=1.88u w=0.5u l=8u
X188 vnx_bias vnx_bias avss avss nfet_03v3 ad=0.7128p pd=4.12u as=0.7128p ps=4.12u w=1.62u l=8u
X189 xf2.t6 vbn_sink.t24 avss avss nfet_05v0 ad=7.1896p pd=33.56u as=7.1896p ps=33.56u w=16.34u l=8u
X190 xf1.t3 v1.t5 vsp.t5 avdd.t106 pfet_05v0 ad=24.1516p pd=0.11066m as=24.1516p ps=0.11066m w=54.89u l=4u
X191 vbp_i.t10 vbn_i.t11 net4 avss nfet_05v0 ad=4.0172p pd=19.14u as=4.0172p ps=19.14u w=9.13u l=8u
X192 pm1.t0 y1.t17 avdd.t169 avdd.t168 pfet_05v0 ad=9.1344p pd=42.4u as=9.1344p ps=42.4u w=20.76u l=4u
X193 iref_gate.t0 vbp_i.t35 avdd.t56 avdd.t55 pfet_05v0 ad=35.2p pd=0.16088m as=35.2p ps=0.16088m w=80u l=1u
X194 xf2.t5 v2.t7 vsp.t8 avdd.t118 pfet_05v0 ad=24.1516p pd=0.11066m as=24.1516p ps=0.11066m w=54.89u l=4u
X195 rbit1top.t5 b0_b.t5 rbit0top.t7 dvdd.t25 pfet_03v3 ad=17.6p pd=80.88u as=17.6p ps=80.88u w=40u l=0.28u
X196 bgsu2 bgsu2 avss avss nfet_03v3 ad=0.44p pd=2.88u as=0.44p ps=2.88u w=1u l=2u
X197 vbn_i.t4 vbp_i.t38 avdd.t110 avdd.t109 pfet_05v0 ad=8.25p pd=38.38u as=8.25p ps=38.38u w=18.75u l=8u
X198 b0_b.t1 b0.t0 dvss dvss nfet_03v3 ad=0.44p pd=2.88u as=0.44p ps=2.88u w=1u l=0.5u
X199 rbit6top.t2 b6.t1 vq3.t1 dvss nfet_03v3 ad=0.55p pd=3.38u as=0.55p ps=3.38u w=1.25u l=0.28u
X200 psrg_vnc.t2 vbp_i.t53 avdd.t114 avdd.t113 pfet_05v0 ad=7.8056p pd=36.36u as=7.8056p ps=36.36u w=17.74u l=4u
X201 vbn_fold.t12 vbp_i.t22 avdd.t235 avdd.t234 pfet_05v0 ad=8.3556p pd=38.86u as=8.3556p ps=38.86u w=18.99u l=8u
X202 auxsu1 auxsu1 auxsu2 avss nfet_03v3 ad=0.44p pd=2.88u as=0.44p ps=2.88u w=1u l=2u
X203 psrg_m3_protected.t3 vgn2.t10 v2.t2 avss nfet_05v0 ad=6.424p pd=30.08u as=6.424p ps=30.08u w=14.6u l=4u
X204 vbn_fold.t9 vbp_i.t15 avdd.t229 avdd.t228 pfet_05v0 ad=8.3556p pd=38.86u as=8.3556p ps=38.86u w=18.99u l=8u
X205 aux_gate vbn_i.t8 avss avss nfet_05v0 ad=0.44p pd=2.88u as=0.44p ps=2.88u w=1u l=8u
X206 vsu1 vbp_i.t56 vsu2 avss nfet_05v0 ad=0.22p pd=1.88u as=0.22p ps=1.88u w=0.5u l=50u
X207 vgn1.t3 vcasp vx1.t5 avdd.t36 pfet_05v0 ad=7.2248p pd=33.72u as=7.2248p ps=33.72u w=16.42u l=4u
X208 vbp_cas.t20 vbn_i.t9 avss avss nfet_05v0 ad=0.286p pd=2.18u as=0.286p ps=2.18u w=0.65u l=8u
X209 pm2.t5 y1.t7 avdd.t179 avdd.t178 pfet_05v0 ad=9.1344p pd=42.4u as=9.1344p ps=42.4u w=20.76u l=4u
X210 vx1.t6 psrg_m3_feed.t27 avdd.t63 avdd.t62 pfet_05v0 ad=7.37p pd=34.38u as=7.37p ps=34.38u w=16.75u l=2u
X211 b6_b.t1 b6.t2 dvss dvss nfet_03v3 ad=0.44p pd=2.88u as=0.44p ps=2.88u w=1u l=0.5u
X212 psrg_mf1_protected.t1 vbn_fold.t14 xf1.t4 avss nfet_05v0 ad=8.1356p pd=37.86u as=8.1356p ps=37.86u w=18.49u l=6u
X213 vbn.t1 aux_gate avdd.t126 avdd.t125 pfet_05v0 ad=0.22p pd=1.88u as=0.22p ps=1.88u w=0.5u l=8u
X214 vsu2 vbp_i.t55 avss avss nfet_05v0 ad=0.22p pd=1.88u as=0.22p ps=1.88u w=0.5u l=50u
X215 vx3.t0 psrg_m3_feed.t18 avdd.t8 avdd.t7 pfet_05v0 ad=7.37p pd=34.38u as=7.37p ps=34.38u w=16.75u l=2u
X216 vgn2.t5 vbp_cas.t28 pm2.t10 avdd.t220 pfet_05v0 ad=9.7724p pd=45.3u as=9.7724p ps=45.3u w=22.21u l=8u
X217 vbp_bias.t24 vbp_bias.t23 avdd.t260 avdd.t259 pfet_03v3 ad=8.3864p pd=39u as=8.3864p ps=39u w=19.06u l=8u
X218 vcasp vbn.t4 avss avss nfet_05v0 ad=3.322p pd=15.98u as=3.322p ps=15.98u w=7.55u l=4u
X219 avss net3 avdd.t111 pplus_u r_width=1u r_length=0.23253m
X220 vgn1.t9 aux_gate psrg_m3_feed.t5 avdd.t124 pfet_05v0 ad=0.88p pd=4.88u as=0.88p ps=4.88u w=2u l=2u
X221 vcasp vcasp avdd.t20 avdd.t19 pfet_05v0 ad=0.396p pd=2.68u as=0.396p ps=2.68u w=0.9u l=2u
X222 psrg_vnc.t4 vbp_i.t49 avdd.t154 avdd.t153 pfet_05v0 ad=7.8056p pd=36.36u as=7.8056p ps=36.36u w=17.74u l=4u
X223 vsp.t2 vbp_tail.t12 avdd.t73 avdd.t72 pfet_03v3 ad=12.7204p pd=58.7u as=12.7204p ps=58.7u w=28.91u l=6u
X224 b2_b.t1 b2.t1 dvss dvss nfet_03v3 ad=0.44p pd=2.88u as=0.44p ps=2.88u w=1u l=0.5u
X225 vgn2.t3 vbp_cas.t29 pm2.t9 avdd.t180 pfet_05v0 ad=9.7724p pd=45.3u as=9.7724p ps=45.3u w=22.21u l=8u
X226 vbn_i.t7 vbn_i.t6 avss avss nfet_05v0 ad=3.4232p pd=16.44u as=3.4232p ps=16.44u w=7.78u l=8u
X227 vbp_bias.t20 vbp_bias.t19 avdd.t105 avdd.t104 pfet_03v3 ad=8.3864p pd=39u as=8.3864p ps=39u w=19.06u l=8u
X228 rbit3top.t4 b2_b.t2 rbit2top.t9 dvdd.t24 pfet_03v3 ad=8.8p pd=40.88u as=8.8p ps=40.88u w=20u l=0.28u
X229 rbit5top.t3 rbit4top.t2 avss ppolyf_u_1k r_width=6.6u r_length=32u
X230 vbn_i.t3 vbp_i.t37 avdd.t108 avdd.t107 pfet_05v0 ad=8.25p pd=38.38u as=8.25p ps=38.38u w=18.75u l=8u
X231 auxsu2 auxsu2 avss avss nfet_03v3 ad=0.44p pd=2.88u as=0.44p ps=2.88u w=1u l=2u
X232 vbn_sink.t3 vbp_i.t28 avdd.t94 avdd.t93 pfet_05v0 ad=8.338p pd=38.78u as=8.338p ps=38.78u w=18.95u l=8u
X233 vbn_sink.t16 vbn_sink.t15 avss avss nfet_05v0 ad=5.4164p pd=25.5u as=5.4164p ps=25.5u w=12.31u l=8u
X234 vgn1.t8 vgn1.t7 v1.t0 avss nfet_05v0 ad=6.424p pd=30.08u as=6.424p ps=30.08u w=14.6u l=4u
X235 b0_b.t0 b0.t1 dvdd.t29 dvdd.t28 pfet_03v3 ad=1.32p pd=6.88u as=1.32p ps=6.88u w=3u l=0.5u
X236 rbit2top.t2 rbit1top.t0 avss ppolyf_u_1k r_width=6.6u r_length=4u
X237 vref.t9 avss cap_mim_2f0fF c_width=70.7u c_length=70.7u
X238 vbn_fold.t13 vbp_i.t12 avdd.t241 avdd.t240 pfet_05v0 ad=8.3556p pd=38.86u as=8.3556p ps=38.86u w=18.99u l=8u
X239 vref.t13 avss cap_mim_2f0fF c_width=70.7u c_length=70.7u
X240 xf1.t5 v1.t4 vsp.t7 avdd.t117 pfet_05v0 ad=24.1516p pd=0.11066m as=24.1516p ps=0.11066m w=54.89u l=4u
X241 psrg_m3_feed.t4 vcasp vx2.t6 avdd.t38 pfet_05v0 ad=7.2248p pd=33.72u as=7.2248p ps=33.72u w=16.42u l=4u
X242 rbit1top.t8 b0_b.t2 rbit0top.t5 dvdd.t2 pfet_03v3 ad=17.6p pd=80.88u as=17.6p ps=80.88u w=40u l=0.28u
X243 vgn1.t4 vcasp vx1.t2 avdd.t29 pfet_05v0 ad=7.2248p pd=33.72u as=7.2248p ps=33.72u w=16.42u l=4u
X244 vsua vsua auxsu1 avss nfet_05v0 ad=0.44p pd=2.88u as=0.44p ps=2.88u w=1u l=2u
X245 xf1.t2 v1.t6 vsp.t4 avdd.t80 pfet_05v0 ad=24.1516p pd=0.11066m as=24.1516p ps=0.11066m w=54.89u l=4u
X246 vx3.t7 psrg_m3_feed.t17 avdd.t79 avdd.t78 pfet_05v0 ad=7.37p pd=34.38u as=7.37p ps=34.38u w=16.75u l=2u
X247 psrg_vnc.t1 vbp_i.t52 avdd.t18 avdd.t17 pfet_05v0 ad=7.8056p pd=36.36u as=7.8056p ps=36.36u w=17.74u l=4u
X248 rbit1top.t4 b0_b.t6 rbit0top.t4 dvdd.t9 pfet_03v3 ad=17.6p pd=80.88u as=17.6p ps=80.88u w=40u l=0.28u
X249 vref.t3 vcasp vx3.t4 avdd.t34 pfet_05v0 ad=7.2248p pd=33.72u as=7.2248p ps=33.72u w=16.42u l=4u
X250 psrg_m3_protected.t2 vgn2.t9 v2.t1 avss nfet_05v0 ad=6.424p pd=30.08u as=6.424p ps=30.08u w=14.6u l=4u
X251 rbit2top.t6 b1_b.t3 rbit1top.t11 dvdd.t6 pfet_03v3 ad=17.6p pd=80.88u as=17.6p ps=80.88u w=40u l=0.28u
X252 psrg_vnc.t3 vbp_i.t54 avdd.t116 avdd.t115 pfet_05v0 ad=7.8056p pd=36.36u as=7.8056p ps=36.36u w=17.74u l=4u
X253 vbn_fold.t1 vbp_i.t17 avdd.t88 avdd.t87 pfet_05v0 ad=8.3556p pd=38.86u as=8.3556p ps=38.86u w=18.99u l=8u
X254 vx2.t8 psrg_m3_feed.t15 avdd.t69 avdd.t68 pfet_05v0 ad=7.37p pd=34.38u as=7.37p ps=34.38u w=16.75u l=2u
X255 pm2.t1 y1.t15 avdd.t165 avdd.t164 pfet_05v0 ad=9.1344p pd=42.4u as=9.1344p ps=42.4u w=20.76u l=4u
X256 vbp_cas.t19 vbp_cas.t18 vbp_bias.t27 avdd.t247 pfet_05v0 ad=8.3292p pd=38.74u as=8.3292p ps=38.74u w=18.93u l=8u
X257 vbn_sink.t9 vbp_i.t23 avdd.t195 avdd.t194 pfet_05v0 ad=8.338p pd=38.78u as=8.338p ps=38.78u w=18.95u l=8u
X258 y1.t3 vbp_cas.t30 pm1.t8 avdd.t181 pfet_05v0 ad=9.7724p pd=45.3u as=9.7724p ps=45.3u w=22.21u l=8u
X259 rbit0top.t8 b0.t3 rbit1top.t12 dvss nfet_03v3 ad=17.6p pd=80.88u as=17.6p ps=80.88u w=40u l=0.28u
X260 vgn1.t1 vcasp vx1.t4 avdd.t35 pfet_05v0 ad=7.2248p pd=33.72u as=7.2248p ps=33.72u w=16.42u l=4u
R0 vref.n6 vref.n5 54.8555
R1 vref vref.n14 53.933
R2 vref.n11 vref.t12 34.6185
R3 vref.n13 vref.t11 34.6113
R4 vref.n9 vref.t13 34.6062
R5 vref.n0 vref.t14 26.519
R6 vref.n6 vref.n0 25.385
R7 vref.n1 vref.t0 18.6289
R8 vref.n5 vref.n4 18.4955
R9 vref.n8 vref.n7 17.2532
R10 vref.n3 vref.t4 15.7039
R11 vref.n1 vref.t3 13.8139
R12 vref.n2 vref.n1 10.4855
R13 vref.n5 vref.t5 10.0775
R14 vref.n2 vref.t2 9.27598
R15 vref.n4 vref.t1 9.27277
R16 vref.n0 vref.t15 9.22104
R17 vref.n7 vref.t10 9.22104
R18 vref.n8 vref.t9 9.22104
R19 vref.n10 vref.t8 9.22104
R20 vref.n12 vref.t7 9.22104
R21 vref.n14 vref.t6 9.22104
R22 vref.n4 vref.n3 9.1355
R23 vref.n9 vref.n8 9.08246
R24 vref.n11 vref.n10 9.01336
R25 vref.n13 vref.n12 8.98764
R26 vref.n14 vref.n13 8.303
R27 vref.n7 vref.n6 8.2805
R28 vref.n12 vref.n11 8.24996
R29 vref.n10 vref.n9 8.20496
R30 vref.n3 vref.n2 4.6355
R31 b1.n1 b1.t0 553.995
R32 b1.n0 b1.t2 52.3518
R33 b1.n0 b1.t1 34.9128
R34 b1 b1.n1 34.0655
R35 b1.n1 b1.n0 8.7305
R36 b2.n0 b2.t2 299.99
R37 b2.n1 b2.t0 44.8554
R38 b2.n0 b2.t1 30.7964
R39 b2 b2.n1 27.8105
R40 b2.n1 b2.n0 23.4005
R41 b6 b6.n1 46.0805
R42 b6.n1 b6.t0 44.9115
R43 b6.n0 b6.t2 44.5322
R44 b6.n0 b6.t1 42.8627
R45 b6.n1 b6.n0 11.8355
R46 b5.n0 b5.t1 63.7544
R47 b5.n0 b5.t2 49.1564
R48 b5.n1 b5.t0 45.1489
R49 b5 b5.n1 37.0805
R50 b5.n1 b5.n0 6.2105
R51 b0.n0 b0.t3 557.883
R52 b0.n0 b0.t2 547.923
R53 b0.n1 b0.t1 44.9587
R54 b0 b0.n2 44.2355
R55 b0.n2 b0.t0 37.0514
R56 b0.n1 b0.n0 19.4405
R57 b0.n2 b0.n1 8.9555
R58 b4.n0 b4.t2 109.124
R59 b4.n1 b4.t0 49.3969
R60 b4 b4.n1 41.0855
R61 b4.n0 b4.t1 35.1074
R62 b4.n1 b4.n0 25.2455
R63 b3.n0 b3.t2 178.858
R64 b3.n1 b3.t0 44.8894
R65 b3 b3.n1 38.0705
R66 b3.n0 b3.t1 37.0593
R67 b3.n1 b3.n0 17.2355
R68 avdd.n76 avdd.t23 770.683
R69 avdd.n256 avdd.t157 648.068
R70 avdd.n260 avdd.t125 648.035
R71 avdd.n254 avdd.t221 582.449
R72 avdd.n261 avdd.t0 577.782
R73 avdd.n69 avdd.t19 243.499
R74 avdd.n181 avdd.t204 202.047
R75 avdd.n255 avdd.t124 200.303
R76 avdd.n163 avdd.t21 197.447
R77 avdd.n183 avdd.t133 132.115
R78 avdd.n364 avdd.t46 131.555
R79 avdd.n184 avdd.t183 131.519
R80 avdd.n283 avdd.t234 130.395
R81 avdd.n218 avdd.t217 129.167
R82 avdd.n380 avdd.t99 128.993
R83 avdd.n376 avdd.t253 128.993
R84 avdd.n371 avdd.t107 128.993
R85 avdd.n383 avdd.t206 128.993
R86 avdd.n387 avdd.t101 128.993
R87 avdd.n392 avdd.t59 128.993
R88 avdd.n378 avdd.t109 128.962
R89 avdd.n373 avdd.t208 128.962
R90 avdd.n384 avdd.t255 128.962
R91 avdd.n125 avdd.t4 128.962
R92 avdd.n206 avdd.t236 128.696
R93 avdd.n202 avdd.t172 128.25
R94 avdd.n59 avdd.t97 128.185
R95 avdd.n251 avdd.t130 128.081
R96 avdd.n249 avdd.t6 128.081
R97 avdd.n227 avdd.t103 128.081
R98 avdd.n220 avdd.t61 128.043
R99 avdd.n252 avdd.t247 128.02
R100 avdd.n250 avdd.t129 128.02
R101 avdd.n332 avdd.t196 128.012
R102 avdd.n327 avdd.t121 128.012
R103 avdd.n324 avdd.t93 128.012
R104 avdd.n337 avdd.t53 128.005
R105 avdd.n341 avdd.t250 128.005
R106 avdd.n286 avdd.t194 127.98
R107 avdd.n208 avdd.t198 127.98
R108 avdd.n329 avdd.t119 127.98
R109 avdd.n338 avdd.t248 127.974
R110 avdd.n11 avdd.t95 127.974
R111 avdd.n205 avdd.t238 127.942
R112 avdd.n116 avdd.t259 127.885
R113 avdd.n241 avdd.t147 127.785
R114 avdd.n243 avdd.t151 127.785
R115 avdd.n237 avdd.t240 127.785
R116 avdd.n278 avdd.t230 127.785
R117 avdd.n238 avdd.t85 127.743
R118 avdd.n232 avdd.t202 127.743
R119 avdd.n275 avdd.t228 127.743
R120 avdd.n245 avdd.t149 127.727
R121 avdd.n274 avdd.t232 127.727
R122 avdd.n112 avdd.t131 127.188
R123 avdd.n115 avdd.t257 127.169
R124 avdd.n402 avdd.t64 127.151
R125 avdd.n396 avdd.t224 127.151
R126 avdd.n109 avdd.t49 127.118
R127 avdd.n119 avdd.t226 127.102
R128 avdd.n118 avdd.t104 127.102
R129 avdd.n221 avdd.t123 123.581
R130 avdd.n217 avdd.t223 123.581
R131 avdd.n248 avdd.t216 123.52
R132 avdd.n323 avdd.t91 123.48
R133 avdd.n225 avdd.t51 123.474
R134 avdd.n212 avdd.t200 123.442
R135 avdd.n264 avdd.t89 123.285
R136 avdd.n263 avdd.t87 123.227
R137 avdd.n111 avdd.t135 122.688
R138 avdd.n358 avdd.t43 114.159
R139 avdd.n356 avdd.t41 114.159
R140 avdd.n192 avdd.t81 114.159
R141 avdd.n198 avdd.t182 114.147
R142 avdd.n350 avdd.t219 114.147
R143 avdd.n360 avdd.t218 114.127
R144 avdd.n357 avdd.t42 114.127
R145 avdd.n196 avdd.t252 114.088
R146 avdd.n199 avdd.t181 114.088
R147 avdd.n351 avdd.t220 114.088
R148 avdd.n352 avdd.t180 109.647
R149 avdd.n191 avdd.t82 109.627
R150 avdd.n223 avdd.t40 92.712
R151 avdd.n419 avdd.t31 91.1774
R152 avdd.n156 avdd.t36 91.1774
R153 avdd.n150 avdd.t38 91.1774
R154 avdd.n444 avdd.t26 91.1774
R155 avdd.n449 avdd.t29 91.1297
R156 avdd.n445 avdd.t27 91.1297
R157 avdd.n87 avdd.t25 91.1297
R158 avdd.n155 avdd.t35 91.1225
R159 avdd.n157 avdd.t37 91.1225
R160 avdd.n71 avdd.t214 89.0865
R161 avdd.n77 avdd.t174 87.1986
R162 avdd.n414 avdd.t33 86.6774
R163 avdd.n85 avdd.t28 86.6774
R164 avdd.n48 avdd.t113 86.6575
R165 avdd.n79 avdd.t155 86.644
R166 avdd.n83 avdd.t34 86.6261
R167 avdd.n417 avdd.t32 86.6261
R168 avdd.n411 avdd.t30 86.6261
R169 avdd.n161 avdd.t39 86.6225
R170 avdd.n78 avdd.t153 86.6125
R171 avdd.n450 avdd.t115 86.5945
R172 avdd.n73 avdd.t11 85.7565
R173 avdd.n82 avdd.t17 82.144
R174 avdd.n81 avdd.t15 82.1125
R175 avdd.n141 avdd.t141 78.8931
R176 avdd.n29 avdd.t74 78.7294
R177 avdd.n302 avdd.t159 78.7114
R178 avdd.n296 avdd.t186 78.7024
R179 avdd.n299 avdd.t188 78.6817
R180 avdd.n303 avdd.t70 78.6784
R181 avdd.n298 avdd.t72 78.6732
R182 avdd.n129 avdd.t178 78.6714
R183 avdd.n166 avdd.t170 78.2045
R184 avdd.n143 avdd.t164 78.146
R185 avdd.n168 avdd.t168 78.146
R186 avdd.n131 avdd.t143 78.1168
R187 avdd.n142 avdd.t162 78.1145
R188 avdd.n130 avdd.t127 78.0547
R189 avdd.n177 avdd.t139 78.0547
R190 avdd.n134 avdd.t137 73.6168
R191 avdd.n144 avdd.t166 73.6145
R192 avdd.n133 avdd.t145 73.5547
R193 avdd.n429 avdd.t7 65.028
R194 avdd.n428 avdd.t78 65.028
R195 avdd.n427 avdd.t76 65.028
R196 avdd.n409 avdd.t66 64.9641
R197 avdd.n107 avdd.t245 64.9641
R198 avdd.n408 avdd.t243 64.9641
R199 avdd.n106 avdd.t192 64.9641
R200 avdd.n152 avdd.t190 64.9641
R201 avdd.n153 avdd.t176 64.9641
R202 avdd.n440 avdd.t210 64.9569
R203 avdd.n439 avdd.t44 64.9569
R204 avdd.n89 avdd.t83 64.9569
R205 avdd.n436 avdd.t2 62.8419
R206 avdd.n430 avdd.t212 60.528
R207 avdd.n100 avdd.t9 60.528
R208 avdd.n422 avdd.t68 60.528
R209 avdd.n436 avdd.t62 60.4569
R210 avdd.n88 avdd.t13 60.4569
R211 avdd avdd.n70 54.7205
R212 avdd.n317 avdd.t112 45.3505
R213 avdd.n315 avdd.t261 45.3505
R214 avdd.n311 avdd.t242 45.3505
R215 avdd.n310 avdd.t117 45.3505
R216 avdd.n294 avdd.t161 45.3505
R217 avdd.n304 avdd.t118 45.3505
R218 avdd.n316 avdd.t48 45.3082
R219 avdd.n292 avdd.t185 45.3082
R220 avdd.n309 avdd.t106 45.3082
R221 avdd.n295 avdd.t80 45.3082
R222 avdd.n233 avdd.t111 39.2557
R223 avdd.n290 avdd.t55 31.9694
R224 avdd.n290 avdd.t57 30.7859
R225 avdd.n203 avdd.t237 25.7055
R226 avdd.n394 avdd.t102 25.6402
R227 avdd.n259 avdd.t126 22.6651
R228 avdd.n75 avdd.t24 22.4086
R229 avdd.n255 avdd.t158 22.3548
R230 avdd.n120 avdd.t260 21.5447
R231 avdd.n209 avdd.t199 21.2055
R232 avdd.n339 avdd.t54 21.2055
R233 avdd.n385 avdd.t207 21.1402
R234 avdd.n137 avdd.t179 20.5222
R235 avdd.n101 avdd.t177 20.0217
R236 avdd.n16 avdd.n103 19.5755
R237 avdd.n224 avdd.n223 19.3505
R238 avdd.n459 avdd.n14 18.4955
R239 avdd.n69 avdd.t20 18.4294
R240 avdd.n321 avdd.n290 17.9443
R241 avdd.n234 avdd.t86 16.8673
R242 avdd.n178 avdd.t100 16.5502
R243 avdd.n436 avdd.n435 16.4705
R244 avdd.n110 avdd.t50 16.3562
R245 avdd.n287 avdd.t197 16.3005
R246 avdd.n372 avdd.t108 16.2802
R247 avdd.n377 avdd.t254 16.2802
R248 avdd.n328 avdd.t120 16.2763
R249 avdd.n180 avdd.t209 16.2583
R250 avdd.n216 avdd.t52 16.0722
R251 avdd.n214 avdd.t251 15.8505
R252 avdd.n14 avdd.t175 15.8393
R253 avdd.n162 avdd.t22 15.8275
R254 avdd.n196 avdd.n188 15.3005
R255 avdd.n103 avdd.n102 15.1756
R256 avdd.n425 avdd.t69 14.3056
R257 avdd.n90 avdd.t14 14.2617
R258 avdd.n186 avdd.t184 14.212
R259 avdd.n63 avdd.t65 14.0162
R260 avdd.n65 avdd.t225 14.0027
R261 avdd.n16 avdd.t246 13.9467
R262 avdd.n9 avdd.t203 13.9423
R263 avdd.n52 avdd.t229 13.9423
R264 avdd.n50 avdd.t10 13.9006
R265 avdd.n53 avdd.t148 13.893
R266 avdd.n51 avdd.t92 13.8913
R267 avdd.n394 avdd.t5 13.8733
R268 avdd.n55 avdd.t187 13.8579
R269 avdd.n147 avdd.t165 13.8558
R270 avdd.n17 avdd.t169 13.8558
R271 avdd.n99 avdd.t8 13.8556
R272 avdd.n434 avdd.t213 13.8556
R273 avdd.n361 avdd.t134 13.848
R274 avdd.n54 avdd.t160 13.8399
R275 avdd.n34 avdd.t138 13.8172
R276 avdd.n91 avdd.t211 13.8117
R277 avdd.n61 avdd.t67 13.8117
R278 avdd.n94 avdd.t3 13.8117
R279 avdd.n124 avdd.t60 13.8052
R280 avdd.n57 avdd.t189 13.8022
R281 avdd.n405 avdd.t136 13.8005
R282 avdd.n282 avdd.t235 13.7999
R283 avdd.n14 avdd.t154 13.7976
R284 avdd.n67 avdd.t116 13.7976
R285 avdd.n174 avdd.t140 13.7941
R286 avdd.n399 avdd.t132 13.787
R287 avdd.n42 avdd.t71 13.7819
R288 avdd.n345 avdd.t98 13.7805
R289 avdd.n200 avdd.t173 13.7805
R290 avdd.n289 avdd.t94 13.7805
R291 avdd.n49 avdd.t18 13.7693
R292 avdd.n458 avdd.t156 13.7693
R293 avdd.n165 avdd.t171 13.7604
R294 avdd.n280 avdd.t231 13.758
R295 avdd.n334 avdd.t195 13.7563
R296 avdd.n322 avdd.t56 13.7345
R297 avdd.n178 avdd.n177 13.7255
R298 avdd.n15 avdd.t75 13.7229
R299 avdd.n321 avdd.t58 13.6082
R300 avdd.n254 avdd.t222 13.4369
R301 avdd.n246 avdd.t1 13.435
R302 avdd.n244 avdd.t88 13.03
R303 avdd.n370 avdd.n15 12.3755
R304 avdd.n272 avdd.n271 11.9705
R305 avdd.n395 avdd.n394 11.9705
R306 avdd.n264 avdd.n263 11.8805
R307 avdd.n214 avdd.n213 11.8805
R308 avdd.n172 avdd.n60 11.8655
R309 avdd.n407 avdd.n63 11.7905
R310 avdd.n288 avdd.n59 11.6105
R311 avdd.n401 avdd.n65 11.6105
R312 avdd.n242 avdd.n241 11.4305
R313 avdd.n145 avdd.t142 11.3808
R314 avdd.n204 avdd.n203 11.335
R315 avdd.n365 avdd.t205 11.2672
R316 avdd.n279 avdd.n278 11.2505
R317 avdd.n138 avdd.n137 11.0705
R318 avdd.n18 avdd.n17 1.08576
R319 avdd.n102 avdd.n101 10.7105
R320 avdd.n446 avdd.n445 10.6205
R321 avdd.n434 avdd.n433 10.4405
R322 avdd.n257 avdd.n256 9.8105
R323 avdd.n70 avdd.t215 9.50051
R324 avdd.n74 avdd.t12 9.50051
R325 avdd.n122 avdd.t227 9.45774
R326 avdd.n272 avdd.t152 9.43487
R327 avdd.n385 avdd.t256 9.41833
R328 avdd.n187 avdd.t47 9.38192
R329 avdd.n424 avdd.t77 9.3556
R330 avdd.n423 avdd.t79 9.3556
R331 avdd.n228 avdd.t233 9.33997
R332 avdd.n271 avdd.t150 9.33997
R333 avdd.n92 avdd.t45 9.31173
R334 avdd.n97 avdd.t84 9.31173
R335 avdd.n101 avdd.t191 9.31173
R336 avdd.n102 avdd.t193 9.31173
R337 avdd.n93 avdd.t63 9.31173
R338 avdd.n244 avdd.t90 9.29987
R339 avdd.n457 avdd.t16 9.29763
R340 avdd.n453 avdd.t114 9.29763
R341 avdd.n137 avdd.t128 9.2941
R342 avdd.n173 avdd.t146 9.2941
R343 avdd.n120 avdd.t258 9.29299
R344 avdd.n121 avdd.t105 9.28695
R345 avdd.n179 avdd.t110 9.28333
R346 avdd.n325 avdd.t122 9.28054
R347 avdd.n138 avdd.t144 9.27224
R348 avdd.n145 avdd.t163 9.26035
R349 avdd.n149 avdd.t167 9.26035
R350 avdd.n235 avdd.t241 9.25804
R351 avdd.n339 avdd.t249 9.23217
R352 avdd.n344 avdd.t96 9.23217
R353 avdd.n369 avdd.t73 9.16723
R354 avdd.n42 avdd.n181 9.0455
R355 avdd.n304 avdd.n303 8.5505
R356 avdd.n361 avdd.n360 8.4605
R357 avdd.n276 avdd.n274 7.4705
R358 avdd.n209 avdd.n200 7.4705
R359 avdd.n430 avdd.n61 7.4255
R360 avdd.n286 avdd.n285 7.3805
R361 avdd.n325 avdd.n51 7.2905
R362 avdd.n192 avdd.n191 7.2905
R363 avdd.n221 avdd.n220 7.2905
R364 avdd.n249 avdd.n248 7.2005
R365 avdd.n352 avdd.n351 7.1105
R366 avdd.n220 avdd.n217 7.1105
R367 avdd.n324 avdd.n323 7.1105
R368 avdd.n326 avdd.n325 7.0205
R369 avdd.n362 avdd.n361 6.9755
R370 avdd.n379 avdd.n179 6.9755
R371 avdd.n369 avdd.n57 6.9305
R372 avdd.n15 avdd.n369 6.9305
R373 avdd.n276 avdd.n275 6.8855
R374 avdd.n236 avdd.n235 6.8405
R375 avdd.n344 avdd.n343 6.8405
R376 avdd.n340 avdd.n339 6.8405
R377 avdd.n211 avdd.n210 6.83504
R378 avdd.n386 avdd.n385 6.7955
R379 avdd.n458 avdd.n457 6.7055
R380 avdd.n98 avdd.n97 6.6155
R381 avdd.n273 avdd.n272 6.6155
R382 avdd.n123 avdd.n122 6.6155
R383 avdd.n88 avdd.n87 6.5255
R384 avdd.n449 avdd.n85 6.3905
R385 avdd.n414 avdd.n413 6.3905
R386 avdd.n17 avdd.n149 6.3905
R387 avdd.n401 avdd.n111 6.3005
R388 avdd.n419 avdd.n411 6.2105
R389 avdd.n417 avdd.n416 6.2105
R390 avdd.n168 avdd.n144 6.2105
R391 avdd.n92 avdd.n91 6.1655
R392 avdd.n452 avdd.n83 6.1655
R393 avdd.n422 avdd.n421 6.1655
R394 avdd.n423 avdd.n99 6.1655
R395 avdd.n34 avdd.n173 6.1205
R396 avdd.n363 avdd.n362 6.0755
R397 avdd.n94 avdd.n93 6.0755
R398 avdd.n146 avdd.n145 6.0305
R399 avdd.n187 avdd.n186 5.93792
R400 avdd.n431 avdd.n430 5.8955
R401 avdd.n427 avdd.n422 5.8505
R402 avdd.n429 avdd.n100 5.8505
R403 avdd.n211 avdd.n202 5.8505
R404 avdd.n97 avdd.n96 5.8055
R405 avdd.n172 avdd.n138 5.7605
R406 avdd.n71 avdd.n70 5.7155
R407 avdd.n259 avdd.n246 5.7155
R408 avdd.n285 avdd.n227 5.7155
R409 avdd.n164 avdd.n161 5.6705
R410 avdd.n76 avdd.n75 5.5805
R411 avdd.n218 avdd.n217 5.51605
R412 avdd.n425 avdd.n424 5.4905
R413 avdd.n366 avdd.n365 5.4455
R414 avdd.n173 avdd.n172 5.4155
R415 avdd.n263 avdd.n262 5.3555
R416 avdd.n270 avdd.n269 5.22849
R417 avdd.n248 avdd.n247 5.21723
R418 avdd.n149 avdd.n148 5.1305
R419 avdd.n35 avdd.n453 5.0855
R420 avdd.n437 avdd.n436 4.9505
R421 avdd.n161 avdd.n160 4.9505
R422 avdd.n432 avdd.n100 4.8605
R423 avdd.n224 avdd.n222 4.8605
R424 avdd.n179 avdd.n178 4.8605
R425 avdd.n459 avdd.n76 4.8155
R426 avdd.n284 avdd.n283 4.8155
R427 avdd.n103 avdd.t244 4.81173
R428 avdd.n421 avdd.n411 4.7705
R429 avdd.n81 avdd.n80 4.7705
R430 avdd.n203 avdd.t239 4.74502
R431 avdd.n210 avdd.t201 4.74502
R432 avdd.n58 avdd.n344 4.6355
R433 avdd.n441 avdd.n88 4.5905
R434 avdd.n460 avdd.n74 4.5905
R435 avdd.n133 avdd.n132 4.5905
R436 avdd.n96 avdd.n93 4.5905
R437 avdd.n144 avdd.n60 4.5455
R438 avdd.n446 avdd.n85 4.5005
R439 avdd.n418 avdd.n417 4.5005
R440 avdd.n416 avdd.n414 4.5005
R441 avdd.n413 avdd.n83 4.5005
R442 avdd.n453 avdd.n452 4.5005
R443 avdd.n454 avdd.n82 4.5005
R444 avdd.n457 avdd.n456 4.5005
R445 avdd.n277 avdd.n276 4.5005
R446 avdd.n235 avdd.n234 4.5005
R447 avdd.n261 avdd.n246 4.5005
R448 avdd.n258 avdd.n254 4.5005
R449 avdd.n265 avdd.n264 4.5005
R450 avdd.n353 avdd.n352 4.5005
R451 avdd.n191 avdd.n190 4.5005
R452 avdd.n210 avdd.n209 4.5005
R453 avdd.n213 avdd.n212 4.5005
R454 avdd.n226 avdd.n225 4.5005
R455 avdd.n222 avdd.n221 4.5005
R456 avdd.n323 avdd.n4 4.5005
R457 avdd.n135 avdd.n134 4.5005
R458 avdd.n111 avdd.n108 4.5005
R459 avdd avdd.n462 4.3285
R460 avdd.n460 avdd.n459 3.8705
R461 avdd.n311 avdd.n310 3.6005
R462 avdd.n225 avdd.n224 3.5555
R463 avdd.n69 avdd.n252 3.5105
R464 avdd.n250 avdd.n249 2.8805
R465 avdd.n252 avdd.n251 2.8805
R466 avdd.n324 avdd.n322 2.8805
R467 avdd.n121 avdd.n120 2.8805
R468 avdd.n234 avdd.n9 2.7905
R469 avdd.n238 avdd.n237 2.7905
R470 avdd.n272 avdd.n228 2.7905
R471 avdd.n122 avdd.n121 2.7905
R472 avdd.n251 avdd.n250 2.7005
R473 avdd.n351 avdd.n350 2.7005
R474 avdd.n353 avdd.n199 2.7005
R475 avdd.n357 avdd.n356 2.7005
R476 avdd.n213 avdd.n208 2.7005
R477 avdd.n341 avdd.n11 2.7005
R478 avdd.n338 avdd.n337 2.7005
R479 avdd.n387 avdd.n125 2.7005
R480 avdd.n384 avdd.n383 2.7005
R481 avdd.n345 avdd.n58 2.6105
R482 avdd.n450 avdd.n67 2.5655
R483 avdd.n289 avdd.n288 2.5205
R484 avdd.n265 avdd.n245 2.5205
R485 avdd.n199 avdd.n198 2.5205
R486 avdd.n356 avdd.n190 2.5205
R487 avdd.n358 avdd.n357 2.5205
R488 avdd.n119 avdd.n118 2.5205
R489 avdd.n118 avdd.n115 2.5205
R490 avdd.n392 avdd.n125 2.5205
R491 avdd.n260 avdd.n258 2.4305
R492 avdd.n358 avdd.n188 2.4305
R493 avdd.n334 avdd.n333 2.3855
R494 avdd.n406 avdd.n108 2.3855
R495 avdd.n393 avdd.n392 2.3405
R496 avdd.n284 avdd.n228 2.2505
R497 avdd.n167 avdd.n17 2.2055
R498 avdd.n298 avdd.n29 2.1605
R499 avdd.n299 avdd.n298 2.1605
R500 avdd.n299 avdd.n296 2.1605
R501 avdd.n303 avdd.n302 2.1605
R502 avdd.n262 avdd.n261 2.1605
R503 avdd.n34 avdd.n32 2.1605
R504 avdd.n400 avdd.n112 2.1605
R505 avdd.n54 avdd.n42 2.08831
R506 avdd.n48 avdd.n35 2.0705
R507 avdd.n14 avdd.n458 2.0705
R508 avdd.n56 avdd.n55 0.525448
R509 avdd.n302 avdd.n296 1.9805
R510 avdd.n174 avdd.n34 1.9505
R511 avdd.n456 avdd.n49 1.8905
R512 avdd.n295 avdd.n294 1.8905
R513 avdd.n285 avdd.n284 1.8905
R514 avdd.n270 avdd.n244 1.8905
R515 avdd.n55 avdd.n54 1.8905
R516 avdd.n371 avdd.n370 1.8905
R517 avdd.n155 avdd.n153 1.8905
R518 avdd.n395 avdd.n112 1.8905
R519 avdd.n63 avdd.n406 1.8455
R520 avdd.n65 avdd.n400 1.8455
R521 avdd.n445 avdd.n444 1.8005
R522 avdd.n419 avdd.n418 1.8005
R523 avdd.n82 avdd.n81 1.8005
R524 avdd.n310 avdd.n309 1.8005
R525 avdd.n315 avdd.n292 1.8005
R526 avdd.n317 avdd.n316 1.8005
R527 avdd.n279 avdd.n52 1.8005
R528 avdd.n134 avdd.n133 1.8005
R529 avdd.n157 avdd.n156 1.8005
R530 avdd.n433 avdd.n432 1.7555
R531 avdd.n394 avdd.n393 1.7555
R532 avdd.n79 avdd.n78 1.7105
R533 avdd.n328 avdd.n327 1.7105
R534 avdd.n329 avdd.n287 1.7105
R535 avdd.n333 avdd.n332 1.7105
R536 avdd.n242 avdd.n9 1.7105
R537 avdd.n236 avdd.n232 1.7105
R538 avdd.n274 avdd.n273 1.7105
R539 avdd.n208 avdd.n204 1.7105
R540 avdd.n341 avdd.n340 1.7105
R541 avdd.n337 avdd.n216 1.7105
R542 avdd.n326 avdd.n4 1.7105
R543 avdd.n373 avdd.n372 1.7105
R544 avdd.n376 avdd.n180 1.7105
R545 avdd.n378 avdd.n377 1.7105
R546 avdd.n132 avdd.n131 1.7105
R547 avdd.n131 avdd.n130 1.7105
R548 avdd.n402 avdd.n110 1.7105
R549 avdd.n396 avdd.n123 1.7105
R550 avdd.n164 avdd.n163 1.7105
R551 avdd.n380 avdd.n379 1.7105
R552 avdd.n387 avdd.n386 1.7105
R553 avdd.n424 avdd.n423 1.6655
R554 avdd.n16 avdd.n104 1.6655
R555 avdd.n24 avdd.n69 1.6485
R556 avdd.n97 avdd.n92 1.6205
R557 avdd.n444 avdd.n87 1.6205
R558 avdd.n454 avdd.n48 1.6205
R559 avdd.n309 avdd.n294 1.6205
R560 avdd.n311 avdd.n292 1.6205
R561 avdd.n316 avdd.n315 1.6205
R562 avdd.n317 avdd.n290 1.6205
R563 avdd.n60 avdd.n143 1.6205
R564 avdd.n143 avdd.n142 1.6205
R565 avdd.n157 avdd.n150 1.6205
R566 avdd.n156 avdd.n155 1.6205
R567 avdd.n223 avdd.n68 1.6175
R568 avdd.n80 avdd.n79 1.5305
R569 avdd.n73 avdd.n70 1.5305
R570 avdd.n53 avdd.n277 1.5305
R571 avdd.n31 avdd.n15 1.5155
R572 avdd.n67 avdd.n449 1.4855
R573 avdd.n51 avdd.n288 1.4405
R574 avdd.n239 avdd.n238 1.4375
R575 avdd.n366 avdd.n364 1.3955
R576 avdd.n51 avdd.n6 1.3905
R577 avdd.n360 avdd.n359 1.3815
R578 avdd.n193 avdd.n192 1.3815
R579 avdd.n10 avdd.n9 1.3745
R580 avdd.n57 avdd.n56 0.618683
R581 avdd.n2 avdd.n109 1.3655
R582 avdd.n439 avdd.n89 1.3505
R583 avdd.n440 avdd.n439 1.3505
R584 avdd.n428 avdd.n427 1.3505
R585 avdd.n429 avdd.n428 1.3505
R586 avdd.n305 avdd.n295 1.3505
R587 avdd.n363 avdd.n184 1.3505
R588 avdd.n343 avdd.n59 1.3505
R589 avdd.n177 avdd.n32 1.3505
R590 avdd.n165 avdd.n164 1.3505
R591 avdd.n153 avdd.n152 1.3505
R592 avdd.n152 avdd.n106 1.3505
R593 avdd.n408 avdd.n106 1.3505
R594 avdd.n427 avdd.n426 1.3295
R595 avdd.n3 avdd.n289 1.3295
R596 avdd.n278 avdd.n7 1.3295
R597 avdd.n18 avdd.n41 0.112143
R598 avdd.n421 avdd.n420 1.3175
R599 avdd.n348 avdd.n200 1.3135
R600 avdd.n35 avdd.n49 1.3055
R601 avdd.n1 avdd.n16 0.429826
R602 avdd.n90 avdd.n38 1.2975
R603 avdd.n456 avdd.n19 1.2975
R604 avdd.n43 avdd.n429 1.2855
R605 avdd.n59 avdd.n13 1.2825
R606 avdd.n256 avdd.n253 1.2775
R607 avdd.n95 avdd.n94 1.2695
R608 avdd.n8 avdd.n53 1.2695
R609 avdd.n146 avdd.n139 1.2695
R610 avdd.n160 avdd.n150 1.2605
R611 avdd.n346 avdd.n345 1.2535
R612 avdd.n162 avdd.n39 1.24379
R613 avdd.n1 avdd.n0 0.39598
R614 avdd.n390 avdd.n124 1.2215
R615 avdd.n462 avdd.n71 1.2175
R616 avdd.n399 avdd.n398 1.2175
R617 avdd.n405 avdd.n404 1.2175
R618 avdd.n148 avdd.n147 1.2155
R619 avdd.n28 avdd.n434 1.2055
R620 avdd.n1 avdd.n61 0.421088
R621 avdd.n34 avdd.n33 1.2015
R622 avdd.n42 avdd.n368 1.17792
R623 avdd.n451 avdd.n450 1.1735
R624 avdd.n26 avdd.n25 1.1735
R625 avdd.n175 avdd.n174 1.1735
R626 avdd.n441 avdd.n440 1.1705
R627 avdd.n435 avdd.n99 1.1705
R628 avdd.n167 avdd.n166 1.1705
R629 avdd.n67 avdd.n66 1.1705
R630 avdd.n65 avdd.n64 1.1705
R631 avdd.n63 avdd.n62 1.1705
R632 avdd.n170 avdd.n60 1.1705
R633 avdd.n54 avdd.n46 1.1705
R634 avdd.n37 avdd.n35 1.1705
R635 avdd.n48 avdd.n36 1.1705
R636 avdd.n185 avdd.n184 1.1575
R637 avdd.n75 avdd.n72 1.1535
R638 avdd.n319 avdd.n290 1.1415
R639 avdd.n461 avdd.n460 1.1255
R640 avdd.n449 avdd.n448 1.1255
R641 avdd.n442 avdd.n87 1.1255
R642 avdd.n444 avdd.n443 1.1255
R643 avdd.n445 avdd.n86 1.1255
R644 avdd.n447 avdd.n446 1.1255
R645 avdd.n38 avdd.n441 1.1255
R646 avdd.n439 avdd.n438 1.1255
R647 avdd.n27 avdd.n437 1.1255
R648 avdd.n96 avdd.n95 1.1255
R649 avdd.n452 avdd.n37 1.1255
R650 avdd.n420 avdd.n419 1.1255
R651 avdd.n418 avdd.n412 1.1255
R652 avdd.n416 avdd.n415 1.1255
R653 avdd.n413 avdd.n84 1.1255
R654 avdd.n455 avdd.n454 1.1255
R655 avdd.n80 avdd.n19 1.1255
R656 avdd.n50 avdd.n28 1.1255
R657 avdd.n426 avdd.n425 1.1255
R658 avdd.n431 avdd.n43 1.1255
R659 avdd.n44 avdd.n408 1.1255
R660 avdd.n152 avdd.n105 1.1255
R661 avdd.n155 avdd.n154 1.1255
R662 avdd.n156 avdd.n151 1.1255
R663 avdd.n158 avdd.n157 1.1255
R664 avdd.n159 avdd.n150 1.1255
R665 avdd.n160 avdd.n39 1.1255
R666 avdd.n410 avdd.n409 1.1255
R667 avdd.n403 avdd.n108 1.1255
R668 avdd.n2 avdd.n402 1.1255
R669 avdd.n118 avdd.n117 1.1255
R670 avdd.n397 avdd.n112 1.1255
R671 avdd.n20 avdd.n396 1.1255
R672 avdd.n119 avdd.n114 1.1255
R673 avdd.n394 avdd.n113 1.1255
R674 avdd.n298 avdd.n297 1.1255
R675 avdd.n300 avdd.n299 1.1255
R676 avdd.n301 avdd.n296 1.1255
R677 avdd.n302 avdd.n47 1.1255
R678 avdd.n303 avdd.n45 1.1255
R679 avdd.n381 avdd.n380 1.1255
R680 avdd.n378 avdd.n127 1.1255
R681 avdd.n376 avdd.n375 1.1255
R682 avdd.n374 avdd.n373 1.1255
R683 avdd.n371 avdd.n30 1.1255
R684 avdd.n31 avdd.n29 1.1255
R685 avdd.n389 avdd.n125 1.1255
R686 avdd.n388 avdd.n387 1.1255
R687 avdd.n384 avdd.n126 1.1255
R688 avdd.n383 avdd.n382 1.1255
R689 avdd.n392 avdd.n391 1.1255
R690 avdd.n306 avdd.n305 1.1255
R691 avdd.n307 avdd.n294 1.1255
R692 avdd.n309 avdd.n308 1.1255
R693 avdd.n310 avdd.n293 1.1255
R694 avdd.n312 avdd.n311 1.1255
R695 avdd.n313 avdd.n292 1.1255
R696 avdd.n315 avdd.n314 1.1255
R697 avdd.n316 avdd.n291 1.1255
R698 avdd.n318 avdd.n317 1.1255
R699 avdd.n321 avdd.n320 1.1255
R700 avdd.n3 avdd.n324 1.1255
R701 avdd.n6 avdd.n4 1.1255
R702 avdd.n327 avdd.n5 1.1255
R703 avdd.n330 avdd.n329 1.1255
R704 avdd.n332 avdd.n331 1.1255
R705 avdd.n335 avdd.n334 1.1255
R706 avdd.n282 avdd.n281 1.1255
R707 avdd.n7 avdd.n280 1.1255
R708 avdd.n52 avdd.n8 1.1255
R709 avdd.n239 avdd.n233 1.1255
R710 avdd.n275 avdd.n231 1.1255
R711 avdd.n241 avdd.n240 1.1255
R712 avdd.n10 avdd.n232 1.1255
R713 avdd.n274 avdd.n230 1.1255
R714 avdd.n267 avdd.n243 1.1255
R715 avdd.n266 avdd.n265 1.1255
R716 avdd.n261 avdd.n24 1.1255
R717 avdd.n262 avdd.n22 1.1255
R718 avdd.n23 avdd.n260 1.1255
R719 avdd.n258 avdd.n253 1.1255
R720 avdd.n258 avdd.n257 1.1255
R721 avdd.n21 avdd.n226 1.1255
R722 avdd.n337 avdd.n336 1.1255
R723 avdd.n13 avdd.n11 1.1255
R724 avdd.n342 avdd.n341 1.1255
R725 avdd.n338 avdd.n215 1.1255
R726 avdd.n58 avdd.n12 1.1255
R727 avdd.n213 avdd.n201 1.1255
R728 avdd.n208 avdd.n207 1.1255
R729 avdd.n347 avdd.n202 1.1255
R730 avdd.n199 avdd.n195 1.1255
R731 avdd.n354 avdd.n353 1.1255
R732 avdd.n351 avdd.n194 1.1255
R733 avdd.n350 avdd.n349 1.1255
R734 avdd.n359 avdd.n358 1.1255
R735 avdd.n357 avdd.n189 1.1255
R736 avdd.n356 avdd.n355 1.1255
R737 avdd.n193 avdd.n190 1.1255
R738 avdd.n367 avdd.n366 1.1255
R739 avdd.n222 avdd.n68 1.1255
R740 avdd.n220 avdd.n219 1.1255
R741 avdd.n177 avdd.n176 1.1255
R742 avdd.n172 avdd.n171 1.1255
R743 avdd.n136 avdd.n135 1.1255
R744 avdd.n132 avdd.n128 1.1255
R745 avdd.n169 avdd.n168 1.1255
R746 avdd.n166 avdd.n40 1.1255
R747 avdd.n143 avdd.n140 1.1255
R748 avdd.n148 avdd.n139 1.1255
R749 avdd.n18 avdd.n165 0.920632
R750 avdd.n322 avdd.n321 1.11425
R751 avdd.n327 avdd.n326 0.9905
R752 avdd.n332 avdd.n287 0.9905
R753 avdd.n271 avdd.n270 0.9905
R754 avdd.n372 avdd.n371 0.9905
R755 avdd.n377 avdd.n376 0.9905
R756 avdd.n409 avdd.n104 0.9905
R757 avdd.n402 avdd.n401 0.9905
R758 avdd.n393 avdd.n124 0.9905
R759 avdd.n91 avdd.n90 0.9455
R760 avdd.n53 avdd.n242 0.9455
R761 avdd.n277 avdd.n52 0.9455
R762 avdd.n66 avdd.n72 0.9365
R763 avdd.n237 avdd.n236 0.9005
R764 avdd.n237 avdd.n233 0.9005
R765 avdd.n212 avdd.n211 0.9005
R766 avdd.n407 avdd.n107 0.9005
R767 avdd.n349 avdd.n348 0.8245
R768 avdd.n329 avdd.n328 0.8105
R769 avdd.n273 avdd.n243 0.8105
R770 avdd.n260 avdd.n259 0.8105
R771 avdd.n280 avdd.n279 0.8105
R772 avdd.n205 avdd.n204 0.8105
R773 avdd.n343 avdd.n11 0.8105
R774 avdd.n340 avdd.n338 0.8105
R775 avdd.n226 avdd.n216 0.8105
R776 avdd.n373 avdd.n180 0.8105
R777 avdd.n379 avdd.n378 0.8105
R778 avdd.n110 avdd.n109 0.8105
R779 avdd.n396 avdd.n395 0.8105
R780 avdd.n123 avdd.n119 0.8105
R781 avdd.n400 avdd.n399 0.8105
R782 avdd.n406 avdd.n405 0.8105
R783 avdd.n386 avdd.n384 0.8105
R784 avdd.n320 avdd.n319 0.7965
R785 avdd.n306 avdd.n45 0.7765
R786 avdd.n58 avdd.n214 0.7655
R787 avdd.n197 avdd.n196 0.717231
R788 avdd.n129 avdd.n128 0.667338
R789 avdd.n77 avdd.n19 0.651338
R790 avdd.n370 avdd.n29 0.6305
R791 avdd.n364 avdd.n363 0.6305
R792 avdd.n116 avdd.n115 0.584461
R793 avdd.n247 avdd.n227 0.584461
R794 avdd.n206 avdd.n205 0.584461
R795 avdd.n198 avdd.n197 0.584461
R796 avdd.n186 avdd.n185 0.544175
R797 avdd.n117 avdd.n116 0.53943
R798 avdd.n207 avdd.n206 0.53943
R799 avdd.n197 avdd.n195 0.53943
R800 avdd.n141 avdd.n140 0.533359
R801 avdd.n364 avdd.n183 0.527202
R802 avdd.n355 avdd.n354 0.5045
R803 avdd.n382 avdd.n381 0.4965
R804 avdd.n78 avdd.n77 0.480177
R805 avdd.n130 avdd.n129 0.480177
R806 avdd.n368 avdd.n367 0.467611
R807 avdd.n437 avdd.n98 0.4505
R808 avdd.n333 avdd.n25 0.4505
R809 avdd.n283 avdd.n282 0.4505
R810 avdd.n135 avdd.n32 0.4505
R811 avdd.n168 avdd.n167 0.4505
R812 avdd.n408 avdd.n407 0.4505
R813 avdd.n432 avdd.n431 0.4505
R814 avdd.n461 avdd.n72 0.4485
R815 avdd.n269 avdd.n245 0.447879
R816 avdd.n281 avdd.n7 0.4445
R817 avdd.n142 avdd.n141 0.423535
R818 avdd.n247 avdd.n229 0.37943
R819 avdd.n219 avdd.n218 0.366609
R820 avdd.n98 avdd.n89 0.3605
R821 avdd.n107 avdd.n104 0.3605
R822 avdd.n269 avdd.n268 0.359922
R823 avdd.n312 avdd.n293 0.3365
R824 avdd.n183 avdd.n182 0.325735
R825 avdd.n257 avdd.n255 0.3155
R826 avdd.n365 avdd.n181 0.3155
R827 avdd.n266 avdd.n22 0.3125
R828 avdd.n154 avdd.n105 0.3045
R829 avdd.n307 avdd.n306 0.3045
R830 avdd.n10 avdd.n239 0.2965
R831 avdd.n47 avdd.n46 0.2965
R832 avdd.n21 avdd.n68 0.2965
R833 avdd.n219 avdd.n68 0.2885
R834 avdd.n320 avdd.n3 0.2845
R835 avdd.n281 avdd.n229 0.2845
R836 avdd.n229 avdd.n26 0.2725
R837 avdd.n305 avdd.n304 0.2705
R838 avdd.n25 avdd.n286 0.2705
R839 avdd.n360 avdd.n188 0.2705
R840 avdd.n147 avdd.n146 0.2705
R841 avdd.n163 avdd.n162 0.2705
R842 avdd.n44 avdd.n105 0.2565
R843 avdd.n389 avdd.n388 0.2565
R844 avdd.n382 avdd.n126 0.2565
R845 avdd.n375 avdd.n127 0.2565
R846 avdd.n374 avdd.n30 0.2565
R847 avdd.n6 avdd.n5 0.2565
R848 avdd.n331 avdd.n330 0.2565
R849 avdd.n268 avdd.n267 0.2565
R850 avdd.n13 avdd.n342 0.2565
R851 avdd.n336 avdd.n215 0.2565
R852 avdd.n207 avdd.n201 0.2565
R853 avdd.n354 avdd.n195 0.2565
R854 avdd.n349 avdd.n194 0.2565
R855 avdd.n355 avdd.n189 0.2565
R856 avdd.n21 avdd.n335 0.2525
R857 avdd.n20 avdd.n114 0.2405
R858 avdd.n117 avdd.n114 0.2405
R859 avdd.n391 avdd.n389 0.2405
R860 avdd.n388 avdd.n126 0.2405
R861 avdd.n381 avdd.n127 0.2405
R862 avdd.n375 avdd.n374 0.2405
R863 avdd.n330 avdd.n5 0.2405
R864 avdd.n240 avdd.n231 0.2405
R865 avdd.n267 avdd.n230 0.2405
R866 avdd.n268 avdd.n266 0.2405
R867 avdd.n342 avdd.n215 0.2405
R868 avdd.n354 avdd.n194 0.2405
R869 avdd.n359 avdd.n189 0.2405
R870 avdd.n355 avdd.n193 0.2405
R871 avdd.n20 avdd.n113 0.2325
R872 avdd.n347 avdd.n346 0.2325
R873 avdd.n37 avdd.n451 0.2205
R874 avdd.n171 avdd.n33 0.2205
R875 avdd.n28 avdd.n27 0.2165
R876 avdd.n426 avdd.n38 0.2165
R877 avdd.n0 avdd.n43 0.2165
R878 avdd.n44 avdd.n62 0.2165
R879 avdd.n404 avdd.n403 0.2165
R880 avdd.n8 avdd.n230 0.2165
R881 avdd.n171 avdd.n170 0.2165
R882 avdd.n170 avdd.n139 0.2165
R883 avdd.n438 avdd.n27 0.2085
R884 avdd.n297 avdd.n31 0.2085
R885 avdd.n300 avdd.n297 0.2085
R886 avdd.n301 avdd.n300 0.2085
R887 avdd.n47 avdd.n45 0.2085
R888 avdd.n24 avdd.n22 0.2085
R889 avdd.n347 avdd.n201 0.2085
R890 avdd.n368 avdd.n46 0.2085
R891 avdd.n2 avdd.n64 0.2005
R892 avdd.n398 avdd.n397 0.2005
R893 avdd.n391 avdd.n390 0.2005
R894 avdd.n23 avdd.n253 0.2005
R895 avdd.n56 avdd.n46 0.542125
R896 avdd.n6 avdd.n3 0.3365
R897 avdd.n8 avdd.n231 0.2805
R898 avdd.n13 avdd.n12 0.2645
R899 avdd.n410 avdd.n44 0.2565
R900 avdd.n397 avdd.n20 0.2565
R901 avdd.n240 avdd.n10 0.2565
R902 avdd.n403 avdd.n2 0.2565
R903 avdd.n28 avdd.n43 0.2485
R904 avdd.n0 avdd.n410 0.2485
R905 avdd.n31 avdd.n30 0.2405
R906 avdd.n336 avdd.n21 0.2405
R907 avdd.n8 avdd.n7 0.2405
R908 avdd.n438 avdd.n38 0.234786
R909 avdd.n41 avdd.n40 0.223611
R910 avdd.n95 avdd.n27 0.2165
R911 avdd.n47 avdd.n301 0.1925
R912 avdd.n19 avdd.n455 0.1925
R913 avdd.n442 avdd.n38 0.186786
R914 avdd.n176 avdd.n175 0.1845
R915 avdd.n39 avdd.n159 0.1845
R916 avdd.n37 avdd.n84 0.1845
R917 avdd.n41 avdd.n39 0.183611
R918 avdd.n435 avdd.n50 0.1805
R919 avdd.n443 avdd.n86 0.1765
R920 avdd.n420 avdd.n412 0.1765
R921 avdd.n415 avdd.n84 0.1765
R922 avdd.n158 avdd.n151 0.1765
R923 avdd.n308 avdd.n293 0.1765
R924 avdd.n314 avdd.n313 0.1765
R925 avdd.n318 avdd.n291 0.1765
R926 avdd.n176 avdd.n136 0.1765
R927 avdd.n136 avdd.n128 0.1765
R928 avdd.n170 avdd.n169 0.1765
R929 avdd.n448 avdd.n447 0.170786
R930 avdd.n451 avdd.n66 0.1685
R931 avdd.n335 avdd.n26 0.1645
R932 avdd.n462 avdd.n461 0.1605
R933 avdd.n443 avdd.n442 0.1605
R934 avdd.n447 avdd.n86 0.1605
R935 avdd.n415 avdd.n412 0.1605
R936 avdd.n455 avdd.n36 0.1605
R937 avdd.n154 avdd.n151 0.1605
R938 avdd.n159 avdd.n158 0.1605
R939 avdd.n404 avdd.n62 0.1605
R940 avdd.n398 avdd.n64 0.1605
R941 avdd.n390 avdd.n113 0.1605
R942 avdd.n308 avdd.n307 0.1605
R943 avdd.n313 avdd.n312 0.1605
R944 avdd.n314 avdd.n291 0.1605
R945 avdd.n331 avdd.n26 0.1605
R946 avdd.n185 avdd.n182 0.1605
R947 avdd.n169 avdd.n40 0.1605
R948 avdd.n170 avdd.n140 0.1605
R949 avdd.n37 avdd.n36 0.1525
R950 avdd.n24 avdd.n23 0.1525
R951 avdd.n319 avdd.n318 0.1445
R952 avdd.n448 avdd.n66 0.138786
R953 avdd.n74 avdd.n73 0.1355
R954 avdd.n433 avdd.n50 0.1355
R955 avdd.n362 avdd.n187 0.1355
R956 avdd.n348 avdd.n347 0.1285
R957 avdd.n175 avdd.n33 0.1245
R958 avdd.n367 avdd.n182 0.115611
R959 avdd.n346 avdd.n12 0.1125
R960 dvdd.n31 dvdd.t11 109.894
R961 dvdd.n30 dvdd.t18 109.692
R962 dvdd.n10 dvdd.t22 109.422
R963 dvdd.n6 dvdd.t28 109.272
R964 dvdd.n26 dvdd.t26 109.264
R965 dvdd.n12 dvdd.t13 104.746
R966 dvdd.n9 dvdd.t20 100.174
R967 dvdd.n7 dvdd.t7 82.4916
R968 dvdd.n1 dvdd.t0 60.7437
R969 dvdd.n14 dvdd.t10 45.3749
R970 dvdd.n38 dvdd.t15 39.4649
R971 dvdd.n39 dvdd.t17 39.4347
R972 dvdd.n13 dvdd.t1 33.4172
R973 dvdd.n18 dvdd.t8 31.6601
R974 dvdd.n15 dvdd.t3 31.4969
R975 dvdd.n20 dvdd.t2 30.6194
R976 dvdd.n18 dvdd.t6 30.6149
R977 dvdd.n17 dvdd.t16 30.6059
R978 dvdd.n21 dvdd.t4 30.578
R979 dvdd.n19 dvdd.t5 30.5714
R980 dvdd.n16 dvdd.t25 30.5689
R981 dvdd.n15 dvdd.t9 30.5667
R982 dvdd.n3 dvdd.t24 30.4271
R983 dvdd.n8 dvdd.n7 24.3348
R984 dvdd.n33 dvdd.n30 19.1255
R985 dvdd.n5 dvdd.n3 15.8855
R986 dvdd.n11 dvdd.t14 15.5386
R987 dvdd.n31 dvdd.t12 15.1483
R988 dvdd.n29 dvdd.t23 15.0481
R989 dvdd.n34 dvdd.t19 15.0481
R990 dvdd.n40 dvdd.n0 14.8505
R991 dvdd.n9 dvdd.n8 14.186
R992 dvdd dvdd.n1 12.4205
R993 dvdd.n7 dvdd.n6 11.5239
R994 dvdd.n5 dvdd.t29 10.5249
R995 dvdd.n8 dvdd.t21 10.5033
R996 dvdd.n27 dvdd.t27 10.4782
R997 dvdd.n33 dvdd.n32 9.8105
R998 dvdd.n0 dvdd.n3 9.37175
R999 dvdd.n35 dvdd.n9 9.288
R1000 dvdd.n13 dvdd.n12 6.5255
R1001 dvdd.n28 dvdd.n27 6.0305
R1002 dvdd.n6 dvdd.n5 5.3555
R1003 dvdd.n27 dvdd.n26 5.0405
R1004 dvdd.n12 dvdd.n11 4.5005
R1005 dvdd.n40 dvdd.n1 4.5005
R1006 dvdd.n35 dvdd.n34 2.4755
R1007 dvdd.n23 dvdd.n22 1.79223
R1008 dvdd.n25 dvdd.n13 1.40779
R1009 dvdd.n32 dvdd.n4 1.3015
R1010 dvdd.n20 dvdd.n19 1.2605
R1011 dvdd.n41 dvdd.n40 1.2375
R1012 dvdd.n26 dvdd.n11 1.1705
R1013 dvdd.n38 dvdd.n2 1.1255
R1014 dvdd.n0 dvdd.n37 1.1255
R1015 dvdd.n36 dvdd.n35 1.1255
R1016 dvdd.n26 dvdd.n25 1.1255
R1017 dvdd.n30 dvdd.n29 1.0805
R1018 dvdd.n21 dvdd.n20 1.0805
R1019 dvdd.n16 dvdd.n15 1.0805
R1020 dvdd.n14 dvdd.n10 0.9905
R1021 dvdd.n23 dvdd.n14 0.966612
R1022 dvdd.n19 dvdd.n18 0.9005
R1023 dvdd.n17 dvdd.n16 0.9005
R1024 dvdd.n39 dvdd.n38 0.8105
R1025 dvdd.n37 dvdd.n36 0.6965
R1026 dvdd.n22 dvdd.n17 0.5855
R1027 dvdd dvdd.n41 0.4925
R1028 dvdd.n41 dvdd.n2 0.4885
R1029 dvdd.n32 dvdd.n31 0.4505
R1030 dvdd.n0 dvdd.n39 0.4505
R1031 dvdd.n28 dvdd.n10 0.2705
R1032 dvdd.n25 dvdd.n24 0.234786
R1033 dvdd.n22 dvdd.n21 0.2255
R1034 dvdd.n24 dvdd.n4 0.1845
R1035 dvdd.n34 dvdd.n33 0.1355
R1036 dvdd.n29 dvdd.n28 0.1355
R1037 dvdd.n37 dvdd.n2 0.1285
R1038 dvdd.n36 dvdd.n4 0.1205
R1039 dvdd.n24 dvdd.n23 0.103319
R1040 psrg_mf1_protected psrg_mf1_protected.t0 24.2068
R1041 psrg_mf1_protected psrg_mf1_protected.t1 4.75063
R1042 su_state su_state.n0 21.9515
R1043 su_state.n0 su_state.t2 17.9745
R1044 su_state.n0 su_state.t1 16.4814
R1045 su_state su_state.t0 8.9205
R1046 xf1.n0 xf1.t4 42.5749
R1047 xf1.n5 xf1.t8 27.3149
R1048 xf1.n0 xf1.t9 18.355
R1049 xf1.n3 xf1.n2 16.2005
R1050 xf1.n4 xf1.t10 14.035
R1051 xf1.n2 xf1.t7 13.9
R1052 xf1.n1 xf1.t6 13.8599
R1053 xf1.n3 xf1.t0 13.8599
R1054 xf1.n8 xf1.t5 13.6805
R1055 xf1.n7 xf1.t11 13.6805
R1056 xf1.n9 xf1.t3 13.6404
R1057 xf1 xf1.n9 13.0678
R1058 xf1.n6 xf1.n5 12.3305
R1059 xf1.n6 xf1.t1 9.14039
R1060 xf1.n8 xf1.n7 7.7405
R1061 xf1.n7 xf1.n6 6.6605
R1062 xf1 xf1.t2 4.5781
R1063 xf1.n2 xf1.n1 3.0605
R1064 xf1.n4 xf1.n3 2.9705
R1065 xf1.n1 xf1.n0 2.7905
R1066 xf1.n5 xf1.n4 2.7005
R1067 xf1.n9 xf1.n8 1.9805
R1068 vsp.n0 vsp.t3 16.0674
R1069 vsp.n5 vsp.t6 15.7916
R1070 vsp.n13 vsp.n4 14.8955
R1071 vsp.n3 vsp.t9 13.7319
R1072 vsp.n0 vsp.t2 13.7004
R1073 vsp.n2 vsp.t12 13.6959
R1074 vsp.n1 vsp.t13 13.6717
R1075 vsp.n4 vsp.t1 13.6659
R1076 vsp.n5 vsp.t0 13.6535
R1077 vsp.n12 vsp.t4 13.6535
R1078 vsp.n10 vsp.t5 13.6535
R1079 vsp.n7 vsp.t11 13.6535
R1080 vsp.n11 vsp.t10 13.6316
R1081 vsp.n9 vsp.t7 13.6316
R1082 vsp.n8 vsp.t14 13.6316
R1083 vsp.n6 vsp.t15 13.6316
R1084 vsp.n13 vsp.n12 6.5255
R1085 vsp vsp.t8 4.5781
R1086 vsp vsp.n13 4.55402
R1087 vsp.n9 vsp.n8 3.9605
R1088 vsp.n4 vsp.n3 2.5205
R1089 vsp.n2 vsp.n1 2.5205
R1090 vsp.n1 vsp.n0 2.5205
R1091 vsp.n3 vsp.n2 2.3405
R1092 vsp.n7 vsp.n6 2.1605
R1093 vsp.n10 vsp.n9 2.1605
R1094 vsp.n12 vsp.n11 2.1605
R1095 vsp.n6 vsp.n5 1.9805
R1096 vsp.n8 vsp.n7 1.9805
R1097 vsp.n11 vsp.n10 1.9805
R1098 iref_gate.n1 iref_gate.t2 79.3175
R1099 iref_gate.n0 iref_gate.t3 74.4705
R1100 iref_gate.n0 iref_gate.t0 13.8913
R1101 iref_gate iref_gate.n1 9.18991
R1102 iref_gate iref_gate.t1 4.55384
R1103 iref_gate.n1 iref_gate.n0 1.0805
R1104 xf2.n6 xf2.t3 37.1877
R1105 xf2.n1 xf2.t2 24.115
R1106 xf2.n4 xf2.n3 20.3855
R1107 xf2 xf2.n9 17.6529
R1108 xf2.n9 xf2.n8 16.8305
R1109 xf2.n0 xf2.t0 16.8299
R1110 xf2.n0 xf2.t1 14.035
R1111 xf2.n3 xf2.t9 13.9
R1112 xf2.n8 xf2.n7 11.2505
R1113 xf2.n4 xf2.t11 9.6749
R1114 xf2.n2 xf2.t6 9.3599
R1115 xf2.n5 xf2.t4 9.18048
R1116 xf2.n9 xf2.t7 9.18048
R1117 xf2.n8 xf2.t10 9.18048
R1118 xf2.n7 xf2.t8 9.14039
R1119 xf2.n1 xf2.n0 8.7305
R1120 xf2.n3 xf2.n2 7.5605
R1121 xf2.n5 xf2.n4 5.9405
R1122 xf2 xf2.t5 4.5781
R1123 xf2.n7 xf2.n6 3.0155
R1124 xf2.n6 xf2.n5 2.7905
R1125 xf2.n2 xf2.n1 2.7905
R1126 vbn_fold.n6 vbn_fold.t15 66.9311
R1127 vbn_fold.n7 vbn_fold.t14 28.7855
R1128 vbn_fold.n0 vbn_fold.t7 18.9113
R1129 vbn_fold.n0 vbn_fold.t8 14.4891
R1130 vbn_fold.n2 vbn_fold.t2 13.813
R1131 vbn_fold.n4 vbn_fold.t5 13.813
R1132 vbn_fold.n1 vbn_fold.t1 13.7911
R1133 vbn_fold.n3 vbn_fold.t4 13.7911
R1134 vbn_fold.n5 vbn_fold.t11 13.7911
R1135 vbn_fold.n10 vbn_fold.t3 13.7803
R1136 vbn_fold.n8 vbn_fold.t13 13.7803
R1137 vbn_fold.n7 vbn_fold.t0 13.7512
R1138 vbn_fold.n11 vbn_fold.t9 13.7512
R1139 vbn_fold.n9 vbn_fold.t6 13.7512
R1140 vbn_fold.n6 vbn_fold.t12 9.31296
R1141 vbn_fold.n12 vbn_fold.n11 7.4255
R1142 vbn_fold.n6 vbn_fold.n5 7.3805
R1143 vbn_fold.n1 vbn_fold.n0 5.4005
R1144 vbn_fold.n12 vbn_fold.n6 5.3555
R1145 vbn_fold vbn_fold.t10 4.72634
R1146 vbn_fold vbn_fold.n12 4.5545
R1147 vbn_fold.n9 vbn_fold.n8 3.0605
R1148 vbn_fold.n11 vbn_fold.n10 3.0605
R1149 vbn_fold.n5 vbn_fold.n4 3.0605
R1150 vbn_fold.n3 vbn_fold.n2 3.0605
R1151 vbn_fold.n8 vbn_fold.n7 2.8805
R1152 vbn_fold.n10 vbn_fold.n9 2.8805
R1153 vbn_fold.n4 vbn_fold.n3 2.8805
R1154 vbn_fold.n2 vbn_fold.n1 2.8805
R1155 vbp_tail.n1 vbp_tail.n0 69.0755
R1156 vbp_tail.n0 vbp_tail.t0 41.9642
R1157 vbp_tail.n8 vbp_tail.t9 32.3537
R1158 vbp_tail.n9 vbp_tail.t10 32.3447
R1159 vbp_tail.n10 vbp_tail.t11 32.29
R1160 vbp_tail.n11 vbp_tail.t12 32.2887
R1161 vbp_tail.n1 vbp_tail.t8 27.7895
R1162 vbp_tail.n2 vbp_tail.t1 25.2678
R1163 vbp_tail.n3 vbp_tail.t5 24.8343
R1164 vbp_tail.n7 vbp_tail.n6 23.5355
R1165 vbp_tail vbp_tail.t13 23.284
R1166 vbp_tail.n2 vbp_tail.t3 23.1438
R1167 vbp_tail.n0 vbp_tail.t7 17.1211
R1168 vbp_tail.n3 vbp_tail.t6 14.5794
R1169 vbp_tail.n6 vbp_tail.t2 13.9791
R1170 vbp_tail.n4 vbp_tail.t4 13.8954
R1171 vbp_tail vbp_tail.n11 11.4282
R1172 vbp_tail.n7 vbp_tail.n1 6.1205
R1173 vbp_tail.n11 vbp_tail.n10 2.3405
R1174 vbp_tail.n10 vbp_tail.n9 2.3405
R1175 vbp_tail.n9 vbp_tail.n8 2.1605
R1176 vbp_tail.n5 vbp_tail.n2 1.7105
R1177 vbp_tail.n4 vbp_tail.n3 1.6205
R1178 vbp_tail.n6 vbp_tail.n5 1.5305
R1179 vbp_tail.n5 vbp_tail.n4 0.9005
R1180 vbp_tail.n8 vbp_tail.n7 0.7205
R1181 psrg_m3_protected.n0 psrg_m3_protected.t1 15.8499
R1182 psrg_m3_protected.n1 psrg_m3_protected.t2 13.8481
R1183 psrg_m3_protected.n0 psrg_m3_protected.t0 13.8481
R1184 psrg_m3_protected psrg_m3_protected.n1 11.0795
R1185 psrg_m3_protected psrg_m3_protected.t3 4.81592
R1186 psrg_m3_protected.n1 psrg_m3_protected.n0 1.2605
R1187 v2.n4 v2.t6 65.4785
R1188 v2.n3 v2.t5 65.4785
R1189 v2.n2 v2.t4 65.4173
R1190 v2.n1 v2.t3 60.9785
R1191 v2 v2.t7 56.411
R1192 v2.n1 v2.n0 43.4705
R1193 v2.n5 v2.t0 38.5239
R1194 v2.n0 v2.t1 15.9669
R1195 v2.n0 v2.t2 13.9918
R1196 v2.n2 v2.n1 10.4405
R1197 v2.n5 v2.n4 8.4605
R1198 v2.n4 v2.n3 7.7405
R1199 v2 v2.n5 4.568
R1200 v2.n3 v2.n2 1.8005
R1201 v1.n3 v1.t4 65.4785
R1202 v1.n2 v1.t3 65.4785
R1203 v1.n4 v1.t5 65.4173
R1204 v1.n1 v1.t2 60.9173
R1205 v1 v1.t6 56.411
R1206 v1.n1 v1.n0 41.2205
R1207 v1.n5 v1 30.488
R1208 v1.n0 v1.t0 15.9181
R1209 v1.n0 v1.t1 14.0049
R1210 v1 v1.n5 9.1418
R1211 v1.n3 v1.n2 7.7405
R1212 v1.n2 v1.n1 6.3005
R1213 v1.n5 v1.n4 3.8705
R1214 v1.n4 v1.n3 1.9805
R1215 vbn vbn.n2 59.162
R1216 vbn.n0 vbn.t2 22.2684
R1217 vbn.n1 vbn.t4 22.2196
R1218 vbn.n2 vbn.t1 17.9215
R1219 vbn.n0 vbn.t3 15.5707
R1220 vbn.n2 vbn.n1 10.1255
R1221 vbn vbn.t0 4.76719
R1222 vbn.n1 vbn.n0 4.3655
R1223 vbp_bias.n23 vbp_bias.n22 97.3355
R1224 vbp_bias.n6 vbp_bias.t7 26.1327
R1225 vbp_bias.n1 vbp_bias.t25 25.8148
R1226 vbp_bias.n19 vbp_bias.t21 25.6872
R1227 vbp_bias.n15 vbp_bias.t17 25.6575
R1228 vbp_bias.n17 vbp_bias.t19 25.6514
R1229 vbp_bias.n7 vbp_bias.t11 25.32
R1230 vbp_bias.n11 vbp_bias.t13 24.3102
R1231 vbp_bias.n22 vbp_bias.t23 24.1122
R1232 vbp_bias.n6 vbp_bias.t9 23.2167
R1233 vbp_bias.n12 vbp_bias.t15 23.1942
R1234 vbp_bias.n2 vbp_bias.t27 16.8913
R1235 vbp_bias.n13 vbp_bias.t14 15.6757
R1236 vbp_bias.n7 vbp_bias.t12 14.7137
R1237 vbp_bias.n0 vbp_bias.n1 14.1755
R1238 vbp_bias.n10 vbp_bias.t8 13.9342
R1239 vbp_bias.n21 vbp_bias.t24 13.928
R1240 vbp_bias.n18 vbp_bias.t20 13.8407
R1241 vbp_bias.n3 vbp_bias.t4 13.8313
R1242 vbp_bias.n8 vbp_bias.t10 13.8083
R1243 vbp_bias.n20 vbp_bias.t22 13.8047
R1244 vbp_bias.n1 vbp_bias.t26 13.8047
R1245 vbp_bias.n16 vbp_bias.t18 13.8002
R1246 vbp_bias.n14 vbp_bias.t16 13.7948
R1247 vbp_bias.n2 vbp_bias.t5 13.7912
R1248 vbp_bias.n0 vbp_bias.t0 13.7912
R1249 vbp_bias.n4 vbp_bias.t3 12.3647
R1250 vbp_bias.n4 vbp_bias.t1 9.34477
R1251 vbp_bias.n5 vbp_bias.t6 9.33127
R1252 vbp_bias vbp_bias.n23 9.20003
R1253 vbp_bias.n1 vbp_bias.n4 7.5155
R1254 vbp_bias.n23 vbp_bias.n5 7.4705
R1255 vbp_bias.n5 vbp_bias.n0 7.3805
R1256 vbp_bias vbp_bias.t2 4.72664
R1257 vbp_bias.n0 vbp_bias.n3 3.0605
R1258 vbp_bias.n11 vbp_bias.n10 2.9705
R1259 vbp_bias.n3 vbp_bias.n2 2.8805
R1260 vbp_bias.n21 vbp_bias.n20 2.7905
R1261 vbp_bias.n13 vbp_bias.n12 2.4305
R1262 vbp_bias.n9 vbp_bias.n6 2.0705
R1263 vbp_bias.n22 vbp_bias.n21 2.0705
R1264 vbp_bias.n8 vbp_bias.n7 1.9805
R1265 vbp_bias.n19 vbp_bias.n18 1.8905
R1266 vbp_bias.n17 vbp_bias.n16 1.8905
R1267 vbp_bias.n15 vbp_bias.n14 1.8905
R1268 vbp_bias.n10 vbp_bias.n9 1.8905
R1269 vbp_bias.n12 vbp_bias.n11 1.8005
R1270 vbp_bias.n20 vbp_bias.n19 1.1705
R1271 vbp_bias.n18 vbp_bias.n17 0.9905
R1272 vbp_bias.n16 vbp_bias.n15 0.9905
R1273 vbp_bias.n14 vbp_bias.n13 0.9905
R1274 vbp_bias.n9 vbp_bias.n8 0.9005
R1275 vbn_sink.n4 vbn_sink.t27 24.6307
R1276 vbn_sink.n0 vbn_sink.t21 24.6181
R1277 vbn_sink.n16 vbn_sink.t13 22.5236
R1278 vbn_sink.n4 vbn_sink.t28 21.9622
R1279 vbn_sink.n6 vbn_sink.t30 21.9622
R1280 vbn_sink.n29 vbn_sink.t32 21.9622
R1281 vbn_sink.n0 vbn_sink.t22 21.9532
R1282 vbn_sink.n2 vbn_sink.t24 21.9532
R1283 vbn_sink.n5 vbn_sink.t29 21.9307
R1284 vbn_sink.n7 vbn_sink.t31 21.9307
R1285 vbn_sink.n1 vbn_sink.t23 21.9181
R1286 vbn_sink.n3 vbn_sink.t25 21.9181
R1287 vbn_sink.n17 vbn_sink.t15 21.5084
R1288 vbn_sink.n8 vbn_sink.t9 21.2325
R1289 vbn_sink.n12 vbn_sink.t17 16.8101
R1290 vbn_sink.n21 vbn_sink.t0 16.6875
R1291 vbn_sink.n26 vbn_sink.n25 14.1755
R1292 vbn_sink.n18 vbn_sink.t16 13.9332
R1293 vbn_sink.n16 vbn_sink.t14 13.9114
R1294 vbn_sink.n15 vbn_sink.t8 13.8851
R1295 vbn_sink.n12 vbn_sink.t18 13.8075
R1296 vbn_sink.n14 vbn_sink.t12 13.8075
R1297 vbn_sink.n9 vbn_sink.t6 13.8075
R1298 vbn_sink.n11 vbn_sink.t2 13.8075
R1299 vbn_sink.n24 vbn_sink.t4 13.8075
R1300 vbn_sink.n22 vbn_sink.t19 13.8075
R1301 vbn_sink.n10 vbn_sink.t7 13.7644
R1302 vbn_sink.n26 vbn_sink.t3 13.7644
R1303 vbn_sink.n13 vbn_sink.t11 13.7501
R1304 vbn_sink.n23 vbn_sink.t20 13.7337
R1305 vbn_sink.n21 vbn_sink.t1 13.7337
R1306 vbn_sink.n19 vbn_sink.n18 12.9605
R1307 vbn_sink vbn_sink.t26 12.8857
R1308 vbn_sink.n8 vbn_sink.t10 9.26438
R1309 vbn_sink vbn_sink.n30 9.248
R1310 vbn_sink.n20 vbn_sink.t5 9.2337
R1311 vbn_sink.n20 vbn_sink.n19 7.7405
R1312 vbn_sink.n9 vbn_sink.n8 7.5605
R1313 vbn_sink.n30 vbn_sink.n29 4.8605
R1314 vbn_sink.n25 vbn_sink.n20 4.6355
R1315 vbn_sink.n28 vbn_sink.n27 3.1505
R1316 vbn_sink.n22 vbn_sink.n21 3.0605
R1317 vbn_sink.n24 vbn_sink.n23 3.0605
R1318 vbn_sink.n14 vbn_sink.n13 3.0605
R1319 vbn_sink.n11 vbn_sink.n10 3.0605
R1320 vbn_sink.n23 vbn_sink.n22 2.8805
R1321 vbn_sink.n13 vbn_sink.n12 2.8805
R1322 vbn_sink.n10 vbn_sink.n9 2.8805
R1323 vbn_sink.n7 vbn_sink.n6 2.8805
R1324 vbn_sink.n5 vbn_sink.n4 2.8805
R1325 vbn_sink.n3 vbn_sink.n2 2.8805
R1326 vbn_sink.n1 vbn_sink.n0 2.8805
R1327 vbn_sink.n25 vbn_sink.n24 2.7905
R1328 vbn_sink.n15 vbn_sink.n14 2.7905
R1329 vbn_sink.n27 vbn_sink.n11 2.7905
R1330 vbn_sink.n6 vbn_sink.n5 2.7005
R1331 vbn_sink.n2 vbn_sink.n1 2.7005
R1332 vbn_sink.n30 vbn_sink.n3 2.5205
R1333 vbn_sink.n19 vbn_sink.n15 1.9355
R1334 vbn_sink.n17 vbn_sink.n16 1.8905
R1335 vbn_sink.n28 vbn_sink.n7 1.8005
R1336 vbn_sink.n18 vbn_sink.n17 1.1705
R1337 vbn_sink.n29 vbn_sink.n28 0.9005
R1338 vbn_sink.n27 vbn_sink.n26 0.1355
R1339 vbn_i.n5 vbn_i.n4 49.6967
R1340 vbn_i.n3 vbn_i.n1 48.7805
R1341 vbn_i.n0 vbn_i.t5 32.0695
R1342 vbn_i.n1 vbn_i.n0 29.5655
R1343 vbn_i.n6 vbn_i.n5 26.0749
R1344 vbn_i.n2 vbn_i.t7 20.6658
R1345 vbn_i.n1 vbn_i.t10 16.3059
R1346 vbn_i vbn_i.n9 14.87
R1347 vbn_i.n4 vbn_i.t11 14.5102
R1348 vbn_i.n7 vbn_i.t4 13.8322
R1349 vbn_i.n6 vbn_i.t3 13.7921
R1350 vbn_i.n8 vbn_i.t1 13.7921
R1351 vbn_i.n9 vbn_i.t2 13.7921
R1352 vbn_i.n2 vbn_i.t6 13.4854
R1353 vbn_i.n9 vbn_i.n8 11.3405
R1354 vbn_i.n0 vbn_i.t8 10.3992
R1355 vbn_i.n7 vbn_i.n6 8.6405
R1356 vbn_i.n4 vbn_i.n3 7.5605
R1357 vbn_i.n5 vbn_i.t9 5.72603
R1358 vbn_i vbn_i.t0 4.72757
R1359 vbn_i.n3 vbn_i.n2 4.5005
R1360 vbn_i.n8 vbn_i.n7 2.8805
R1361 y1.n2 y1.t1 82.8267
R1362 y1.n16 y1.n15 36.4505
R1363 y1.n5 y1.t12 36.316
R1364 y1.n10 y1.t18 36.2645
R1365 y1.n9 y1.t7 34.3675
R1366 y1.n7 y1.t9 34.3675
R1367 y1.n5 y1.t11 34.3675
R1368 y1.n8 y1.t8 34.336
R1369 y1.n14 y1.t13 34.3349
R1370 y1.n12 y1.t15 34.3349
R1371 y1.n10 y1.t17 34.3349
R1372 y1.n13 y1.t14 34.2845
R1373 y1.n6 y1.t10 29.836
R1374 y1.n11 y1.t16 29.7845
R1375 y1.n0 y1.t6 26.9336
R1376 y1.n3 y1.n2 11.8805
R1377 y1.n1 y1.n0 11.8355
R1378 y1.n1 y1.t4 9.38362
R1379 y1.n0 y1.t3 9.28871
R1380 y1.n2 y1.t2 9.27408
R1381 y1.n3 y1.t0 9.20433
R1382 y1.n7 y1.n6 6.4805
R1383 y1.n12 y1.n11 6.4805
R1384 y1.n6 y1.n5 6.3005
R1385 y1.n11 y1.n10 6.3005
R1386 y1.n4 y1.n1 6.1205
R1387 y1.n4 y1.n3 5.8505
R1388 y1.n15 y1.n9 5.7605
R1389 y1 y1.t5 4.69308
R1390 y1 y1.n16 4.5815
R1391 y1.n16 y1.n4 2.8355
R1392 y1.n9 y1.n8 1.9805
R1393 y1.n14 y1.n13 1.9805
R1394 y1.n8 y1.n7 1.8005
R1395 y1.n13 y1.n12 1.8005
R1396 y1.n15 y1.n14 0.2705
R1397 pm1.n8 pm1.n7 31.9955
R1398 pm1.n5 pm1.t3 28.451
R1399 pm1.n1 pm1.t11 26.8117
R1400 pm1.n4 pm1.t0 20.4924
R1401 pm1.n0 pm1.t7 16.6719
R1402 pm1.n5 pm1.t5 15.851
R1403 pm1.n6 pm1.n5 14.5355
R1404 pm1.n5 pm1.t4 13.9561
R1405 pm1.n0 pm1.t6 13.8821
R1406 pm1.n2 pm1.n1 12.1055
R1407 pm1.n3 pm1.n2 10.3955
R1408 pm1.n7 pm1.t2 9.28735
R1409 pm1.n2 pm1.t9 9.26171
R1410 pm1.n1 pm1.t8 9.23985
R1411 pm1.n4 pm1.t1 9.22476
R1412 pm1.n7 pm1.n6 8.4155
R1413 pm1.n8 pm1.n3 7.2905
R1414 pm1.n6 pm1.n4 6.3905
R1415 pm1.n3 pm1.n0 5.5805
R1416 pm1 pm1.t10 4.69308
R1417 pm1 pm1.n8 4.50934
R1418 vgn2.n7 vgn2.t8 51.9968
R1419 vgn2.n6 vgn2.n5 31.1405
R1420 vgn2.n0 vgn2.t10 30.4617
R1421 vgn2.n0 vgn2.t9 28.7139
R1422 vgn2.n7 vgn2.n6 23.1305
R1423 vgn2.n1 vgn2.t6 22.3387
R1424 vgn2.n2 vgn2.t1 16.5843
R1425 vgn2.n1 vgn2.t5 16.5787
R1426 vgn2.n1 vgn2.t3 13.8836
R1427 vgn2.n4 vgn2.t2 13.8393
R1428 vgn2.n5 vgn2.t4 13.8058
R1429 vgn2.n2 vgn2.t0 13.7741
R1430 vgn2.n6 vgn2.n0 9.9005
R1431 vgn2.n8 vgn2.t7 9.22128
R1432 vgn2.n8 vgn2.n7 7.3265
R1433 vgn2.n3 vgn2.n1 6.1205
R1434 vgn2.n4 vgn2.n3 5.7605
R1435 vgn2 vgn2.n8 4.5005
R1436 vgn2.n3 vgn2.n2 2.7905
R1437 vgn2.n5 vgn2.n4 2.7905
R1438 pm2 pm2.n8 45.4055
R1439 pm2.n0 pm2.t11 31.2449
R1440 pm2.n1 pm2.n0 21.1505
R1441 pm2.n4 pm2.t5 19.5811
R1442 pm2.n2 pm2.t8 16.2671
R1443 pm2.n6 pm2.t0 15.4348
R1444 pm2.n2 pm2.n1 15.3905
R1445 pm2.n4 pm2.t4 13.781
R1446 pm2.n8 pm2.t2 13.7248
R1447 pm2.n6 pm2.n5 10.7105
R1448 pm2.n3 pm2.n2 10.6205
R1449 pm2.n5 pm2.t3 9.3211
R1450 pm2.n7 pm2.t1 9.28735
R1451 pm2.n3 pm2.t6 9.20192
R1452 pm2.n7 pm2.n6 8.5505
R1453 pm2 pm2.n3 7.61787
R1454 pm2.n5 pm2.n4 6.7055
R1455 pm2.n8 pm2.n7 6.6605
R1456 pm2.n0 pm2.t9 4.76171
R1457 pm2 pm2.t7 4.74708
R1458 pm2.n1 pm2.t10 4.73985
R1459 vbp_cas.n30 vbp_cas.t20 48.2304
R1460 vbp_cas.n19 vbp_cas.n18 31.2305
R1461 vbp_cas.n7 vbp_cas.t12 30.3349
R1462 vbp_cas.n11 vbp_cas.t16 30.3349
R1463 vbp_cas.n24 vbp_cas.t27 27.5103
R1464 vbp_cas.n0 vbp_cas.t4 25.8619
R1465 vbp_cas.n8 vbp_cas.t18 25.4416
R1466 vbp_cas.n6 vbp_cas.t0 25.2769
R1467 vbp_cas.n1 vbp_cas.t6 25.2454
R1468 vbp_cas.n25 vbp_cas.t29 24.6303
R1469 vbp_cas.n27 vbp_cas.t31 24.6303
R1470 vbp_cas.n23 vbp_cas.t25 24.6303
R1471 vbp_cas.n24 vbp_cas.t28 24.5961
R1472 vbp_cas.n26 vbp_cas.t30 24.5961
R1473 vbp_cas.n28 vbp_cas.t32 24.5961
R1474 vbp_cas.n20 vbp_cas.t22 24.5673
R1475 vbp_cas.n22 vbp_cas.t24 24.5673
R1476 vbp_cas.n17 vbp_cas.t8 23.1349
R1477 vbp_cas.n0 vbp_cas.t2 23.1304
R1478 vbp_cas.n21 vbp_cas.t23 20.1303
R1479 vbp_cas.n19 vbp_cas.t21 20.1303
R1480 vbp_cas.n7 vbp_cas.t10 18.6016
R1481 vbp_cas.n11 vbp_cas.t14 18.6016
R1482 vbp_cas.n3 vbp_cas.n2 16.5605
R1483 vbp_cas vbp_cas.t26 15.5628
R1484 vbp_cas.n29 vbp_cas.n28 15.1655
R1485 vbp_cas.n1 vbp_cas.t7 14.6959
R1486 vbp_cas.n8 vbp_cas.t19 14.6824
R1487 vbp_cas.n15 vbp_cas.t9 13.9393
R1488 vbp_cas.n13 vbp_cas.t13 13.8043
R1489 vbp_cas.n9 vbp_cas.t17 13.8043
R1490 vbp_cas.n3 vbp_cas.t3 13.7959
R1491 vbp_cas.n10 vbp_cas.t15 13.7824
R1492 vbp_cas.n18 vbp_cas.n17 12.2855
R1493 vbp_cas.n2 vbp_cas.t5 9.31777
R1494 vbp_cas.n5 vbp_cas.t1 9.31777
R1495 vbp_cas.n14 vbp_cas.t11 9.28241
R1496 vbp_cas.n14 vbp_cas.n13 7.6055
R1497 vbp_cas.n20 vbp_cas.n19 7.3805
R1498 vbp_cas.n22 vbp_cas.n21 7.3805
R1499 vbp_cas.n15 vbp_cas.n14 7.2905
R1500 vbp_cas.n21 vbp_cas.n20 7.2005
R1501 vbp_cas.n12 vbp_cas.n11 6.8405
R1502 vbp_cas.n5 vbp_cas.n4 6.5255
R1503 vbp_cas.n2 vbp_cas.n1 6.5255
R1504 vbp_cas.n16 vbp_cas.n7 6.3005
R1505 vbp_cas.n6 vbp_cas.n5 5.5805
R1506 vbp_cas.n30 vbp_cas.n29 4.6805
R1507 vbp_cas vbp_cas.n30 4.505
R1508 vbp_cas.n10 vbp_cas.n9 3.0605
R1509 vbp_cas.n28 vbp_cas.n27 2.8805
R1510 vbp_cas.n26 vbp_cas.n25 2.8805
R1511 vbp_cas.n29 vbp_cas.n23 2.7005
R1512 vbp_cas.n23 vbp_cas.n22 2.7005
R1513 vbp_cas.n27 vbp_cas.n26 2.7005
R1514 vbp_cas.n25 vbp_cas.n24 2.7005
R1515 vbp_cas.n16 vbp_cas.n15 2.0705
R1516 vbp_cas.n4 vbp_cas.n0 2.0705
R1517 vbp_cas.n9 vbp_cas.n8 1.9805
R1518 vbp_cas.n13 vbp_cas.n12 1.9805
R1519 vbp_cas.n17 vbp_cas.n16 1.0805
R1520 vbp_cas.n12 vbp_cas.n10 0.9005
R1521 vbp_cas.n4 vbp_cas.n3 0.9005
R1522 vbp_cas.n18 vbp_cas.n6 0.1805
R1523 vaux vaux.n0 72.6164
R1524 vaux.n0 vaux.t0 15.5393
R1525 vaux.n0 vaux.t2 14.1443
R1526 vaux vaux.t1 4.76719
R1527 psrg_vnc.n4 psrg_vnc.n3 83.0705
R1528 psrg_vnc.n2 psrg_vnc.t9 60.8876
R1529 psrg_vnc.n3 psrg_vnc.t11 28.7139
R1530 psrg_vnc.n0 psrg_vnc.t8 24.5053
R1531 psrg_vnc.n2 psrg_vnc.t10 24.1617
R1532 psrg_vnc.n9 psrg_vnc.n1 14.2205
R1533 psrg_vnc.n0 psrg_vnc.t7 14.212
R1534 psrg_vnc.n6 psrg_vnc.t5 13.8246
R1535 psrg_vnc.n7 psrg_vnc.t0 13.7764
R1536 psrg_vnc.n5 psrg_vnc.t4 13.7764
R1537 psrg_vnc.n9 psrg_vnc.n8 11.0255
R1538 psrg_vnc.n8 psrg_vnc.t1 9.32463
R1539 psrg_vnc.n4 psrg_vnc.t6 9.32463
R1540 psrg_vnc.n1 psrg_vnc.t3 9.26409
R1541 psrg_vnc.n1 psrg_vnc.n0 9.1805
R1542 psrg_vnc.n8 psrg_vnc.n7 6.7055
R1543 psrg_vnc.n5 psrg_vnc.n4 6.4805
R1544 psrg_vnc.n3 psrg_vnc.n2 6.3005
R1545 psrg_vnc psrg_vnc.t2 4.74363
R1546 psrg_vnc psrg_vnc.n9 4.53323
R1547 psrg_vnc.n6 psrg_vnc.n5 2.1605
R1548 psrg_vnc.n7 psrg_vnc.n6 1.9805
R1549 vgn1.n4 vgn1.n3 77.1305
R1550 vgn1.n0 vgn1.t9 49.5595
R1551 vgn1.n2 vgn1.t7 30.1539
R1552 vgn1.n3 vgn1.t5 28.6617
R1553 vgn1.n1 vgn1.t6 13.9918
R1554 vgn1.n5 vgn1.t2 13.9078
R1555 vgn1.n6 vgn1.t0 13.8139
R1556 vgn1.n4 vgn1.t4 13.8139
R1557 vgn1.n7 vgn1.t3 13.7792
R1558 vgn1 vgn1.n7 11.0795
R1559 vgn1.n0 vgn1.t8 9.39692
R1560 vgn1.n7 vgn1.n6 6.6605
R1561 vgn1.n1 vgn1.n0 6.3905
R1562 vgn1.n6 vgn1.n5 6.3005
R1563 vgn1 vgn1.t1 4.75991
R1564 vgn1.n5 vgn1.n4 2.0705
R1565 vgn1.n2 vgn1.n1 1.5305
R1566 vgn1.n3 vgn1.n2 0.5405
R1567 vx3.n1 vx3.t5 23.1445
R1568 vx3.n6 vx3.t9 20.0487
R1569 vx3.n0 vx3.t6 19.9587
R1570 vx3.n2 vx3.n1 15.1655
R1571 vx3.n2 vx3.t1 14.1559
R1572 vx3.n4 vx3.n3 13.3655
R1573 vx3.n5 vx3.n4 10.6205
R1574 vx3.n5 vx3.t0 9.3826
R1575 vx3.n4 vx3.t7 9.3826
R1576 vx3.n2 vx3.t3 9.34091
R1577 vx3.n0 vx3.t8 9.33873
R1578 vx3.n3 vx3.t2 9.28037
R1579 vx3.n1 vx3.t4 9.28037
R1580 vx3.n5 vx3.n0 5.0405
R1581 vx3.n6 vx3.n5 4.8605
R1582 vx3 vx3.t10 4.75773
R1583 vx3 vx3.n6 4.5815
R1584 vx3.n3 vx3.n2 2.1605
R1585 vx1.n0 vx1.t9 18.2487
R1586 vx1.n6 vx1.t5 16.0009
R1587 vx1.n2 vx1.t2 15.7563
R1588 vx1.n0 vx1.t6 13.9737
R1589 vx1.n2 vx1.t1 13.8409
R1590 vx1.n7 vx1.t8 13.8387
R1591 vx1.n6 vx1.t4 13.7845
R1592 vx1.n3 vx1.t3 13.7804
R1593 vx1.n4 vx1.n3 11.2055
R1594 vx1.n4 vx1.t7 9.3826
R1595 vx1.n1 vx1.t0 9.3826
R1596 vx1.n1 vx1.n0 9.3155
R1597 vx1.n8 vx1.n5 9.1355
R1598 vx1.n8 vx1.n7 9.0455
R1599 vx1.n5 vx1.n4 8.9105
R1600 vx1.n3 vx1.n2 7.5605
R1601 vx1 vx1.t10 4.75773
R1602 vx1.n5 vx1.n1 4.6355
R1603 vx1 vx1.n8 4.5815
R1604 vx1.n7 vx1.n6 2.8805
R1605 vx2.n0 vx2.t0 23.3787
R1606 vx2.n4 vx2.t2 23.2009
R1607 vx2.n2 vx2.t1 13.9737
R1608 vx2.n3 vx2.t8 13.8826
R1609 vx2.n8 vx2.n0 13.8605
R1610 vx2.n7 vx2.t9 13.8387
R1611 vx2.n1 vx2.t4 13.5063
R1612 vx2.n8 vx2.n7 11.8805
R1613 vx2.n5 vx2.n4 11.2505
R1614 vx2.n6 vx2.n5 9.6305
R1615 vx2.n0 vx2.t10 9.3826
R1616 vx2.n4 vx2.t6 9.34091
R1617 vx2.n5 vx2.t3 9.28446
R1618 vx2.n1 vx2.t5 9.27627
R1619 vx2.n2 vx2.n1 5.7605
R1620 vx2.n3 vx2.n2 4.8155
R1621 vx2 vx2.t7 4.75773
R1622 vx2.n6 vx2.n3 4.6805
R1623 vx2 vx2.n8 4.5815
R1624 vx2.n7 vx2.n6 0.1355
R1625 psrg_m3_feed.n11 psrg_m3_feed.n10 67.6607
R1626 psrg_m3_feed.n12 psrg_m3_feed.n11 51.1655
R1627 psrg_m3_feed.n0 psrg_m3_feed.t9 49.1358
R1628 psrg_m3_feed.n4 psrg_m3_feed.t15 49.0656
R1629 psrg_m3_feed.n0 psrg_m3_feed.t10 47.6958
R1630 psrg_m3_feed.n1 psrg_m3_feed.t11 47.6958
R1631 psrg_m3_feed.n2 psrg_m3_feed.t12 47.6958
R1632 psrg_m3_feed.n3 psrg_m3_feed.t13 47.6958
R1633 psrg_m3_feed.n17 psrg_m3_feed.t23 47.6913
R1634 psrg_m3_feed.n18 psrg_m3_feed.t24 47.6913
R1635 psrg_m3_feed.n19 psrg_m3_feed.t25 47.6913
R1636 psrg_m3_feed.n20 psrg_m3_feed.t26 47.6913
R1637 psrg_m3_feed.n21 psrg_m3_feed.t27 47.6913
R1638 psrg_m3_feed.n22 psrg_m3_feed.t28 47.6913
R1639 psrg_m3_feed.n4 psrg_m3_feed.t16 47.6255
R1640 psrg_m3_feed.n5 psrg_m3_feed.t17 47.6255
R1641 psrg_m3_feed.n6 psrg_m3_feed.t18 47.6255
R1642 psrg_m3_feed.n7 psrg_m3_feed.t19 47.6255
R1643 psrg_m3_feed.n24 psrg_m3_feed.t20 47.6255
R1644 psrg_m3_feed psrg_m3_feed.t14 38.6237
R1645 psrg_m3_feed.n8 psrg_m3_feed.t21 36.8148
R1646 psrg_m3_feed.n8 psrg_m3_feed.t22 35.3747
R1647 psrg_m3_feed.n10 psrg_m3_feed.t5 27.7165
R1648 psrg_m3_feed.n10 psrg_m3_feed.n9 25.5155
R1649 psrg_m3_feed.n15 psrg_m3_feed.n12 21.2855
R1650 psrg_m3_feed.n9 psrg_m3_feed.t7 15.9268
R1651 psrg_m3_feed.n13 psrg_m3_feed.t3 15.7039
R1652 psrg_m3_feed.n9 psrg_m3_feed.t6 14.0319
R1653 psrg_m3_feed.n13 psrg_m3_feed.t4 13.9142
R1654 psrg_m3_feed.n16 psrg_m3_feed.t0 13.8139
R1655 psrg_m3_feed.n14 psrg_m3_feed.t2 13.776
R1656 psrg_m3_feed.n11 psrg_m3_feed.t8 11.7515
R1657 psrg_m3_feed.n15 psrg_m3_feed.n14 11.0255
R1658 psrg_m3_feed.n15 psrg_m3_feed.t1 9.31391
R1659 psrg_m3_feed psrg_m3_feed.n25 9.2525
R1660 psrg_m3_feed.n16 psrg_m3_feed.n15 8.4605
R1661 psrg_m3_feed.n23 psrg_m3_feed.n22 4.8605
R1662 psrg_m3_feed.n25 psrg_m3_feed.n24 4.8605
R1663 psrg_m3_feed.n14 psrg_m3_feed.n13 4.5905
R1664 psrg_m3_feed.n17 psrg_m3_feed.n16 4.4105
R1665 psrg_m3_feed.n12 psrg_m3_feed.n8 3.6005
R1666 psrg_m3_feed.n22 psrg_m3_feed.n21 1.4405
R1667 psrg_m3_feed.n21 psrg_m3_feed.n20 1.4405
R1668 psrg_m3_feed.n20 psrg_m3_feed.n19 1.4405
R1669 psrg_m3_feed.n19 psrg_m3_feed.n18 1.4405
R1670 psrg_m3_feed.n18 psrg_m3_feed.n17 1.4405
R1671 psrg_m3_feed.n7 psrg_m3_feed.n6 1.4405
R1672 psrg_m3_feed.n6 psrg_m3_feed.n5 1.4405
R1673 psrg_m3_feed.n5 psrg_m3_feed.n4 1.4405
R1674 psrg_m3_feed.n3 psrg_m3_feed.n2 1.4405
R1675 psrg_m3_feed.n2 psrg_m3_feed.n1 1.4405
R1676 psrg_m3_feed.n1 psrg_m3_feed.n0 1.4405
R1677 psrg_m3_feed.n23 psrg_m3_feed.n7 1.2605
R1678 psrg_m3_feed.n25 psrg_m3_feed.n3 1.2605
R1679 psrg_m3_feed.n24 psrg_m3_feed.n23 0.1805
R1680 vbp_i.n1 vbp_i.t36 313.836
R1681 vbp_i.n1 vbp_i.t35 312.575
R1682 vbp_i.n31 vbp_i.n30 42.6605
R1683 vbp_i.n36 vbp_i.t53 31.74
R1684 vbp_i.n31 vbp_i.t48 31.5915
R1685 vbp_i.n33 vbp_i.t50 31.5915
R1686 vbp_i.n37 vbp_i.t52 31.5915
R1687 vbp_i.n32 vbp_i.t49 31.56
R1688 vbp_i.n38 vbp_i.t51 31.56
R1689 vbp_i.n35 vbp_i.t54 31.5146
R1690 vbp_i.n34 vbp_i.t56 26.4981
R1691 vbp_i.n7 vbp_i.t17 26.0243
R1692 vbp_i.n25 vbp_i.t43 26.024
R1693 vbp_i.n2 vbp_i.t11 25.9874
R1694 vbp_i.n40 vbp_i.t37 25.953
R1695 vbp_i.n20 vbp_i.t29 25.8017
R1696 vbp_i.n7 vbp_i.t18 23.1758
R1697 vbp_i.n9 vbp_i.t20 23.1758
R1698 vbp_i.n11 vbp_i.t22 23.1758
R1699 vbp_i.n14 vbp_i.t24 23.1643
R1700 vbp_i.n16 vbp_i.t26 23.1643
R1701 vbp_i.n18 vbp_i.t28 23.1643
R1702 vbp_i.n2 vbp_i.t12 23.1623
R1703 vbp_i.n4 vbp_i.t14 23.1623
R1704 vbp_i.n6 vbp_i.t16 23.1623
R1705 vbp_i.n8 vbp_i.t19 23.1443
R1706 vbp_i.n10 vbp_i.t21 23.1443
R1707 vbp_i.n20 vbp_i.t30 23.144
R1708 vbp_i.n22 vbp_i.t32 23.144
R1709 vbp_i.n24 vbp_i.t34 23.144
R1710 vbp_i.n26 vbp_i.t45 23.144
R1711 vbp_i.n28 vbp_i.t47 23.144
R1712 vbp_i.n13 vbp_i.t23 23.1328
R1713 vbp_i.n15 vbp_i.t25 23.1328
R1714 vbp_i.n17 vbp_i.t27 23.1328
R1715 vbp_i.n3 vbp_i.t13 23.1074
R1716 vbp_i.n5 vbp_i.t15 23.1074
R1717 vbp_i.n21 vbp_i.t31 23.1017
R1718 vbp_i.n23 vbp_i.t33 23.1017
R1719 vbp_i.n25 vbp_i.t44 23.0783
R1720 vbp_i.n27 vbp_i.t46 23.0783
R1721 vbp_i.n43 vbp_i.t6 23.073
R1722 vbp_i.n46 vbp_i.t39 23.073
R1723 vbp_i.n47 vbp_i.t4 23.073
R1724 vbp_i.n50 vbp_i.t40 23.073
R1725 vbp_i.n40 vbp_i.t8 23.0415
R1726 vbp_i.n45 vbp_i.t38 23.0415
R1727 vbp_i.n49 vbp_i.t2 23.0415
R1728 vbp_i.n52 vbp_i.t0 23.0415
R1729 vbp_i.n39 vbp_i.n38 17.8205
R1730 vbp_i.n0 vbp_i.t5 16.7621
R1731 vbp_i.n41 vbp_i.t9 16.6222
R1732 vbp_i.n51 vbp_i.t1 15.9472
R1733 vbp_i.n36 vbp_i.n35 14.2655
R1734 vbp_i.n30 vbp_i.t10 14.0219
R1735 vbp_i vbp_i.t41 13.9853
R1736 vbp_i.n0 vbp_i.t3 13.9672
R1737 vbp_i.n41 vbp_i.t7 13.9271
R1738 vbp_i.n34 vbp_i.t55 13.8317
R1739 vbp_i.n39 vbp_i.t42 13.8039
R1740 vbp_i.n19 vbp_i.n18 12.6455
R1741 vbp_i vbp_i.n52 11.7883
R1742 vbp_i.n13 vbp_i.n12 7.4705
R1743 vbp_i.n30 vbp_i.n29 5.7605
R1744 vbp_i.n47 vbp_i.n46 5.5805
R1745 vbp_i.n12 vbp_i.n6 5.4005
R1746 vbp_i.n29 vbp_i.n24 4.8605
R1747 vbp_i.n35 vbp_i.n34 4.1405
R1748 vbp_i.n23 vbp_i.n22 2.8805
R1749 vbp_i.n21 vbp_i.n20 2.8805
R1750 vbp_i.n17 vbp_i.n16 2.8805
R1751 vbp_i.n15 vbp_i.n14 2.8805
R1752 vbp_i.n11 vbp_i.n10 2.8805
R1753 vbp_i.n9 vbp_i.n8 2.8805
R1754 vbp_i.n6 vbp_i.n5 2.8805
R1755 vbp_i.n4 vbp_i.n3 2.8805
R1756 vbp_i.n27 vbp_i.n26 2.8805
R1757 vbp_i.n50 vbp_i.n49 2.7005
R1758 vbp_i.n46 vbp_i.n45 2.7005
R1759 vbp_i.n24 vbp_i.n23 2.7005
R1760 vbp_i.n22 vbp_i.n21 2.7005
R1761 vbp_i.n18 vbp_i.n17 2.7005
R1762 vbp_i.n16 vbp_i.n15 2.7005
R1763 vbp_i.n14 vbp_i.n13 2.7005
R1764 vbp_i.n10 vbp_i.n9 2.7005
R1765 vbp_i.n8 vbp_i.n7 2.7005
R1766 vbp_i.n5 vbp_i.n4 2.7005
R1767 vbp_i.n3 vbp_i.n2 2.7005
R1768 vbp_i.n28 vbp_i.n27 2.7005
R1769 vbp_i.n26 vbp_i.n25 2.7005
R1770 vbp_i.n19 vbp_i.n1 2.1605
R1771 vbp_i.n51 vbp_i.n50 1.9805
R1772 vbp_i.n48 vbp_i.n47 1.9805
R1773 vbp_i.n38 vbp_i.n33 1.9805
R1774 vbp_i.n32 vbp_i.n31 1.9805
R1775 vbp_i.n42 vbp_i.n41 1.8905
R1776 vbp_i.n48 vbp_i.n0 1.8905
R1777 vbp_i.n24 vbp_i.n19 1.8905
R1778 vbp_i.n45 vbp_i.n44 1.8005
R1779 vbp_i.n42 vbp_i.n40 1.8005
R1780 vbp_i.n37 vbp_i.n36 1.8005
R1781 vbp_i.n38 vbp_i.n37 1.8005
R1782 vbp_i.n33 vbp_i.n32 1.8005
R1783 vbp_i.n44 vbp_i.n39 1.6205
R1784 vbp_i.n44 vbp_i.n43 1.0805
R1785 vbp_i.n52 vbp_i.n51 0.9005
R1786 vbp_i.n49 vbp_i.n48 0.9005
R1787 vbp_i.n43 vbp_i.n42 0.9005
R1788 vbp_i.n29 vbp_i.n28 0.6305
R1789 vbp_i.n12 vbp_i.n11 0.1805
R1790 b3_b b3_b.t2 413.057
R1791 b3_b.n0 b3_b.t0 30.5101
R1792 b3_b.n0 b3_b.t1 18.2995
R1793 b3_b b3_b.n0 11.9367
R1794 b1_b.n1 b1_b.t2 552.784
R1795 b1_b.n2 b1_b.t3 552.491
R1796 b1_b b1_b.t4 543.413
R1797 b1_b.n0 b1_b.t1 19.0513
R1798 b1_b.n0 b1_b.t0 17.9371
R1799 b1_b b1_b.n2 9.91021
R1800 b1_b.n1 b1_b.n0 7.6505
R1801 b1_b.n2 b1_b.n1 0.7205
R1802 vq3.n0 vq3 86.063
R1803 vq3.n0 vq3.t2 28.5582
R1804 vq3 vq3.n1 21.2567
R1805 vq3.n1 vq3.n0 14.3555
R1806 vq3.n1 vq3.t1 13.5475
R1807 vq3 vq3.t0 5.63583
R1808 b6_b b6_b.t2 70.8681
R1809 b6_b.n0 b6_b.t1 27.1512
R1810 b6_b.n0 b6_b.t0 24.2956
R1811 b6_b b6_b.n0 8.52575
R1812 b4_b b4_b.t2 217.519
R1813 b4_b.n0 b4_b.t1 38.4035
R1814 b4_b.n0 b4_b.t0 20.5606
R1815 b4_b b4_b.n0 19.2897
R1816 b0_b.n1 b0_b.t2 552.495
R1817 b0_b.n3 b0_b.t4 552.482
R1818 b0_b.n2 b0_b.t3 552.424
R1819 b0_b.n4 b0_b.t5 547.922
R1820 b0_b.n5 b0_b.t6 547.922
R1821 b0_b b0_b.t7 543.413
R1822 b0_b.n0 b0_b.t0 21.7749
R1823 b0_b.n0 b0_b.t1 18.3369
R1824 b0_b b0_b.n5 14.4612
R1825 b0_b.n5 b0_b.n4 10.0805
R1826 b0_b.n1 b0_b.n0 5.8055
R1827 b0_b.n4 b0_b.n3 5.4005
R1828 b0_b.n3 b0_b.n2 1.0805
R1829 b0_b.n2 b0_b.n1 1.0805
R1830 rbit0top.n1 rbit0top.t0 47.8149
R1831 rbit0top.n1 rbit0top.t1 27.35
R1832 rbit0top.n2 rbit0top.n1 24.7955
R1833 rbit0top.n0 rbit0top.t8 14.9729
R1834 rbit0top.n3 rbit0top.t6 13.6904
R1835 rbit0top.n0 rbit0top.t9 13.6898
R1836 rbit0top.n5 rbit0top.t7 13.6634
R1837 rbit0top.n7 rbit0top.t4 13.6544
R1838 rbit0top.n4 rbit0top.t3 13.6145
R1839 rbit0top rbit0top.n7 10.3573
R1840 rbit0top.n6 rbit0top.n0 10.2155
R1841 rbit0top.n2 rbit0top.t5 9.11555
R1842 rbit0top.n3 rbit0top.n2 5.7605
R1843 rbit0top rbit0top.t2 4.60718
R1844 rbit0top.n5 rbit0top.n4 1.2605
R1845 rbit0top.n4 rbit0top.n3 1.0805
R1846 rbit0top.n6 rbit0top.n5 0.8105
R1847 rbit0top.n7 rbit0top.n6 0.2705
R1848 rbit1top.n2 rbit1top.n1 31.9505
R1849 rbit1top.n1 rbit1top.t0 22.274
R1850 rbit1top.n0 rbit1top.t13 14.8598
R1851 rbit1top.n7 rbit1top.t7 13.8254
R1852 rbit1top.n9 rbit1top.t5 13.7984
R1853 rbit1top.n10 rbit1top.t4 13.7894
R1854 rbit1top.n2 rbit1top.t2 13.7888
R1855 rbit1top.n0 rbit1top.t12 13.7579
R1856 rbit1top.n8 rbit1top.t6 13.7495
R1857 rbit1top.n3 rbit1top.t10 13.6949
R1858 rbit1top.n5 rbit1top.t9 13.6724
R1859 rbit1top.n6 rbit1top.t8 13.6155
R1860 rbit1top.n4 rbit1top.t11 13.6152
R1861 rbit1top.n11 rbit1top.n0 10.3055
R1862 rbit1top.n1 rbit1top.t1 10.142
R1863 rbit1top rbit1top.n11 9.00729
R1864 rbit1top rbit1top.t3 4.60718
R1865 rbit1top.n3 rbit1top.n2 1.5305
R1866 rbit1top.n5 rbit1top.n4 1.2605
R1867 rbit1top.n4 rbit1top.n3 1.2605
R1868 rbit1top.n11 rbit1top.n10 1.2155
R1869 rbit1top.n7 rbit1top.n6 1.1705
R1870 rbit1top.n6 rbit1top.n5 1.0805
R1871 rbit1top.n9 rbit1top.n8 1.0805
R1872 rbit1top.n10 rbit1top.n9 0.9005
R1873 rbit1top.n8 rbit1top.n7 0.9005
R1874 rbit2top.n1 rbit2top.n0 34.9521
R1875 rbit2top.n0 rbit2top.t2 25.739
R1876 rbit2top.n4 rbit2top.t1 15.0003
R1877 rbit2top.n5 rbit2top.t9 13.9426
R1878 rbit2top.n4 rbit2top.t3 13.9336
R1879 rbit2top.n6 rbit2top.t8 13.8011
R1880 rbit2top.n3 rbit2top.t6 13.7502
R1881 rbit2top.n2 rbit2top.t7 13.6949
R1882 rbit2top.n7 rbit2top.n6 11.9255
R1883 rbit2top.n6 rbit2top.n5 10.6655
R1884 rbit2top.n0 rbit2top.t0 10.106
R1885 rbit2top rbit2top.n7 9.20075
R1886 rbit2top.n1 rbit2top.t4 9.11557
R1887 rbit2top.n2 rbit2top.n1 5.5805
R1888 rbit2top rbit2top.t5 4.60718
R1889 rbit2top.n3 rbit2top.n2 1.1705
R1890 rbit2top.n7 rbit2top.n3 1.0805
R1891 rbit2top.n5 rbit2top.n4 0.9005
R1892 b2_b.n1 b2_b.t2 291.709
R1893 b2_b.n2 b2_b.t3 291.709
R1894 b2_b b2_b.t4 282.7
R1895 b2_b.n0 b2_b.t0 29.7878
R1896 b2_b.n1 b2_b.n0 29.7455
R1897 b2_b b2_b.n2 9.96125
R1898 b2_b.n0 b2_b.t1 9.37191
R1899 b2_b.n2 b2_b.n1 1.0805
R1900 rbit6top.n2 rbit6top.t5 20.1082
R1901 rbit6top rbit6top.n3 16.4243
R1902 rbit6top.n2 rbit6top.t3 16.2905
R1903 rbit6top.n3 rbit6top.n0 11.8353
R1904 rbit6top.n3 rbit6top.t1 10.197
R1905 rbit6top.n1 rbit6top.n2 9.5405
R1906 rbit6top.n1 rbit6top.t2 9.02203
R1907 rbit6top.n1 rbit6top.n0 4.4644
R1908 rbit6top rbit6top.t0 5.06817
R1909 rbit6top.n0 rbit6top.t4 17.5032
R1910 rbit5top.n2 rbit5top.n1 30.1505
R1911 rbit5top rbit5top.t2 29.4175
R1912 rbit5top.n1 rbit5top.t1 28.961
R1913 rbit5top rbit5top.n2 16.7383
R1914 rbit5top.n2 rbit5top.n0 12.9155
R1915 rbit5top.n0 rbit5top.t0 11.3205
R1916 rbit5top.n0 rbit5top.t5 9.9581
R1917 rbit5top.n1 rbit5top.t3 5.59703
R1918 rbit5top rbit5top.t4 4.78433
R1919 b5_b b5_b.t2 119.752
R1920 b5_b b5_b.n0 34.8211
R1921 b5_b.n0 b5_b.t0 31.9875
R1922 b5_b.n0 b5_b.t1 9.33465
R1923 rbit3top.n0 rbit3top.t0 38.816
R1924 rbit3top.n3 rbit3top.n0 34.9205
R1925 rbit3top.n1 rbit3top.t5 18.735
R1926 rbit3top.n0 rbit3top.t1 15.7715
R1927 rbit3top.n5 rbit3top.n4 15.2105
R1928 rbit3top.n1 rbit3top.t2 13.9653
R1929 rbit3top.n4 rbit3top.t4 13.8076
R1930 rbit3top.n2 rbit3top.t3 13.7986
R1931 rbit3top rbit3top.n5 12.5895
R1932 rbit3top.n5 rbit3top.t7 9.43613
R1933 rbit3top rbit3top.t6 4.64242
R1934 rbit3top.n2 rbit3top.n1 1.0805
R1935 rbit3top.n3 rbit3top.n2 0.9905
R1936 rbit3top.n4 rbit3top.n3 0.1355
R1937 rbit4top.n2 rbit4top.t0 31.76
R1938 rbit4top.n3 rbit4top.n2 20.2505
R1939 rbit4top.n0 rbit4top.t1 17.61
R1940 rbit4top.n1 rbit4top.n0 17.0555
R1941 rbit4top.n0 rbit4top.t5 14.5188
R1942 rbit4top.n1 rbit4top.t3 13.9981
R1943 rbit4top.n3 rbit4top.n1 12.2405
R1944 rbit4top.n2 rbit4top.t2 10.097
R1945 rbit4top rbit4top.t4 4.64242
R1946 rbit4top rbit4top.n3 4.53446
C0 vbp_i vbn_fold 11.739f
C1 rbit1top b1 0.87742f
C2 v2 iref_gate 0.64906f
C3 y1 iref_gate 0.10436f
C4 vbn_i vsu 0.3708f
C5 b5 b0_b 0.19552f
C6 psrg_m3_feed avdd 56.31682f
C7 v1 vq2 0.28351f
C8 rbit4top b4 0.21187f
C9 vsp avdd 0.10386p
C10 vbp_i vbp_tail 3.35896f
C11 dvss b2_b 1.96288f
C12 b6 b4_b 0.16695f
C13 b0 b2_b 1.29126f
C14 rbit0top avdd 0.11793f
C15 b4 rbit2top 0.2024f
C16 b5 rbit0top 0.25231f
C17 psrg_m3_feed iref_gate 1.06745f
C18 b4_b b6_b 0.9559f
C19 b3 b5_b 0.3282f
C20 vbp_tail net3 1.05691f
C21 b5 rbit5top 0.17375f
C22 vsp iref_gate 0.81681f
C23 dvss rbit6top 1.79096f
C24 xf1 psrg_mf1_protected 0.13981f
C25 vbn_fold aux_gate 0.62924f
C26 rbit2top b1 1.03686f
C27 vx3 avdd 31.8324f
C28 b0 rbit6top 0.45856f
C29 rbit1top avdd 0.17165f
C30 psrg_m3_feed vq2 5.12005f
C31 b5 rbit1top 0.27554f
C32 vbp_i pm2 1.23585f
C33 b1_b b1 3.74994f
C34 vbn vgn2 0.12496f
C35 b3 rbit3top 0.44919f
C36 vq3 b3 1.1684f
C37 vbp_tail aux_gate 1.99643f
C38 pm2 pm1 12.1903f
C39 xf1 vbp_i 0.73622f
C40 b4 b4_b 0.6945f
C41 vbn_i vbn_fold 2.11959f
C42 vbp_i vsu1 0.29412f
C43 vbn vcasp 6.46858f
C44 vbp_cas vbp_tail 0.20385f
C45 vbp_i net4 0.68274f
C46 rbit4top b5 0.14768f
C47 su_state vbn 0.51024f
C48 vbn_sink vsu 2.45374f
C49 b1 b4_b 0.21877f
C50 b3 b2_b 1.45425f
C51 vgn2 vcasp 0.26958f
C52 vbn_i vbp_tail 6.61404f
C53 b3_b dvss 0.96866f
C54 vaux vbn 0.18148f
C55 su_state vgn2 0.12044f
C56 vbn_i vnx_bias 0.1277f
C57 net4 net3 0.21018f
C58 v1 vbn 0.2475f
C59 vbn v2 0.52261f
C60 b3 rbit6top 0.28161f
C61 vbp_cas pm2 9.58589f
C62 psrg_vnc avdd 27.3707f
C63 vaux vgn2 0.16422f
C64 vbn_i psrg_m3_protected 0.26514f
C65 vbp_i pm1 1.8438f
C66 vbp_i net3 2.05787f
C67 v2 vgn2 1.50463f
C68 dvss b6 2.47367f
C69 y1 vgn2 3.98685f
C70 su_state vcasp 0.12217f
C71 b4 b2 0.16147f
C72 vq3 pm2 1.76859f
C73 dvss b6_b 2.06579f
C74 vgn1 vbn_fold 0.21297f
C75 vbp_tail vsua 1.33691f
C76 psrg_m3_feed vbn 0.43041f
C77 vaux vcasp 0.65926f
C78 b5 b4_b 0.97427f
C79 rb_mid aux_gate 0.19126f
C80 v1 vcasp 0.19797f
C81 vbp_i aux_gate 0.24491f
C82 vsu2 vcasp 0.27825f
C83 xf1 vbn_i 0.23103f
C84 vbp_cas net4 5.13989f
C85 rfix1 rfix2 0.18834f
C86 b0_b dvdd 5.68882f
C87 b2 b1 1.18477f
C88 v2 vcasp 0.34754f
C89 vx2 vcasp 4.94163f
C90 vbn_fold vbn_sink 1.45062f
C91 vbp_tail vbp_bias 0.32402f
C92 vbn_i net4 0.42336f
C93 vref vcasp 4.83961f
C94 vbp_cas vbp_i 3.26422f
C95 b3_b b3 0.42582f
C96 net4 vq3 0.41149f
C97 pm2 vsua 0.22691f
C98 rbit0top dvdd 30.0793f
C99 vaux y1 0.16463f
C100 v1 v2 14.6926f
C101 b4 dvss 1.42112f
C102 y1 v1 0.18075f
C103 vbp_i vbn_i 11.9574f
C104 psrg_m3_feed vcasp 5.73849f
C105 vbp_tail vbn_sink 1.51169f
C106 rb_mid vq3 0.15374f
C107 dvdd rbit5top 4.67329f
C108 y1 v2 2.94204f
C109 vbp_cas pm1 7.99879f
C110 vbp_i vq3 2.67766f
C111 pm2 vbp_bias 0.17989f
C112 rbit1top dvdd 43.2764f
C113 dvss b1 1.83316f
C114 b3 b6 1.75404f
C115 vbn_i net3 0.1723f
C116 vaux psrg_m3_feed 0.8277f
C117 vref vx2 0.43052f
C118 b0 b1 0.49485f
C119 b5 b2 1.78164f
C120 psrg_m3_feed v1 0.72526f
C121 vsu2 psrg_m3_feed 0.28512f
C122 vq3 pm1 0.33579f
C123 b3 b6_b 0.19347f
C124 xf1 vbp_bias 0.26006f
C125 psrg_m3_feed v2 0.87255f
C126 vbp_cas aux_gate 0.22496f
C127 vsp v1 10.4163f
C128 y1 psrg_m3_feed 0.53507f
C129 vx3 vcasp 5.08699f
C130 vgn1 vsu1 0.18706f
C131 xf2 vsu 2.81892f
C132 psrg_m3_feed vx2 8.91396f
C133 vsu1 vbp_bias 0.96396f
C134 vsp v2 11.157f
C135 vbp_i vsua 1.30631f
C136 vref psrg_m3_feed 1.24892f
C137 vsp y1 0.10341f
C138 vgn1 net4 6.11043f
C139 vbn_i aux_gate 6.22113f
C140 rbit4top dvdd 8.20952f
C141 xf1 vbn_sink 6.86035f
C142 vref rbit0top 2.72432f
C143 rbit2top dvdd 24.2054f
C144 pm1 vsua 0.2836f
C145 vbp_i vgn1 1.18073f
C146 vbp_i vbp_bias 0.9516f
C147 vbp_cas vbn_i 0.56771f
C148 rbit3top b5_b 0.10459f
C149 b1_b dvdd 2.347f
C150 psrg_vnc vbn 0.43313f
C151 b5 dvss 2.67566f
C152 b4 b3 4.31308f
C153 rbit0top b0_b 2.21042f
C154 vsp psrg_m3_feed 0.30249f
C155 vx3 vx2 0.71594f
C156 vref vx3 3.45456f
C157 vref rbit1top 4.41895f
C158 psrg_vnc vgn2 1.12358f
C159 auxsu1 vsua 0.37587f
C160 b0_b rbit5top 0.1439f
C161 pm1 vbp_bias 1.15892f
C162 net3 vbp_bias 0.16448f
C163 vbp_i vbn_sink 18.4909f
C164 avdd vsu 7.09342f
C165 b3 b1 0.25065f
C166 rbit1top b0_b 2.12085f
C167 vx3 psrg_m3_feed 4.80132f
C168 rbit0top rbit5top 0.19256f
C169 net3 vbn_sink 0.16702f
C170 dvdd b4_b 2.58898f
C171 vbp_cas vsua 3.61284f
C172 psrg_vnc vcasp 0.89989f
C173 vgn1 aux_gate 1.95059f
C174 vsu iref_gate 7.17726f
C175 vbn_fold xf2 2.80397f
C176 rbit1top rbit0top 31.6753f
C177 rbit6top b5_b 0.21464f
C178 b2_b rbit3top 1.66075f
C179 vq3 b2_b 0.17628f
C180 vq2 vsu 0.3692f
C181 vref rbit2top 3.66787f
C182 vbp_cas vgn1 1.32053f
C183 rbit4top b0_b 0.1617f
C184 vaux psrg_vnc 0.10578f
C185 vbp_cas vbp_bias 17.5596f
C186 psrg_vnc v1 0.25909f
C187 vbp_tail xf2 0.90034f
C188 b0_b rbit2top 0.14501f
C189 psrg_vnc v2 0.60375f
C190 b5 b3 0.59668f
C191 psrg_vnc y1 1.12938f
C192 vgn1 vbn_i 9.07292f
C193 vbn_i vbp_bias 1.76868f
C194 rbit6top rbit3top 0.82438f
C195 vq3 rbit6top 6.45544f
C196 vgn1 vx1 3.13047f
C197 vq3 vbp_bias 0.90325f
C198 vbp_cas vbn_sink 0.81593f
C199 rbit0top rbit2top 2.73172f
C200 vbn_fold avdd 41.9818f
C201 rbit4top rbit5top 3.70078f
C202 vbn_i vbn_sink 0.86756f
C203 dvdd b2 3.60905f
C204 psrg_vnc psrg_m3_feed 2.17271f
C205 rbit2top rbit5top 0.16828f
C206 rbit6top b2_b 0.24114f
C207 b1_b rbit5top 0.28902f
C208 b3_b b5_b 0.12774f
C209 vbp_tail avdd 50.0761f
C210 rbit1top rbit2top 17.7916f
C211 vbn_fold iref_gate 0.71284f
C212 xf1 xf2 6.24477f
C213 vbp_bias vsua 0.44161f
C214 avdd vnx_bias 0.38981f
C215 b1_b rbit1top 1.0224f
C216 b3_b rbit3top 0.57452f
C217 vbp_tail iref_gate 3.91782f
C218 vref rfix0 0.8496f
C219 vgn1 vbp_bias 0.45212f
C220 vbn_sink vsua 1.50022f
C221 b6 b5_b 0.15457f
C222 avdd pm2 44.0287f
C223 dvss dvdd 7.99298f
C224 rbit4top rbit2top 2.63156f
C225 b0 dvdd 2.75392f
C226 rbit5top b4_b 0.81654f
C227 vbn vsu 0.70477f
C228 vbn_sink vbp_bias 0.82732f
C229 b6 rbit3top 0.38535f
C230 xf1 avdd 38.9184f
C231 b1_b rbit2top 1.01233f
C232 b3_b b2_b 0.14987f
C233 vq3 b6 0.60932f
C234 rfix0 rbit0top 0.22803f
C235 avdd vsu1 2.71121f
C236 rbit3top b6_b 0.12518f
C237 vq3 b6_b 0.64539f
C238 b0_b b2 0.76689f
C239 net4 avdd 4.50198f
C240 xf1 iref_gate 1.94173f
C241 b4 b5_b 4.7115f
C242 rb_mid avdd 0.8068f
C243 vcasp vsu 0.24537f
C244 bgsu1 bgsu2 0.41323f
C245 vbp_i avdd 0.21371p
C246 rbit4top b4_b 0.64833f
C247 rbit0top b2 0.30397f
C248 su_state vsu 0.22274f
C249 b2 rbit5top 0.20686f
C250 b1_b b4_b 0.12858f
C251 vbp_cas xf2 0.14767f
C252 b4 vq3 0.10345f
C253 avdd pm1 43.3937f
C254 v1 vsu 0.4387f
C255 rbit6top b6 0.2823f
C256 avdd net3 8.51088f
C257 b3 dvdd 2.41974f
C258 vbp_i iref_gate 6.12357f
C259 rbit1top b2 0.89353f
C260 v2 vsu 0.63194f
C261 vbn_fold vbn 0.19588f
C262 b0_b dvss 1.0362f
C263 vbn_i xf2 0.526f
C264 rfix0 rbit4top 0.21062f
C265 rbit6top b6_b 0.1563f
C266 b0 b0_b 2.81287f
C267 vq3 b1 0.1123f
C268 rfix0 rbit2top 0.85625f
C269 vbn_fold vgn2 1.02751f
C270 avdd aux_gate 5.05412f
C271 rbit0top dvss 8.74257f
C272 b4 b2_b 0.30466f
C273 vbp_tail vbn 0.12664f
C274 b0 rbit0top 1.1838f
C275 psrg_m3_feed vsu 2.198f
C276 rbit4top b2 0.21125f
C277 dvss rbit5top 1.97323f
C278 b0 rbit5top 1.08329f
C279 b5 b5_b 0.86786f
C280 vsp vsu 0.85839f
C281 vbp_cas avdd 0.10076p
C282 b2_b b1 0.31456f
C283 rbit2top b2 0.27743f
C284 rbit1top dvss 12.9565f
C285 vsua xf2 0.12641f
C286 b0 rbit1top 0.98106f
C287 b3_b b6 1.01578f
C288 vbn_i avdd 21.9598f
C289 vx1 avdd 35.2473f
C290 psrg_m3_protected vgn2 1.45949f
C291 vq3 avdd 3.1344f
C292 b3_b b6_b 0.16107f
C293 b5 rbit3top 0.17918f
C294 b5 vq3 0.13324f
C295 v1 vbn_fold 0.60807f
C296 vbp_bias xf2 0.32149f
C297 pm2 vgn2 2.38974f
C298 vnx_bias vcasp 0.17898f
C299 b0_b b3 0.6222f
C300 vbn_fold v2 0.21234f
C301 vbn_i iref_gate 0.81755f
C302 y1 vbn_fold 1.43474f
C303 vbp_cas vq2 0.23087f
C304 rbit4top dvss 4.46449f
C305 rbit4top b0 0.31177f
C306 v1 vbp_tail 1.58133f
C307 vbn_sink xf2 7.01853f
C308 vbn_i vq2 0.12561f
C309 b6 b6_b 0.67454f
C310 dvss rbit2top 6.47227f
C311 rbit0top b3 0.53998f
C312 b0 rbit2top 0.58571f
C313 vbp_tail v2 0.87674f
C314 avdd vsua 7.34097f
C315 vq3 vq2 0.71944f
C316 b1_b dvss 0.70803f
C317 psrg_m3_feed vbn_fold 10.6152f
C318 b1_b b0 0.21771f
C319 vbp_i vbn 1.36069f
C320 b3 rbit5top 0.33178f
C321 vgn1 avdd 18.8546f
C322 b5 rbit6top 0.36676f
C323 vaux pm2 0.16736f
C324 rbit1top b3 0.43786f
C325 psrg_m3_protected v2 0.69866f
C326 avdd vbp_bias 0.10147p
C327 vbp_i vgn2 3.01936f
C328 b3_b b1 0.33353f
C329 vsu1 vcasp 2.01775f
C330 y1 pm2 10.015f
C331 b4 b6 0.13739f
C332 vq2 vsua 1.14717f
C333 vsp vbp_tail 7.87899f
C334 vbp_bias iref_gate 0.15181f
C335 avdd vbn_sink 60.214f
C336 dvss b4_b 0.74387f
C337 xf1 v1 10.2886f
C338 vgn2 pm1 2.13706f
C339 b4 b6_b 0.20318f
C340 rb_mid vcasp 1.34108f
C341 psrg_m3_feed psrg_m3_protected 0.85721f
C342 xf1 v2 0.27167f
C343 vbp_i vcasp 0.41851f
C344 xf1 y1 6.94221f
C345 vaux net4 0.27149f
C346 y1 psrg_mf1_protected 0.69177f
C347 vbn aux_gate 0.50084f
C348 rbit4top b3 3.85971f
C349 vq2 vbp_bias 0.56997f
C350 vx2 vsu1 0.70883f
C351 vbn_sink iref_gate 2.55434f
C352 b1 b6_b 0.20434f
C353 y1 net4 0.84565f
C354 vref vsu1 0.73254f
C355 vgn2 aux_gate 0.26108f
C356 vaux vbp_i 2.74092f
C357 vref rfix2 0.91589f
C358 vbp_i v1 1.35947f
C359 vref net4 0.25004f
C360 vbp_i vsu2 5.09731f
C361 b3_b b5 0.231f
C362 vbp_cas vbn 1.22372f
C363 xf1 psrg_m3_feed 0.46203f
C364 vbp_i v2 0.48845f
C365 auxsu2 auxsu1 0.31683f
C366 vbp_i y1 3.23783f
C367 xf1 vsp 7.79995f
C368 dvdd b5_b 1.16684f
C369 vbn_i vbn 0.16668f
C370 vbp_cas vgn2 11.2096f
C371 vaux pm1 0.17034f
C372 vbp_i vref 0.17146f
C373 vcasp aux_gate 5.87717f
C374 v2 net3 0.57255f
C375 dvss b2 1.29674f
C376 y1 pm1 9.66249f
C377 vbn_i vgn2 0.69009f
C378 rb_mid psrg_m3_feed 0.17742f
C379 rbit0top rfix2 0.28137f
C380 b5 b6 1.31967f
C381 b0 b2 0.31135f
C382 vbp_i psrg_m3_feed 1.94976f
C383 dvdd rbit3top 13.9743f
C384 b3 b4_b 0.18306f
C385 psrg_vnc vbn_fold 0.18848f
C386 vq3 dvdd 0.84903f
C387 vbp_cas vcasp 2.83164f
C388 vaux aux_gate 0.10754f
C389 vx3 vsu1 0.20767f
C390 vbn_i vcasp 0.518f
C391 vx1 vcasp 4.56382f
C392 psrg_vnc vbp_tail 2.11535f
C393 vaux vbp_cas 3.03123f
C394 vq3 vcasp 0.51649f
C395 vsp net3 0.14854f
C396 vbp_cas v1 1.84705f
C397 b2_b dvdd 3.6832f
C398 vbp_cas v2 3.82018f
C399 vaux vbn_i 1.05472f
C400 vbp_cas y1 8.50353f
C401 vgn1 vbn 0.62766f
C402 b0 dvss 1.81704f
C403 vbn_i v1 1.76628f
C404 vbn vbp_bias 0.13373f
C405 psrg_vnc psrg_m3_protected 1.29419f
C406 psrg_m3_feed aux_gate 1.26273f
C407 b4 b5 0.77437f
C408 vbn_i v2 0.98635f
C409 v1 vq3 1.04944f
C410 rfix1 vref 0.91067f
C411 rbit6top dvdd 4.28384f
C412 psrg_vnc pm2 0.75199f
C413 vgn2 vbp_bias 0.20008f
C414 y1 vq3 1.46015f
C415 avdd xf2 37.4943f
C416 vcasp vsua 1.13f
C417 vx2 vx1 1.59365f
C418 b3 b2 0.82218f
C419 rbit2top rfix2 0.92377f
C420 vbp_cas psrg_m3_feed 1.02546f
C421 vref vx1 0.88318f
C422 vgn2 vbn_sink 0.86021f
C423 vbn_i psrg_m3_feed 0.21852f
C424 psrg_vnc psrg_mf1_protected 0.77161f
C425 vgn1 vcasp 19.1865f
C426 xf2 iref_gate 2.70811f
C427 psrg_m3_feed vx1 5.13568f
C428 vcasp vbp_bias 2.56845f
C429 rfix1 rbit0top 0.26344f
C430 v1 vsua 3.88251f
C431 psrg_m3_feed vq3 0.26949f
C432 vsp vbn_i 0.5747f
C433 psrg_vnc net4 1.24418f
C434 b5_b rbit5top 0.36198f
C435 v2 vsua 9.53629f
C436 y1 vsua 1.43812f
C437 rbit0top rbit3top 0.18061f
C438 rb_mid psrg_vnc 0.79729f
C439 vgn1 v1 2.04664f
C440 v1 vbp_bias 1.74402f
C441 vbp_i psrg_vnc 9.40262f
C442 dvss b3 2.47514f
C443 rbit3top rbit5top 9.21737f
C444 b0_b b2_b 0.6531f
C445 b3_b dvdd 1.41013f
C446 vgn1 v2 0.10136f
C447 b0 b3 0.15351f
C448 v2 vbp_bias 2.25526f
C449 vq3 rbit5top 0.11707f
C450 y1 vbp_bias 0.79323f
C451 rbit1top rbit3top 0.19439f
C452 vx3 vx1 2.90626f
C453 vgn1 vx2 0.9818f
C454 psrg_m3_feed vsua 0.11359f
C455 vref rbit6top 0.11361f
C456 vref vgn1 0.18774f
C457 vaux vbn_sink 0.31645f
C458 psrg_vnc pm1 3.60303f
C459 v1 vbn_sink 0.24909f
C460 vsp vsua 0.14888f
C461 avdd iref_gate 33.8731f
C462 b0_b rbit6top 0.43936f
C463 v2 vbn_sink 0.23826f
C464 rbit4top b5_b 0.112f
C465 y1 vbn_sink 1.23295f
C466 dvdd b6 2.68811f
C467 vgn1 psrg_m3_feed 1.51298f
C468 psrg_m3_feed vbp_bias 0.32891f
C469 b2_b rbit5top 0.27685f
C470 avdd vq2 0.2772f
C471 b1_b b5_b 0.45855f
C472 rfix1 rbit2top 0.91898f
C473 dvdd b6_b 1.30502f
C474 vsp vbp_bias 0.48005f
C475 psrg_vnc aux_gate 0.8724f
C476 rbit0top rbit6top 0.19439f
C477 vbn_fold vsu 0.36465f
C478 rbit4top rbit3top 6.57522f
C479 bgsu1 vsu 1.03106f
C480 rbit4top vq3 0.19245f
C481 psrg_m3_feed vbn_sink 1.44591f
C482 rbit2top rbit3top 9.8463f
C483 rbit6top rbit5top 1.83882f
C484 vbp_cas psrg_vnc 3.11352f
C485 vbp_tail vsu 0.1293f
C486 vx3 vgn1 0.10755f
C487 vnx_bias vsu 0.20458f
C488 psrg_vnc vbn_i 1.89856f
C489 b3_b b0_b 0.26233f
C490 rbit4top b2_b 0.2183f
C491 b4 dvdd 2.35748f
C492 b5_b b4_b 0.22887f
C493 psrg_vnc vq3 1.25069f
C494 b2_b rbit2top 0.62978f
C495 vgn2 xf2 0.23576f
C496 dvdd b1 2.15562f
C497 rbit4top rbit6top 0.67023f
C498 rbit3top b4_b 0.20071f
C499 b0_b b6 0.27119f
C500 rbit6top rbit2top 0.30581f
C501 b1_b rbit6top 1.0297f
C502 xf1 vsu 2.39876f
C503 rfix1 rfix0 0.18752f
C504 b0_b b6_b 0.10457f
C505 rbit0top b6 0.29145f
C506 avdd vbn 5.7741f
C507 rfix0 vq3 5.16564f
C508 vbp_tail vbn_fold 0.21285f
C509 vgn1 psrg_vnc 0.53166f
C510 vbn_fold vnx_bias 0.44744f
C511 b6 rbit5top 0.28987f
C512 avdd vgn2 25.7525f
C513 v1 xf2 1.0939f
C514 vbp_i vsu 2.38741f
C515 rbit1top b6 0.40928f
C516 rbit5top b6_b 0.10079f
C517 b5 dvdd 2.30597f
C518 vbn iref_gate 0.11992f
C519 v2 xf2 10.4106f
C520 y1 xf2 0.81527f
C521 b3_b rbit4top 0.32162f
C522 b4 b0_b 0.34059f
C523 psrg_vnc vbn_sink 1.79382f
C524 b2 rbit3top 0.29283f
C525 vq3 b2 1.01287f
C526 avdd vcasp 40.4401f
C527 su_state avdd 0.81312f
C528 b4 rbit0top 0.26882f
C529 psrg_m3_feed xf2 0.38229f
C530 rfix0 rbit6top 0.31729f
C531 dvss b5_b 1.60251f
C532 rbit4top b6 0.54445f
C533 xf1 vbn_fold 0.97203f
C534 b4 rbit5top 0.35986f
C535 vsp xf2 7.18284f
C536 vaux avdd 8.89276f
C537 vbn_fold psrg_mf1_protected 0.73665f
C538 aux_gate vsu 0.16883f
C539 b2_b b2 0.88825f
C540 v1 avdd 11.88061f
C541 vsu2 avdd 0.18862f
C542 rbit0top b1 0.60448f
C543 b4 rbit1top 0.31841f
C544 b1_b b6 0.30215f
C545 avdd v2 13.715f
C546 y1 avdd 57.2095f
C547 xf1 vbp_tail 0.45879f
C548 vx2 avdd 33.2731f
C549 dvss rbit3top 4.2815f
C550 vq3 dvss 0.74444f
C551 b0 rbit3top 0.32954f
C552 b3_b b4_b 0.66061f
C553 b1_b b6_b 0.24061f
C554 vref avdd 12.7623f
C555 vbp_cas vsu 2.53191f
C556 rbit6top b2 0.39618f
C557 v1 iref_gate 0.47074f
C558 vref avss 3.19982p
C559 b1 avss 5.71487f
C560 b2 avss 4.327f
C561 b6 avss 6.09351f
C562 b5 avss 4.28006f
C563 b0 avss 6.6011f
C564 b4 avss 5.52149f
C565 b3 avss 6.59461f
C566 avdd avss 4.05028p
C567 dvss avss 33.57692f
C568 dvdd avss 0.23367p
C569 psrg_mf1_protected avss 4.20468f
C570 su_state avss 2.16994f
C571 auxsu1 avss 8.20437f
C572 xf1 avss 23.06063f
C573 vsp avss 5.32154f
C574 iref_gate avss 11.29854f
C575 vsu avss 0.26419f
C576 xf2 avss 22.5748f
C577 vbn_fold avss 16.79765f
C578 vbp_tail avss 23.41124f
C579 psrg_m3_protected avss 7.06389f
C580 v2 avss 13.42506f
C581 vbn avss 13.62627f
C582 vbp_bias avss 26.37754f
C583 vbn_sink avss 67.55415f
C584 vbn_i avss 40.28291f
C585 y1 avss 23.326f
C586 pm1 avss 7.9314f
C587 vgn2 avss 0.24364p
C588 pm2 avss 15.93898f
C589 vbp_cas avss 21.62527f
C590 vaux avss 22.22923f
C591 rb_mid avss 1.83077f
C592 psrg_vnc avss 33.65138f
C593 vgn1 avss 15.82217f
C594 vx3 avss 3.49829f
C595 vx1 avss 3.71291f
C596 vx2 avss 4.70378f
C597 psrg_m3_feed avss 32.06069f
C598 vsu1 avss 8.90251f
C599 vsu2 avss 7.93288f
C600 vbp_i avss 88.54301f
C601 rfix2 avss 11.5703f
C602 rfix1 avss 11.5329f
C603 rfix0 avss 10.1505f
C604 b3_b avss 2.34461f
C605 b1_b avss 1.56725f
C606 b6_b avss 2.16598f
C607 b4_b avss 2.39059f
C608 b0_b avss 2.19442f
C609 rbit0top avss 20.48001f
C610 rbit1top avss 11.11638f
C611 rbit2top avss 14.96893f
C612 b2_b avss 2.47232f
C613 rbit6top avss 17.65135f
C614 rbit5top avss 23.30639f
C615 b5_b avss 7.52965f
C616 rbit3top avss 19.14367f
C617 rbit4top avss 14.19899f
C618 rbit4top.t3 avss 2.56612f
C619 rbit4top.t1 avss 2.15752f
C620 rbit4top.t5 avss 1.07531f
C621 rbit4top.n0 avss 4.48654f
C622 rbit4top.n1 avss 4.46185f
C623 rbit4top.t0 avss 2.80252f
C624 rbit4top.t2 avss 1.11124f
C625 rbit4top.n2 avss 6.93738f
C626 rbit4top.n3 avss 5.45146f
C627 rbit4top.t4 avss 4.77654f
C628 rbit3top.t6 avss 4.93617f
C629 rbit3top.t7 avss 3.44832f
C630 rbit3top.t1 avss 1.22886f
C631 rbit3top.t0 avss 4.12432f
C632 rbit3top.n0 avss 11.9359f
C633 rbit3top.t5 avss 2.30691f
C634 rbit3top.t2 avss 3.3998f
C635 rbit3top.n1 avss 2.04148f
C636 rbit3top.t3 avss 3.42344f
C637 rbit3top.n2 avss 0.53103f
C638 rbit3top.n3 avss 5.04775f
C639 rbit3top.t4 avss 3.40894f
C640 rbit3top.n4 avss 1.83695f
C641 rbit3top.n5 avss 4.72615f
C642 b5_b.t1 avss 0.53209f
C643 b5_b.t0 avss 1.22981f
C644 b5_b.n0 avss 5.77671f
C645 rbit5top.t0 avss 1.05924f
C646 rbit5top.t5 avss 0.88982f
C647 rbit5top.n0 avss 0.87916f
C648 rbit5top.t1 avss 3.71016f
C649 rbit5top.t3 avss 0.8281f
C650 rbit5top.n1 avss 7.43506f
C651 rbit5top.n2 avss 6.51751f
C652 rbit5top.t2 avss 0.95442f
C653 rbit5top.t4 avss 2.05775f
C654 rbit6top.n0 avss 1.71357f
C655 rbit6top.n1 avss 1.57323f
C656 rbit6top.t4 avss 0.47564f
C657 rbit6top.t5 avss 2.53271f
C658 rbit6top.t3 avss 2.02127f
C659 rbit6top.n2 avss 6.42364f
C660 rbit6top.t2 avss 0.194f
C661 rbit6top.t1 avss 0.55172f
C662 rbit6top.n3 avss 2.69472f
C663 rbit6top.t0 avss 0.97788f
C664 b2_b.t1 avss 0.24686f
C665 b2_b.t0 avss 1.21583f
C666 b2_b.n0 avss 4.25876f
C667 b2_b.n1 avss 3.97703f
C668 b2_b.n2 avss 1.06499f
C669 rbit2top.t5 avss 7.68445f
C670 rbit2top.t6 avss 7.79631f
C671 rbit2top.t4 avss 7.79019f
C672 rbit2top.t0 avss 1.41686f
C673 rbit2top.t2 avss 2.2241f
C674 rbit2top.n0 avss 8.73342f
C675 rbit2top.n1 avss 6.22951f
C676 rbit2top.t7 avss 7.81838f
C677 rbit2top.n2 avss 0.86248f
C678 rbit2top.n3 avss 0.67649f
C679 rbit2top.t9 avss 4.06851f
C680 rbit2top.t3 avss 4.04699f
C681 rbit2top.t1 avss 4.08455f
C682 rbit2top.n4 avss 1.05763f
C683 rbit2top.n5 avss 2.86304f
C684 rbit2top.t8 avss 4.14254f
C685 rbit2top.n6 avss 5.35119f
C686 rbit2top.n7 avss 3.16522f
C687 rbit1top.t3 avss 7.88553f
C688 rbit1top.t12 avss 8.12738f
C689 rbit1top.t13 avss 8.15546f
C690 rbit1top.n0 avss 3.35732f
C691 rbit1top.t4 avss 8.01021f
C692 rbit1top.t5 avss 8.00303f
C693 rbit1top.t6 avss 8.0041f
C694 rbit1top.t7 avss 8.00987f
C695 rbit1top.t2 avss 8.13193f
C696 rbit1top.t1 avss 1.48728f
C697 rbit1top.t0 avss 1.94006f
C698 rbit1top.n1 avss 7.1791f
C699 rbit1top.n2 avss 8.09972f
C700 rbit1top.t10 avss 8.09744f
C701 rbit1top.n3 avss 0.83567f
C702 rbit1top.t11 avss 8.08815f
C703 rbit1top.n4 avss 0.76936f
C704 rbit1top.t9 avss 8.09983f
C705 rbit1top.n5 avss 0.71638f
C706 rbit1top.t8 avss 7.99854f
C707 rbit1top.n6 avss 0.65889f
C708 rbit1top.n7 avss 0.68742f
C709 rbit1top.n8 avss 0.63982f
C710 rbit1top.n9 avss 0.65567f
C711 rbit1top.n10 avss 0.67899f
C712 rbit1top.n11 avss 2.859f
C713 rbit0top.t8 avss 6.87687f
C714 rbit0top.t9 avss 6.84996f
C715 rbit0top.n0 avss 2.71385f
C716 rbit0top.t5 avss 6.68552f
C717 rbit0top.t0 avss 5.80302f
C718 rbit0top.t1 avss 1.98347f
C719 rbit0top.n1 avss 14.5852f
C720 rbit0top.n2 avss 5.05915f
C721 rbit0top.t6 avss 6.73662f
C722 rbit0top.n3 avss 0.83099f
C723 rbit0top.t3 avss 6.72031f
C724 rbit0top.n4 avss 0.59686f
C725 rbit0top.t7 avss 6.72721f
C726 rbit0top.n5 avss 0.54543f
C727 rbit0top.n6 avss 2.26641f
C728 rbit0top.t4 avss 6.71767f
C729 rbit0top.n7 avss 0.58542f
C730 rbit0top.t2 avss 6.62285f
C731 b0_b.t0 avss 0.8746f
C732 b0_b.t1 avss 0.24723f
C733 b0_b.n0 avss 2.75895f
C734 b0_b.n1 avss 1.6447f
C735 b0_b.n2 avss 0.89851f
C736 b0_b.n3 avss 0.88163f
C737 b0_b.n4 avss 0.87283f
C738 b0_b.n5 avss 1.01579f
C739 b4_b.t1 avss 1.44155f
C740 b4_b.t0 avss 0.98388f
C741 b4_b.n0 avss 5.42135f
C742 b6_b.t1 avss 0.88917f
C743 b6_b.t0 avss 1.20083f
C744 b6_b.n0 avss 5.08731f
C745 vq3.t2 avss 1.74463f
C746 vq3.n0 avss 12.4388f
C747 vq3.t1 avss 0.19962f
C748 vq3.n1 avss 2.01588f
C749 vq3.t0 avss 0.45812f
C750 b1_b.t1 avss 0.26212f
C751 b1_b.t0 avss 0.69237f
C752 b1_b.n0 avss 2.61633f
C753 b1_b.n1 avss 2.18848f
C754 b1_b.n2 avss 1.10546f
C755 b3_b.t1 avss 0.34252f
C756 b3_b.t0 avss 1.47881f
C757 b3_b.n0 avss 2.97278f
C758 vbp_i.t1 avss 3.44428f
C759 vbp_i.t3 avss 3.43187f
C760 vbp_i.t5 avss 3.45183f
C761 vbp_i.n0 avss 0.3165f
C762 vbp_i.n1 avss 1.81421f
C763 vbp_i.n2 avss 1.62372f
C764 vbp_i.n3 avss 0.90397f
C765 vbp_i.n4 avss 0.90433f
C766 vbp_i.n5 avss 0.90397f
C767 vbp_i.n6 avss 1.01168f
C768 vbp_i.n7 avss 1.62605f
C769 vbp_i.n8 avss 0.90476f
C770 vbp_i.n9 avss 0.90583f
C771 vbp_i.n10 avss 0.90476f
C772 vbp_i.n11 avss 0.81418f
C773 vbp_i.n12 avss 0.47725f
C774 vbp_i.n13 avss 1.07419f
C775 vbp_i.n14 avss 0.9038f
C776 vbp_i.n15 avss 0.90273f
C777 vbp_i.n16 avss 0.9038f
C778 vbp_i.n17 avss 0.90273f
C779 vbp_i.n18 avss 0.98081f
C780 vbp_i.n19 avss 0.25325f
C781 vbp_i.n20 avss 1.61981f
C782 vbp_i.n21 avss 0.90216f
C783 vbp_i.n22 avss 0.90291f
C784 vbp_i.n23 avss 0.90216f
C785 vbp_i.n24 avss 1.05305f
C786 vbp_i.n25 avss 1.61897f
C787 vbp_i.n26 avss 0.9016f
C788 vbp_i.n27 avss 0.90156f
C789 vbp_i.n28 avss 0.82399f
C790 vbp_i.n29 avss 0.41219f
C791 vbp_i.t10 avss 4.31647f
C792 vbp_i.n30 avss 1.78361f
C793 vbp_i.n31 avss 2.09121f
C794 vbp_i.n32 avss 0.60022f
C795 vbp_i.n33 avss 0.60211f
C796 vbp_i.n34 avss 0.90184f
C797 vbp_i.n35 avss 0.84553f
C798 vbp_i.n36 avss 0.71337f
C799 vbp_i.n37 avss 0.59556f
C800 vbp_i.n38 avss 1.25336f
C801 vbp_i.n39 avss 0.74096f
C802 vbp_i.n40 avss 1.5691f
C803 vbp_i.t7 avss 3.42954f
C804 vbp_i.t9 avss 3.4522f
C805 vbp_i.n41 avss 0.30538f
C806 vbp_i.n42 avss 0.16692f
C807 vbp_i.n43 avss 0.76228f
C808 vbp_i.n44 avss 0.16511f
C809 vbp_i.n45 avss 0.85285f
C810 vbp_i.n46 avss 0.99139f
C811 vbp_i.n47 avss 0.96521f
C812 vbp_i.n48 avss 0.17347f
C813 vbp_i.n49 avss 0.82012f
C814 vbp_i.n50 avss 0.86047f
C815 vbp_i.n51 avss 0.26426f
C816 vbp_i.n52 avss 0.90096f
C817 psrg_m3_feed.n0 avss 1.83938f
C818 psrg_m3_feed.n1 avss 0.99469f
C819 psrg_m3_feed.n2 avss 0.99469f
C820 psrg_m3_feed.n3 avss 0.97809f
C821 psrg_m3_feed.n4 avss 1.81816f
C822 psrg_m3_feed.n5 avss 0.98394f
C823 psrg_m3_feed.n6 avss 0.98394f
C824 psrg_m3_feed.n7 avss 0.96734f
C825 psrg_m3_feed.t0 avss 1.16117f
C826 psrg_m3_feed.n8 avss 1.43236f
C827 psrg_m3_feed.t5 avss 0.65968f
C828 psrg_m3_feed.t6 avss 3.89916f
C829 psrg_m3_feed.t7 avss 3.83311f
C830 psrg_m3_feed.n9 avss 2.28217f
C831 psrg_m3_feed.n10 avss 8.50879f
C832 psrg_m3_feed.n11 avss 8.55801f
C833 psrg_m3_feed.n12 avss 5.20458f
C834 psrg_m3_feed.t1 avss 1.14509f
C835 psrg_m3_feed.t2 avss 1.15955f
C836 psrg_m3_feed.t3 avss 1.18949f
C837 psrg_m3_feed.t4 avss 1.16061f
C838 psrg_m3_feed.n13 avss 0.87708f
C839 psrg_m3_feed.n14 avss 0.89419f
C840 psrg_m3_feed.n15 avss 2.49421f
C841 psrg_m3_feed.n16 avss 1.05525f
C842 psrg_m3_feed.n17 avss 1.29356f
C843 psrg_m3_feed.n18 avss 0.99409f
C844 psrg_m3_feed.n19 avss 0.99409f
C845 psrg_m3_feed.n20 avss 0.99409f
C846 psrg_m3_feed.n21 avss 0.99409f
C847 psrg_m3_feed.n22 avss 1.32086f
C848 psrg_m3_feed.n23 avss 0.59452f
C849 psrg_m3_feed.n24 avss 1.19451f
C850 psrg_m3_feed.n25 avss 0.62726f
C851 vx2.t0 avss 4.76184f
C852 vx2.t10 avss 4.29802f
C853 vx2.n0 avss 2.64978f
C854 vx2.t1 avss 4.32422f
C855 vx2.t4 avss 3.04179f
C856 vx2.t5 avss 2.6987f
C857 vx2.n1 avss 1.89798f
C858 vx2.n2 avss 1.73415f
C859 vx2.t8 avss 4.35558f
C860 vx2.n3 avss 2.16477f
C861 vx2.t2 avss 3.25496f
C862 vx2.t6 avss 2.71611f
C863 vx2.n4 avss 2.39803f
C864 vx2.t3 avss 2.70064f
C865 vx2.n5 avss 2.30633f
C866 vx2.n6 avss 1.65992f
C867 vx2.t9 avss 4.33517f
C868 vx2.n7 avss 2.4131f
C869 vx2.n8 avss 2.60482f
C870 vx2.t7 avss 4.12022f
C871 vx1.t6 avss 4.42396f
C872 vx1.t9 avss 4.69775f
C873 vx1.n0 avss 3.17077f
C874 vx1.t0 avss 4.39689f
C875 vx1.n1 avss 1.21817f
C876 vx1.t7 avss 4.39689f
C877 vx1.t2 avss 2.90389f
C878 vx1.t1 avss 2.85192f
C879 vx1.n2 avss 2.85789f
C880 vx1.t3 avss 2.832f
C881 vx1.n3 avss 3.41499f
C882 vx1.n4 avss 2.23824f
C883 vx1.n5 avss 2.6943f
C884 vx1.t8 avss 4.4221f
C885 vx1.t5 avss 2.94088f
C886 vx1.t4 avss 2.83333f
C887 vx1.n6 avss 1.82999f
C888 vx1.n7 avss 2.38776f
C889 vx1.n8 avss 1.63102f
C890 vx1.t10 avss 4.30035f
C891 vx3.t6 avss 4.61699f
C892 vx3.t8 avss 4.32762f
C893 vx3.n0 avss 1.89253f
C894 vx3.t0 avss 4.34251f
C895 vx3.t1 avss 14.4097f
C896 vx3.t3 avss 2.75857f
C897 vx3.t5 avss 3.20848f
C898 vx3.t4 avss 2.74282f
C899 vx3.n1 avss 2.61775f
C900 vx3.n2 avss 4.69767f
C901 vx3.t2 avss 2.74282f
C902 vx3.n3 avss 1.14527f
C903 vx3.t7 avss 4.34251f
C904 vx3.n4 avss 2.05493f
C905 vx3.n5 avss 2.71239f
C906 vx3.t9 avss 4.47584f
C907 vx3.n6 avss 1.94981f
C908 vx3.t10 avss 4.24784f
C909 vgn1.t2 avss 1.73712f
C910 vgn1.t6 avss 5.76905f
C911 vgn1.t8 avss 5.79559f
C912 vgn1.t9 avss 3.24215f
C913 vgn1.n0 avss 5.39604f
C914 vgn1.n1 avss 0.79553f
C915 vgn1.n2 avss 1.99236f
C916 vgn1.n3 avss 12.0966f
C917 vgn1.t4 avss 1.7396f
C918 vgn1.n4 avss 11.0304f
C919 vgn1.n5 avss 1.28403f
C920 vgn1.t0 avss 1.74041f
C921 vgn1.n6 avss 1.89055f
C922 vgn1.t3 avss 1.73798f
C923 vgn1.n7 avss 1.56211f
C924 vgn1.t1 avss 1.66885f
C925 psrg_vnc.t8 avss 1.91723f
C926 psrg_vnc.n0 avss 0.9185f
C927 psrg_vnc.t3 avss 2.5665f
C928 psrg_vnc.n1 avss 0.96109f
C929 psrg_vnc.n2 avss 5.93856f
C930 psrg_vnc.n3 avss 8.35785f
C931 psrg_vnc.t6 avss 2.57595f
C932 psrg_vnc.n4 avss 7.75842f
C933 psrg_vnc.t4 avss 2.58419f
C934 psrg_vnc.n5 avss 0.59344f
C935 psrg_vnc.t5 avss 2.59367f
C936 psrg_vnc.n6 avss 0.45813f
C937 psrg_vnc.t0 avss 2.58419f
C938 psrg_vnc.n7 avss 0.36653f
C939 psrg_vnc.t1 avss 2.57595f
C940 psrg_vnc.n8 avss 0.58363f
C941 psrg_vnc.n9 avss 0.85932f
C942 psrg_vnc.t2 avss 2.54068f
C943 vaux.t2 avss 1.90269f
C944 vaux.t0 avss 1.91536f
C945 vaux.n0 avss 7.22115f
C946 vaux.t1 avss 1.38891f
C947 vbp_cas.t20 avss 1.18249f
C948 vbp_cas.t1 avss 3.85101f
C949 vbp_cas.n0 avss 1.74736f
C950 vbp_cas.t5 avss 3.8708f
C951 vbp_cas.t7 avss 3.8601f
C952 vbp_cas.n1 avss 1.01235f
C953 vbp_cas.n2 avss 0.25975f
C954 vbp_cas.t3 avss 3.82066f
C955 vbp_cas.n3 avss 0.22066f
C956 vbp_cas.n4 avss 0.23875f
C957 vbp_cas.n6 avss 0.96277f
C958 vbp_cas.n7 avss 1.76617f
C959 vbp_cas.t9 avss 3.82145f
C960 vbp_cas.t13 avss 3.92607f
C961 vbp_cas.t15 avss 3.72574f
C962 vbp_cas.t17 avss 3.93448f
C963 vbp_cas.t19 avss 3.87962f
C964 vbp_cas.n8 avss 1.02396f
C965 vbp_cas.n9 avss 0.23112f
C966 vbp_cas.n10 avss 0.18588f
C967 vbp_cas.n11 avss 1.88222f
C968 vbp_cas.n12 avss 0.15364f
C969 vbp_cas.n13 avss 0.27997f
C970 vbp_cas.t11 avss 3.71828f
C971 vbp_cas.n14 avss 0.15734f
C972 vbp_cas.n15 avss 0.30639f
C973 vbp_cas.n16 avss 0.253f
C974 vbp_cas.n17 avss 0.96662f
C975 vbp_cas.n18 avss 1.26322f
C976 vbp_cas.n19 avss 2.2686f
C977 vbp_cas.n20 avss 1.28297f
C978 vbp_cas.n21 avss 1.32744f
C979 vbp_cas.n22 avss 1.26608f
C980 vbp_cas.n23 avss 1.18596f
C981 vbp_cas.n24 avss 2.17014f
C982 vbp_cas.n25 avss 1.19503f
C983 vbp_cas.n26 avss 1.19406f
C984 vbp_cas.n27 avss 1.19503f
C985 vbp_cas.n28 avss 1.41286f
C986 vbp_cas.n29 avss 0.31569f
C987 vbp_cas.n30 avss 1.29942f
C988 pm2.t8 avss 7.55976f
C989 pm2.t10 avss 7.44487f
C990 pm2.t9 avss 7.44668f
C991 pm2.t11 avss 8.41097f
C992 pm2.n0 avss 3.92235f
C993 pm2.n1 avss 2.74673f
C994 pm2.n2 avss 3.75805f
C995 pm2.t6 avss 7.5145f
C996 pm2.n3 avss 2.46708f
C997 pm2.t0 avss 6.63096f
C998 pm2.t4 avss 6.47648f
C999 pm2.t5 avss 7.01012f
C1000 pm2.n4 avss 2.81596f
C1001 pm2.t3 avss 6.53689f
C1002 pm2.n5 avss 2.89986f
C1003 pm2.n6 avss 2.46114f
C1004 pm2.t1 avss 6.52225f
C1005 pm2.n7 avss 1.43736f
C1006 pm2.t2 avss 6.54093f
C1007 pm2.n8 avss 8.35136f
C1008 pm2.t7 avss 7.44435f
C1009 vgn2.n0 avss 0.22762f
C1010 vgn2.t2 avss 3.73827f
C1011 vgn2.t3 avss 3.84756f
C1012 vgn2.t5 avss 3.85076f
C1013 vgn2.t6 avss 3.87123f
C1014 vgn2.n1 avss 0.18527f
C1015 vgn2.t1 avss 3.85068f
C1016 vgn2.t0 avss 3.84533f
C1017 vgn2.n3 avss 0.10298f
C1018 vgn2.t4 avss 8.94657f
C1019 vgn2.n5 avss 0.23799f
C1020 vgn2.n6 avss 0.43864f
C1021 vgn2.n7 avss 0.3126f
C1022 pm1.t6 avss 7.61183f
C1023 pm1.t7 avss 8.25992f
C1024 pm1.n0 avss 2.51689f
C1025 pm1.t11 avss 8.56656f
C1026 pm1.t8 avss 7.68398f
C1027 pm1.n1 avss 3.91035f
C1028 pm1.t9 avss 7.68948f
C1029 pm1.n2 avss 3.38971f
C1030 pm1.n3 avss 3.21679f
C1031 pm1.t1 avss 6.5678f
C1032 pm1.t0 avss 6.94537f
C1033 pm1.n4 avss 1.2623f
C1034 pm1.t4 avss 6.73424f
C1035 pm1.t5 avss 6.79005f
C1036 pm1.t3 avss 7.74683f
C1037 pm1.n5 avss 4.77515f
C1038 pm1.n6 avss 3.13352f
C1039 pm1.t2 avss 6.66978f
C1040 pm1.n7 avss 4.72725f
C1041 pm1.n8 avss 7.18966f
C1042 pm1.t10 avss 7.31738f
C1043 y1.t4 avss 4.92804f
C1044 y1.t3 avss 4.93101f
C1045 y1.t6 avss 5.32588f
C1046 y1.n0 avss 1.15556f
C1047 y1.n1 avss 0.79219f
C1048 y1.t2 avss 4.9266f
C1049 y1.t1 avss 11.80313f
C1050 y1.n2 avss 5.42641f
C1051 y1.t0 avss 4.81505f
C1052 y1.n3 avss 0.68001f
C1053 y1.n4 avss 1.0727f
C1054 y1.n5 avss 2.63234f
C1055 y1.n6 avss 1.3967f
C1056 y1.n7 avss 1.4857f
C1057 y1.n8 avss 1.3794f
C1058 y1.n9 avss 1.68372f
C1059 y1.n10 avss 2.62331f
C1060 y1.n11 avss 1.39205f
C1061 y1.n12 avss 1.48081f
C1062 y1.n13 avss 1.37511f
C1063 y1.n14 avss 1.2798f
C1064 y1.n15 avss 2.29514f
C1065 y1.n16 avss 1.67312f
C1066 y1.t5 avss 4.62125f
C1067 vbn_i.t5 avss 4.98738f
C1068 vbn_i.n0 avss 2.6471f
C1069 vbn_i.n1 avss 6.89042f
C1070 vbn_i.t7 avss 4.20377f
C1071 vbn_i.n2 avss 1.0622f
C1072 vbn_i.n3 avss 4.48929f
C1073 vbn_i.n4 avss 5.15462f
C1074 vbn_i.n5 avss 6.03264f
C1075 vbn_i.t3 avss 4.34707f
C1076 vbn_i.n6 avss 3.15138f
C1077 vbn_i.t4 avss 4.31083f
C1078 vbn_i.n7 avss 1.18892f
C1079 vbn_i.t1 avss 4.30278f
C1080 vbn_i.n8 avss 1.4598f
C1081 vbn_i.t2 avss 4.30278f
C1082 vbn_i.n9 avss 2.09787f
C1083 vbn_i.t0 avss 4.02886f
C1084 vbn_sink.n0 avss 1.59497f
C1085 vbn_sink.n1 avss 0.89908f
C1086 vbn_sink.n2 avss 0.9003f
C1087 vbn_sink.n3 avss 0.89141f
C1088 vbn_sink.n4 avss 1.5957f
C1089 vbn_sink.n5 avss 0.89938f
C1090 vbn_sink.n6 avss 0.90072f
C1091 vbn_sink.n7 avss 0.86105f
C1092 vbn_sink.t10 avss 3.54387f
C1093 vbn_sink.t9 avss 3.59341f
C1094 vbn_sink.n8 avss 0.32318f
C1095 vbn_sink.t6 avss 3.55393f
C1096 vbn_sink.n9 avss 0.36713f
C1097 vbn_sink.t7 avss 3.55102f
C1098 vbn_sink.n10 avss 0.28287f
C1099 vbn_sink.t2 avss 3.55393f
C1100 vbn_sink.n11 avss 0.28129f
C1101 vbn_sink.t8 avss 3.54918f
C1102 vbn_sink.t17 avss 3.62118f
C1103 vbn_sink.t18 avss 3.55135f
C1104 vbn_sink.n12 avss 0.40892f
C1105 vbn_sink.t11 avss 3.54895f
C1106 vbn_sink.n13 avss 0.28241f
C1107 vbn_sink.t12 avss 3.55135f
C1108 vbn_sink.n14 avss 0.28083f
C1109 vbn_sink.n15 avss 0.23903f
C1110 vbn_sink.t14 avss 2.78617f
C1111 vbn_sink.n16 avss 0.69739f
C1112 vbn_sink.n17 avss 0.66988f
C1113 vbn_sink.t16 avss 2.77483f
C1114 vbn_sink.n18 avss 0.32117f
C1115 vbn_sink.n19 avss 0.2748f
C1116 vbn_sink.t5 avss 3.54165f
C1117 vbn_sink.n20 avss 0.20241f
C1118 vbn_sink.t4 avss 3.55111f
C1119 vbn_sink.t20 avss 3.54836f
C1120 vbn_sink.t19 avss 3.55111f
C1121 vbn_sink.t1 avss 3.54836f
C1122 vbn_sink.t0 avss 3.61816f
C1123 vbn_sink.n21 avss 0.40244f
C1124 vbn_sink.n22 avss 0.28439f
C1125 vbn_sink.n23 avss 0.28188f
C1126 vbn_sink.n24 avss 0.28029f
C1127 vbn_sink.n25 avss 0.3835f
C1128 vbn_sink.t3 avss 3.55102f
C1129 vbn_sink.n26 avss 0.23545f
C1130 vbn_sink.n27 avss 0.26716f
C1131 vbn_sink.n28 avss 0.24917f
C1132 vbn_sink.n29 avss 0.91364f
C1133 vbn_sink.n30 avss 0.34338f
C1134 vbp_bias.n0 avss 0.56937f
C1135 vbp_bias.n1 avss 0.89126f
C1136 vbp_bias.t27 avss 4.23321f
C1137 vbp_bias.t5 avss 4.24337f
C1138 vbp_bias.n2 avss 0.59746f
C1139 vbp_bias.t4 avss 4.04137f
C1140 vbp_bias.n3 avss 0.40823f
C1141 vbp_bias.t26 avss 4.18793f
C1142 vbp_bias.t1 avss 4.1241f
C1143 vbp_bias.t3 avss 4.21642f
C1144 vbp_bias.n4 avss 0.67122f
C1145 vbp_bias.t25 avss 4.31825f
C1146 vbp_bias.t0 avss 4.23496f
C1147 vbp_bias.t6 avss 4.02905f
C1148 vbp_bias.n5 avss 0.3897f
C1149 vbp_bias.t8 avss 5.98053f
C1150 vbp_bias.n6 avss 2.73808f
C1151 vbp_bias.t12 avss 5.96294f
C1152 vbp_bias.n7 avss 1.61566f
C1153 vbp_bias.t10 avss 5.90007f
C1154 vbp_bias.n8 avss 0.21575f
C1155 vbp_bias.n9 avss 0.30511f
C1156 vbp_bias.n10 avss 0.35672f
C1157 vbp_bias.n11 avss 1.57448f
C1158 vbp_bias.n12 avss 1.4636f
C1159 vbp_bias.t14 avss 5.94856f
C1160 vbp_bias.n13 avss 0.46612f
C1161 vbp_bias.t16 avss 5.89787f
C1162 vbp_bias.n14 avss 0.21724f
C1163 vbp_bias.n15 avss 1.55752f
C1164 vbp_bias.t18 avss 5.96515f
C1165 vbp_bias.n16 avss 0.21897f
C1166 vbp_bias.n17 avss 1.55899f
C1167 vbp_bias.t20 avss 5.96876f
C1168 vbp_bias.n18 avss 0.2207f
C1169 vbp_bias.n19 avss 1.57131f
C1170 vbp_bias.t22 avss 5.96771f
C1171 vbp_bias.n20 avss 0.28797f
C1172 vbp_bias.t24 avss 5.92295f
C1173 vbp_bias.n21 avss 0.35199f
C1174 vbp_bias.n22 avss 6.55612f
C1175 vbp_bias.n23 avss 5.02302f
C1176 vbp_bias.t2 avss 4.09788f
C1177 vbn.t1 avss 13.13947f
C1178 vbn.t3 avss 2.38841f
C1179 vbn.n0 avss 1.22919f
C1180 vbn.n1 avss 1.38871f
C1181 vbn.n2 avss 4.87576f
C1182 vbn.t0 avss 1.19079f
C1183 v1.t1 avss 4.7278f
C1184 v1.t0 avss 4.7829f
C1185 v1.n0 avss 1.79133f
C1186 v1.n1 avss 4.23209f
C1187 v1.n2 avss 2.77437f
C1188 v1.n3 avss 2.72555f
C1189 v1.n4 avss 2.54487f
C1190 v1.n5 avss 1.45974f
C1191 v2.t0 avss 0.92961f
C1192 v2.t2 avss 0.81678f
C1193 v2.t1 avss 0.83795f
C1194 v2.n0 avss 2.2608f
C1195 v2.n1 avss 5.34903f
C1196 v2.n2 avss 3.30061f
C1197 v2.n3 avss 3.24886f
C1198 v2.n4 avss 3.50483f
C1199 v2.n5 avss 1.47107f
C1200 psrg_m3_protected.t1 avss 3.68751f
C1201 psrg_m3_protected.t0 avss 3.74775f
C1202 psrg_m3_protected.n0 avss 0.48298f
C1203 psrg_m3_protected.t2 avss 1.10152f
C1204 psrg_m3_protected.n1 avss 0.34395f
C1205 psrg_m3_protected.t3 avss 1.06231f
C1206 vbp_tail.t0 avss 7.03045f
C1207 vbp_tail.n0 avss 4.29952f
C1208 vbp_tail.n1 avss 4.81679f
C1209 vbp_tail.t2 avss 2.63461f
C1210 vbp_tail.n2 avss 1.27149f
C1211 vbp_tail.t4 avss 2.61185f
C1212 vbp_tail.t6 avss 2.63208f
C1213 vbp_tail.n3 avss 0.81123f
C1214 vbp_tail.n4 avss 0.14889f
C1215 vbp_tail.n5 avss 0.20026f
C1216 vbp_tail.n6 avss 0.43407f
C1217 vbp_tail.n7 avss 0.40001f
C1218 vbp_tail.n8 avss 1.55388f
C1219 vbp_tail.n9 avss 1.62997f
C1220 vbp_tail.n10 avss 1.63746f
C1221 vbp_tail.n11 avss 1.73386f
C1222 vbn_fold.t12 avss 4.67966f
C1223 vbn_fold.t8 avss 2.6384f
C1224 vbn_fold.n0 avss 1.35441f
C1225 vbn_fold.t1 avss 4.744f
C1226 vbn_fold.n1 avss 1.07769f
C1227 vbn_fold.t2 avss 4.70311f
C1228 vbn_fold.n2 avss 0.8081f
C1229 vbn_fold.t4 avss 4.69918f
C1230 vbn_fold.n3 avss 0.80834f
C1231 vbn_fold.t5 avss 4.70311f
C1232 vbn_fold.n4 avss 0.8081f
C1233 vbn_fold.t11 avss 4.69918f
C1234 vbn_fold.n5 avss 1.04433f
C1235 vbn_fold.n6 avss 8.06435f
C1236 vbn_fold.t9 avss 4.69125f
C1237 vbn_fold.t3 avss 4.69553f
C1238 vbn_fold.t6 avss 4.69125f
C1239 vbn_fold.t13 avss 4.69553f
C1240 vbn_fold.t0 avss 4.73608f
C1241 vbn_fold.n7 avss 2.85799f
C1242 vbn_fold.n8 avss 0.80487f
C1243 vbn_fold.n9 avss 0.80448f
C1244 vbn_fold.n10 avss 0.80487f
C1245 vbn_fold.n11 avss 1.04461f
C1246 vbn_fold.n12 avss 0.80989f
C1247 vbn_fold.t10 avss 4.63062f
C1248 xf2.t8 avss 13.23785f
C1249 xf2.t3 avss 13.05982f
C1250 xf2.t11 avss 5.35452f
C1251 xf2.t1 avss 5.40034f
C1252 xf2.t0 avss 5.49935f
C1253 xf2.n0 avss 2.13828f
C1254 xf2.t2 avss 5.8639f
C1255 xf2.n1 avss 3.19682f
C1256 xf2.t6 avss 5.34825f
C1257 xf2.n2 avss 0.8849f
C1258 xf2.t9 avss 5.39875f
C1259 xf2.n3 avss 2.73791f
C1260 xf2.n4 avss 2.43944f
C1261 xf2.t4 avss 13.15225f
C1262 xf2.n5 avss 1.78565f
C1263 xf2.n6 avss 3.48566f
C1264 xf2.n7 avss 0.91275f
C1265 xf2.t10 avss 13.253f
C1266 xf2.n8 avss 1.58557f
C1267 xf2.t7 avss 13.253f
C1268 xf2.n9 avss 3.0381f
C1269 xf2.t5 avss 12.95369f
C1270 iref_gate.t2 avss 8.45116f
C1271 iref_gate.t0 avss 13.25945f
C1272 iref_gate.n0 avss 10.4372f
C1273 iref_gate.n1 avss 12.5292f
C1274 iref_gate.t1 avss 13.14275f
C1275 vsp.t3 avss 9.07555f
C1276 vsp.t2 avss 9.23982f
C1277 vsp.n0 avss 1.90175f
C1278 vsp.t13 avss 9.22416f
C1279 vsp.n1 avss 1.34631f
C1280 vsp.t12 avss 9.23993f
C1281 vsp.n2 avss 1.31355f
C1282 vsp.t9 avss 9.25138f
C1283 vsp.n3 avss 1.31468f
C1284 vsp.t1 avss 9.11925f
C1285 vsp.n4 avss 3.92906f
C1286 vsp.t4 avss 14.13992f
C1287 vsp.t10 avss 15.21474f
C1288 vsp.t5 avss 14.32139f
C1289 vsp.t7 avss 14.31718f
C1290 vsp.t14 avss 15.21474f
C1291 vsp.t11 avss 15.21869f
C1292 vsp.t15 avss 14.31718f
C1293 vsp.t6 avss 15.20235f
C1294 vsp.t0 avss 14.23728f
C1295 vsp.n5 avss 1.7058f
C1296 vsp.n6 avss 1.14786f
C1297 vsp.n7 avss 1.14821f
C1298 vsp.n8 avss 1.55619f
C1299 vsp.n9 avss 1.6267f
C1300 vsp.n10 avss 1.14821f
C1301 vsp.n11 avss 1.14786f
C1302 vsp.n12 avss 1.24084f
C1303 vsp.n13 avss 2.22289f
C1304 vsp.t8 avss 14.86244f
C1305 xf1.t3 avss 12.39575f
C1306 xf1.t5 avss 12.41506f
C1307 xf1.t11 avss 12.41506f
C1308 xf1.t8 avss 5.63507f
C1309 xf1.t10 avss 5.40696f
C1310 xf1.t9 avss 5.67674f
C1311 xf1.t4 avss 13.12385f
C1312 xf1.n0 avss 6.41666f
C1313 xf1.t6 avss 5.38895f
C1314 xf1.n1 avss 1.21601f
C1315 xf1.t7 avss 5.40537f
C1316 xf1.n2 avss 2.40351f
C1317 xf1.t0 avss 5.38931f
C1318 xf1.n3 avss 1.81434f
C1319 xf1.n4 avss 1.24079f
C1320 xf1.n5 avss 2.94107f
C1321 xf1.t1 avss 12.27812f
C1322 xf1.n6 avss 2.19058f
C1323 xf1.n7 avss 2.32918f
C1324 xf1.n8 avss 1.97405f
C1325 xf1.n9 avss 1.83869f
C1326 xf1.t2 avss 12.11382f
C1327 su_state.t1 avss 0.3907f
C1328 su_state.n0 avss 1.13403f
C1329 su_state.t0 avss 0.50078f
C1330 psrg_mf1_protected.t0 avss 7.80604f
C1331 psrg_mf1_protected.t1 avss 8.11676f
C1332 dvdd.n0 avss 0.41832f
C1333 dvdd.t0 avss 1.05647f
C1334 dvdd.n1 avss 2.02678f
C1335 dvdd.n2 avss 1.97657f
C1336 dvdd.t24 avss 2.48396f
C1337 dvdd.n3 avss 3.36775f
C1338 dvdd.n4 avss 2.12957f
C1339 dvdd.t21 avss 0.31417f
C1340 dvdd.t28 avss 0.63389f
C1341 dvdd.t29 avss 0.28539f
C1342 dvdd.n5 avss 0.23114f
C1343 dvdd.n6 avss 1.39577f
C1344 dvdd.t7 avss 0.55885f
C1345 dvdd.n7 avss 1.48114f
C1346 dvdd.n8 avss 0.2243f
C1347 dvdd.t20 avss 0.5313f
C1348 dvdd.n9 avss 1.31897f
C1349 dvdd.t19 avss 0.37166f
C1350 dvdd.t18 avss 0.63783f
C1351 dvdd.t22 avss 0.63494f
C1352 dvdd.n10 avss 1.21962f
C1353 dvdd.t14 avss 0.36859f
C1354 dvdd.n11 avss 0.14493f
C1355 dvdd.t13 avss 0.58476f
C1356 dvdd.n12 avss 1.2831f
C1357 dvdd.t1 avss 5.1777f
C1358 dvdd.n13 avss 3.33685f
C1359 dvdd.t10 avss 2.34022f
C1360 dvdd.n14 avss 2.7923f
C1361 dvdd.t3 avss 7.38608f
C1362 dvdd.t9 avss 7.28927f
C1363 dvdd.n15 avss 6.47804f
C1364 dvdd.t25 avss 7.28921f
C1365 dvdd.n16 avss 3.31207f
C1366 dvdd.t16 avss 7.2942f
C1367 dvdd.n17 avss 3.28442f
C1368 dvdd.t8 avss 7.40076f
C1369 dvdd.t6 avss 7.29542f
C1370 dvdd.n18 avss 6.46444f
C1371 dvdd.t5 avss 7.28919f
C1372 dvdd.n19 avss 3.32077f
C1373 dvdd.t2 avss 7.29603f
C1374 dvdd.n20 avss 3.32984f
C1375 dvdd.t4 avss 7.28931f
C1376 dvdd.n21 avss 3.27293f
C1377 dvdd.n22 avss 1.95992f
C1378 dvdd.n24 avss 5.6373f
C1379 dvdd.n25 avss 2.49509f
C1380 dvdd.t26 avss 0.63376f
C1381 dvdd.n26 avss 1.34162f
C1382 dvdd.t27 avss 0.33222f
C1383 dvdd.n27 avss 0.15087f
C1384 dvdd.t23 avss 0.34742f
C1385 dvdd.n30 avss 1.29989f
C1386 dvdd.t12 avss 0.37114f
C1387 dvdd.t11 avss 0.6405f
C1388 dvdd.n31 avss 1.27351f
C1389 dvdd.n32 avss 0.24463f
C1390 dvdd.n33 avss 0.16481f
C1391 dvdd.n34 avss 0.17151f
C1392 dvdd.n35 avss 0.25733f
C1393 dvdd.n36 avss 2.66646f
C1394 dvdd.n37 avss 2.63653f
C1395 dvdd.t15 avss 3.22517f
C1396 dvdd.n38 avss 2.62452f
C1397 dvdd.t17 avss 3.22283f
C1398 dvdd.n39 avss 2.5644f
C1399 dvdd.n40 avss 0.47213f
C1400 dvdd.n41 avss 3.78027f
C1401 avdd.n0 avss 1.10733f
C1402 avdd.n2 avss 1.47956f
C1403 avdd.n3 avss 1.49978f
C1404 avdd.n5 avss 0.71752f
C1405 avdd.n6 avss 1.48926f
C1406 avdd.n7 avss 1.80328f
C1407 avdd.n8 avss 1.53215f
C1408 avdd.n9 avss 0.23173f
C1409 avdd.n10 avss 1.6361f
C1410 avdd.n11 avss 4.27103f
C1411 avdd.n12 avss 0.50921f
C1412 avdd.n13 avss 1.25312f
C1413 avdd.n14 avss 0.42703f
C1414 avdd.n15 avss 0.27259f
C1415 avdd.n16 avss 0.19911f
C1416 avdd.n17 avss 0.25288f
C1417 avdd.n19 avss 1.86212f
C1418 avdd.n20 avss 1.16887f
C1419 avdd.n21 avss 1.36045f
C1420 avdd.n22 avss 0.7567f
C1421 avdd.n23 avss 0.51847f
C1422 avdd.n24 avss 2.02169f
C1423 avdd.n26 avss 1.21574f
C1424 avdd.n27 avss 1.07629f
C1425 avdd.n28 avss 1.03004f
C1426 avdd.n29 avss 4.48498f
C1427 avdd.n30 avss 0.62494f
C1428 avdd.n31 avss 1.56296f
C1429 avdd.n32 avss 0.10308f
C1430 avdd.n33 avss 0.65011f
C1431 avdd.n34 avss 0.25403f
C1432 avdd.n35 avss 0.1414f
C1433 avdd.n36 avss 0.50921f
C1434 avdd.n37 avss 1.00685f
C1435 avdd.n38 avss 1.59786f
C1436 avdd.n39 avss 1.16538f
C1437 avdd.n40 avss 0.53236f
C1438 avdd.n41 avss 1.17121f
C1439 avdd.n42 avss 0.24379f
C1440 avdd.n43 avss 1.19071f
C1441 avdd.n44 avss 1.12258f
C1442 avdd.n45 avss 1.53264f
C1443 avdd.n46 avss 1.57582f
C1444 avdd.n47 avss 1.07629f
C1445 avdd.n48 avss 2.71118f
C1446 avdd.n49 avss 0.10049f
C1447 avdd.n51 avss 0.28139f
C1448 avdd.n52 avss 0.13235f
C1449 avdd.n53 avss 0.15187f
C1450 avdd.n54 avss 0.16248f
C1451 avdd.n55 avss 0.1623f
C1452 avdd.n56 avss 0.31246f
C1453 avdd.n57 avss 0.27711f
C1454 avdd.n58 avss 0.13936f
C1455 avdd.n59 avss 4.32953f
C1456 avdd.n60 avss 0.14579f
C1457 avdd.n61 avss 0.21872f
C1458 avdd.n62 avss 0.6018f
C1459 avdd.n63 avss 0.21937f
C1460 avdd.n64 avss 0.57865f
C1461 avdd.n65 avss 0.21847f
C1462 avdd.n66 avss 1.89264f
C1463 avdd.n67 avss 0.15832f
C1464 avdd.n68 avss 2.14924f
C1465 avdd.n69 avss 0.98423f
C1466 avdd.t215 avss 1.17996f
C1467 avdd.n70 avss 1.34862f
C1468 avdd.t214 avss 1.04732f
C1469 avdd.n71 avss 1.44861f
C1470 avdd.n72 avss 2.16087f
C1471 avdd.t12 avss 1.16903f
C1472 avdd.t11 avss 0.99555f
C1473 avdd.n73 avss 1.50916f
C1474 avdd.t23 avss 0.70066f
C1475 avdd.n76 avss 1.29914f
C1476 avdd.t175 avss 1.67686f
C1477 avdd.t16 avss 1.66326f
C1478 avdd.t18 avss 1.668f
C1479 avdd.t15 avss 2.27355f
C1480 avdd.t174 avss 2.43296f
C1481 avdd.n77 avss 3.13605f
C1482 avdd.t153 avss 2.4146f
C1483 avdd.n78 avss 2.7007f
C1484 avdd.t155 avss 2.41577f
C1485 avdd.n79 avss 2.65863f
C1486 avdd.n81 avss 2.75928f
C1487 avdd.t17 avss 2.27472f
C1488 avdd.n82 avss 2.75982f
C1489 avdd.t114 avss 1.6646f
C1490 avdd.t34 avss 2.10589f
C1491 avdd.n83 avss 2.62714f
C1492 avdd.n84 avss 0.43399f
C1493 avdd.t116 avss 1.66657f
C1494 avdd.t29 avss 2.23347f
C1495 avdd.t28 avss 2.10754f
C1496 avdd.n85 avss 2.62273f
C1497 avdd.n86 avss 0.48607f
C1498 avdd.t27 avss 2.23347f
C1499 avdd.t26 avss 2.23498f
C1500 avdd.t25 avss 2.23347f
C1501 avdd.n87 avss 2.60487f
C1502 avdd.t13 avss 1.59784f
C1503 avdd.n88 avss 1.9632f
C1504 avdd.t44 avss 1.73131f
C1505 avdd.t83 avss 1.73131f
C1506 avdd.n89 avss 1.83742f
C1507 avdd.t14 avss 1.84714f
C1508 avdd.n90 avss 0.14208f
C1509 avdd.t211 avss 1.84639f
C1510 avdd.t45 avss 1.84194f
C1511 avdd.n92 avss 0.11479f
C1512 avdd.t84 avss 1.84194f
C1513 avdd.t63 avss 1.84194f
C1514 avdd.t3 avss 1.84639f
C1515 avdd.n95 avss 0.72204f
C1516 avdd.n96 avss 0.11615f
C1517 avdd.n97 avss 0.16028f
C1518 avdd.t62 avss 1.59784f
C1519 avdd.t2 avss 1.67354f
C1520 avdd.t8 avss 1.84718f
C1521 avdd.t10 avss 1.84723f
C1522 avdd.t9 avss 1.6004f
C1523 avdd.n100 avss 1.95153f
C1524 avdd.t212 avss 1.6004f
C1525 avdd.t67 avss 1.76179f
C1526 avdd.t246 avss 1.84656f
C1527 avdd.t191 avss 1.84199f
C1528 avdd.t177 avss 1.87567f
C1529 avdd.n101 avss 0.129f
C1530 avdd.t193 avss 1.84199f
C1531 avdd.n102 avss 0.11172f
C1532 avdd.t244 avss 1.83361f
C1533 avdd.n103 avss 0.13087f
C1534 avdd.n105 avss 0.81011f
C1535 avdd.t192 avss 1.73157f
C1536 avdd.n106 avss 1.86339f
C1537 avdd.t243 avss 1.73157f
C1538 avdd.t245 avss 1.73157f
C1539 avdd.n107 avss 1.82574f
C1540 avdd.t65 avss 5.37772f
C1541 avdd.n108 avss 0.10051f
C1542 avdd.t49 avss 3.82438f
C1543 avdd.n109 avss 4.21326f
C1544 avdd.t50 avss 5.48077f
C1545 avdd.n110 avss 0.16164f
C1546 avdd.t64 avss 3.82561f
C1547 avdd.t135 avss 3.6771f
C1548 avdd.n111 avss 4.29284f
C1549 avdd.t225 avss 5.37615f
C1550 avdd.t131 avss 3.82683f
C1551 avdd.n112 avss 4.22623f
C1552 avdd.t132 avss 5.40458f
C1553 avdd.n113 avss 0.62494f
C1554 avdd.n114 avss 0.69438f
C1555 avdd.t257 avss 3.82619f
C1556 avdd.n115 avss 4.25394f
C1557 avdd.t104 avss 3.82386f
C1558 avdd.t259 avss 3.85012f
C1559 avdd.n116 avss 4.72176f
C1560 avdd.n117 avss 1.28585f
C1561 avdd.n118 avss 4.24956f
C1562 avdd.t226 avss 3.8238f
C1563 avdd.n119 avss 4.20419f
C1564 avdd.t227 avss 5.43516f
C1565 avdd.t260 avss 5.42614f
C1566 avdd.t258 avss 5.43558f
C1567 avdd.n120 avss 0.2582f
C1568 avdd.t105 avss 5.43418f
C1569 avdd.n121 avss 0.16951f
C1570 avdd.n122 avss 0.19286f
C1571 avdd.t224 avss 3.82554f
C1572 avdd.t60 avss 3.05479f
C1573 avdd.t4 avss 3.80631f
C1574 avdd.n125 avss 4.28644f
C1575 avdd.t59 avss 3.80748f
C1576 avdd.n126 avss 0.71752f
C1577 avdd.t206 avss 3.80748f
C1578 avdd.n127 avss 0.71752f
C1579 avdd.t100 avss 3.29223f
C1580 avdd.n128 avss 1.23126f
C1581 avdd.t145 avss 2.66343f
C1582 avdd.t127 avss 2.83667f
C1583 avdd.t178 avss 2.86004f
C1584 avdd.n129 avss 3.41245f
C1585 avdd.n130 avss 2.95867f
C1586 avdd.t143 avss 2.83918f
C1587 avdd.n131 avss 2.91986f
C1588 avdd.n133 avss 3.04901f
C1589 avdd.t137 avss 2.6661f
C1590 avdd.n134 avss 3.04847f
C1591 avdd.n136 avss 0.50921f
C1592 avdd.t138 avss 3.38161f
C1593 avdd.t144 avss 3.3767f
C1594 avdd.t128 avss 3.37582f
C1595 avdd.t179 avss 3.40111f
C1596 avdd.n137 avss 0.15897f
C1597 avdd.n138 avss 0.1105f
C1598 avdd.n139 avss 0.81462f
C1599 avdd.n140 avss 0.93576f
C1600 avdd.t162 avss 2.83923f
C1601 avdd.t141 avss 2.86824f
C1602 avdd.n141 avss 3.12921f
C1603 avdd.n142 avss 2.94825f
C1604 avdd.t164 avss 2.84064f
C1605 avdd.n143 avss 2.95379f
C1606 avdd.t166 avss 2.66608f
C1607 avdd.n144 avss 3.03167f
C1608 avdd.t168 avss 2.84064f
C1609 avdd.t165 avss 3.37816f
C1610 avdd.t142 avss 3.38773f
C1611 avdd.t163 avss 3.37246f
C1612 avdd.n145 avss 0.21024f
C1613 avdd.t167 avss 3.28895f
C1614 avdd.t169 avss 3.37816f
C1615 avdd.t39 avss 2.10577f
C1616 avdd.t38 avss 2.23493f
C1617 avdd.n150 avss 2.56529f
C1618 avdd.n151 avss 0.48607f
C1619 avdd.t37 avss 2.23323f
C1620 avdd.t36 avss 2.23493f
C1621 avdd.t35 avss 2.23323f
C1622 avdd.t190 avss 1.73157f
C1623 avdd.n152 avss 1.89919f
C1624 avdd.t176 avss 1.73157f
C1625 avdd.n153 avss 1.87719f
C1626 avdd.n154 avss 0.67123f
C1627 avdd.n155 avss 2.58066f
C1628 avdd.n156 avss 2.57918f
C1629 avdd.n157 avss 2.57857f
C1630 avdd.n158 avss 0.48607f
C1631 avdd.n159 avss 0.41663f
C1632 avdd.n161 avss 2.60598f
C1633 avdd.t21 avss 0.36739f
C1634 avdd.n163 avss 0.74744f
C1635 avdd.n164 avss 0.13928f
C1636 avdd.t171 avss 3.41119f
C1637 avdd.n165 avss 0.14049f
C1638 avdd.t170 avss 2.8425f
C1639 avdd.n166 avss 2.90296f
C1640 avdd.n168 avss 2.94542f
C1641 avdd.n169 avss 0.48607f
C1642 avdd.n170 avss 1.11101f
C1643 avdd.n171 avss 0.69701f
C1644 avdd.n172 avss 0.23176f
C1645 avdd.t146 avss 3.29213f
C1646 avdd.t140 avss 3.4151f
C1647 avdd.n174 avss 0.10746f
C1648 avdd.n175 avss 0.63709f
C1649 avdd.n176 avss 0.57865f
C1650 avdd.t139 avss 2.83667f
C1651 avdd.n177 avss 3.07093f
C1652 avdd.n178 avss 0.25074f
C1653 avdd.t110 avss 3.2715f
C1654 avdd.t254 avss 3.31661f
C1655 avdd.t209 avss 3.31491f
C1656 avdd.n180 avss 0.17101f
C1657 avdd.t253 avss 3.80748f
C1658 avdd.t108 avss 3.3609f
C1659 avdd.t74 avss 4.92861f
C1660 avdd.t75 avss 4.35962f
C1661 avdd.t73 avss 4.62717f
C1662 avdd.t189 avss 4.63132f
C1663 avdd.t187 avss 4.63484f
C1664 avdd.t160 avss 4.63454f
C1665 avdd.t204 avss 0.38358f
C1666 avdd.n181 avss 0.81262f
C1667 avdd.n182 avss 1.00514f
C1668 avdd.t133 avss 2.34444f
C1669 avdd.n183 avss 2.86194f
C1670 avdd.t46 avss 2.33234f
C1671 avdd.t183 avss 2.33147f
C1672 avdd.n184 avss 2.80136f
C1673 avdd.n185 avss 0.98248f
C1674 avdd.t184 avss 2.41094f
C1675 avdd.n186 avss 0.32601f
C1676 avdd.t47 avss 2.37881f
C1677 avdd.t134 avss 2.40166f
C1678 avdd.n188 avss 0.22487f
C1679 avdd.t218 avss 4.49812f
C1680 avdd.n189 avss 0.71752f
C1681 avdd.n190 avss 0.10416f
C1682 avdd.t41 avss 4.49957f
C1683 avdd.t81 avss 4.49957f
C1684 avdd.t82 avss 4.30906f
C1685 avdd.n191 avss 4.85687f
C1686 avdd.n192 avss 4.8092f
C1687 avdd.n193 avss 1.06635f
C1688 avdd.n194 avss 0.71752f
C1689 avdd.n195 avss 1.309f
C1690 avdd.t181 avss 4.49632f
C1691 avdd.t182 avss 4.49893f
C1692 avdd.t252 avss 4.49632f
C1693 avdd.n196 avss 4.97292f
C1694 avdd.n197 avss 0.47487f
C1695 avdd.n198 avss 4.77616f
C1696 avdd.n199 avss 4.77645f
C1697 avdd.t219 avss 4.49893f
C1698 avdd.t173 avss 3.30663f
C1699 avdd.n200 avss 0.1499f
C1700 avdd.n201 avss 0.67123f
C1701 avdd.t172 avss 3.85452f
C1702 avdd.n202 avss 4.21031f
C1703 avdd.t251 avss 3.31526f
C1704 avdd.t239 avss 3.29155f
C1705 avdd.t237 avss 3.4224f
C1706 avdd.n203 avss 0.23162f
C1707 avdd.t198 avss 3.84577f
C1708 avdd.t238 avss 3.84435f
C1709 avdd.n205 avss 4.27045f
C1710 avdd.t236 avss 3.8699f
C1711 avdd.n206 avss 4.78347f
C1712 avdd.n207 avss 1.309f
C1713 avdd.n208 avss 4.29477f
C1714 avdd.t201 avss 3.29155f
C1715 avdd.t199 avss 3.3555f
C1716 avdd.n209 avss 0.23764f
C1717 avdd.n210 avss 0.11639f
C1718 avdd.t200 avss 3.6933f
C1719 avdd.n212 avss 4.31555f
C1720 avdd.n213 avss 0.20004f
C1721 avdd.n214 avss 0.19849f
C1722 avdd.t96 avss 3.30029f
C1723 avdd.t95 avss 3.84551f
C1724 avdd.t97 avss 3.85252f
C1725 avdd.n215 avss 0.71752f
C1726 avdd.t52 avss 3.39183f
C1727 avdd.n216 avss 0.15396f
C1728 avdd.t53 avss 3.84669f
C1729 avdd.t223 avss 3.69111f
C1730 avdd.n217 avss 4.37744f
C1731 avdd.t61 avss 3.84057f
C1732 avdd.t217 avss 3.87813f
C1733 avdd.n218 avss 5.11256f
C1734 avdd.n219 avss 1.05687f
C1735 avdd.n220 avss 4.32119f
C1736 avdd.t123 avss 3.69111f
C1737 avdd.n221 avss 4.36572f
C1738 avdd.t40 avss 2.17699f
C1739 avdd.n223 avss 2.87715f
C1740 avdd.n224 avss 0.22046f
C1741 avdd.t51 avss 3.69447f
C1742 avdd.n225 avss 4.38495f
C1743 avdd.t103 avss 3.84181f
C1744 avdd.n227 avss 4.29627f
C1745 avdd.t233 avss 3.31022f
C1746 avdd.n228 avss 0.15057f
C1747 avdd.t234 avss 3.94237f
C1748 avdd.t235 avss 3.31412f
C1749 avdd.n229 avss 1.57868f
C1750 avdd.t229 avss 3.31299f
C1751 avdd.n230 avss 0.71752f
C1752 avdd.n231 avss 0.67123f
C1753 avdd.t147 avss 3.85363f
C1754 avdd.t202 avss 3.8521f
C1755 avdd.n232 avss 4.23245f
C1756 avdd.t111 avss 25.9201f
C1757 avdd.n233 avss 1.76795f
C1758 avdd.t85 avss 3.8521f
C1759 avdd.t241 avss 3.3076f
C1760 avdd.t86 avss 3.37483f
C1761 avdd.t203 avss 3.31299f
C1762 avdd.n234 avss 0.23701f
C1763 avdd.n235 avss 0.11203f
C1764 avdd.t240 avss 3.85363f
C1765 avdd.n237 avss 4.26834f
C1766 avdd.n238 avss 4.37313f
C1767 avdd.n239 avss 1.40262f
C1768 avdd.n240 avss 0.57865f
C1769 avdd.n241 avss 4.26909f
C1770 avdd.n242 avss 0.11982f
C1771 avdd.t148 avss 3.31201f
C1772 avdd.t151 avss 3.85356f
C1773 avdd.n243 avss 4.20885f
C1774 avdd.t152 avss 3.30979f
C1775 avdd.t150 avss 3.31022f
C1776 avdd.t88 avss 3.38913f
C1777 avdd.t90 avss 3.3095f
C1778 avdd.n244 avss 0.25344f
C1779 avdd.t149 avss 3.8515f
C1780 avdd.n245 avss 4.29385f
C1781 avdd.t0 avss 0.67444f
C1782 avdd.t1 avss 0.45913f
C1783 avdd.t20 avss 0.90758f
C1784 avdd.t19 avss 0.28593f
C1785 avdd.n247 avss 0.33857f
C1786 avdd.t216 avss 3.68888f
C1787 avdd.n248 avss 4.38904f
C1788 avdd.t6 avss 3.84181f
C1789 avdd.n249 avss 4.28328f
C1790 avdd.t129 avss 3.8397f
C1791 avdd.n250 avss 4.28359f
C1792 avdd.t130 avss 3.84181f
C1793 avdd.n251 avss 4.2838f
C1794 avdd.t247 avss 3.8397f
C1795 avdd.n252 avss 4.30484f
C1796 avdd.n253 avss 0.86868f
C1797 avdd.t221 avss 0.68411f
C1798 avdd.n254 avss 1.24996f
C1799 avdd.t158 avss 4.80852f
C1800 avdd.t124 avss 0.37832f
C1801 avdd.n255 avss 0.8526f
C1802 avdd.t157 avss 0.59444f
C1803 avdd.n256 avss 1.19437f
C1804 avdd.n258 avss 0.13095f
C1805 avdd.t126 avss 13.11112f
C1806 avdd.t125 avss 0.59434f
C1807 avdd.n260 avss 1.209f
C1808 avdd.n261 avss 1.33044f
C1809 avdd.n262 avss 0.11889f
C1810 avdd.t87 avss 3.69999f
C1811 avdd.n263 avss 4.38313f
C1812 avdd.t89 avss 3.70211f
C1813 avdd.n264 avss 4.39763f
C1814 avdd.n265 avss 0.10416f
C1815 avdd.n266 avss 0.90981f
C1816 avdd.n267 avss 0.71752f
C1817 avdd.n268 avss 1.15163f
C1818 avdd.n269 avss 0.10215f
C1819 avdd.n271 avss 0.16025f
C1820 avdd.n272 avss 0.24292f
C1821 avdd.t232 avss 3.8515f
C1822 avdd.n274 avss 4.26859f
C1823 avdd.t228 avss 3.8521f
C1824 avdd.n275 avss 4.23377f
C1825 avdd.n276 avss 0.21231f
C1826 avdd.t230 avss 3.85363f
C1827 avdd.n278 avss 4.31884f
C1828 avdd.n279 avss 0.11758f
C1829 avdd.t231 avss 3.31187f
C1830 avdd.n281 avss 1.05314f
C1831 avdd.n283 avss 4.22805f
C1832 avdd.n284 avss 0.11952f
C1833 avdd.n285 avss 0.11082f
C1834 avdd.t194 avss 3.84575f
C1835 avdd.n286 avss 4.26795f
C1836 avdd.t196 avss 3.84693f
C1837 avdd.t197 avss 3.35729f
C1838 avdd.n287 avss 0.16511f
C1839 avdd.t119 avss 3.84575f
C1840 avdd.t121 avss 3.84693f
C1841 avdd.t122 avss 3.30365f
C1842 avdd.t92 avss 3.30679f
C1843 avdd.n288 avss 0.16972f
C1844 avdd.t94 avss 3.30835f
C1845 avdd.n289 avss 0.16862f
C1846 avdd.t56 avss 2.81745f
C1847 avdd.t58 avss 2.81807f
C1848 avdd.t55 avss 9.38358f
C1849 avdd.t57 avss 9.29149f
C1850 avdd.n290 avss 5.11409f
C1851 avdd.n291 avss 0.48607f
C1852 avdd.t112 avss 8.64701f
C1853 avdd.t48 avss 8.64213f
C1854 avdd.t261 avss 8.64701f
C1855 avdd.t185 avss 8.64213f
C1856 avdd.n292 avss 4.87438f
C1857 avdd.n293 avss 0.74067f
C1858 avdd.t242 avss 8.64701f
C1859 avdd.t117 avss 8.64701f
C1860 avdd.t106 avss 8.64213f
C1861 avdd.t161 avss 8.64701f
C1862 avdd.n294 avss 4.87391f
C1863 avdd.t80 avss 8.64213f
C1864 avdd.n295 avss 4.83325f
C1865 avdd.t118 avss 8.64701f
C1866 avdd.t70 avss 4.92539f
C1867 avdd.t159 avss 4.92751f
C1868 avdd.t186 avss 4.92696f
C1869 avdd.n296 avss 4.52063f
C1870 avdd.n297 avss 0.6018f
C1871 avdd.t188 avss 4.92551f
C1872 avdd.t72 avss 4.92521f
C1873 avdd.n298 avss 4.52585f
C1874 avdd.n299 avss 4.52416f
C1875 avdd.n300 avss 0.6018f
C1876 avdd.n301 avss 0.50921f
C1877 avdd.n302 avss 4.52054f
C1878 avdd.n303 avss 4.69284f
C1879 avdd.n304 avss 4.98071f
C1880 avdd.n306 avss 1.56891f
C1881 avdd.n307 avss 0.67123f
C1882 avdd.n308 avss 0.48607f
C1883 avdd.n309 avss 4.87438f
C1884 avdd.n310 avss 4.92274f
C1885 avdd.n311 avss 4.91811f
C1886 avdd.n312 avss 0.71752f
C1887 avdd.n313 avss 0.48607f
C1888 avdd.n314 avss 0.48607f
C1889 avdd.n315 avss 4.87181f
C1890 avdd.n316 avss 4.87438f
C1891 avdd.n317 avss 4.87181f
C1892 avdd.n318 avss 0.46292f
C1893 avdd.n319 avss 1.46285f
C1894 avdd.n320 avss 1.61125f
C1895 avdd.n321 avss 0.36997f
C1896 avdd.n322 avss 0.12216f
C1897 avdd.t91 avss 3.69472f
C1898 avdd.n323 avss 4.3841f
C1899 avdd.t93 avss 3.84693f
C1900 avdd.n324 avss 4.30877f
C1901 avdd.n325 avss 0.14957f
C1902 avdd.n327 avss 4.25129f
C1903 avdd.t120 avss 3.35561f
C1904 avdd.n328 avss 0.16023f
C1905 avdd.n329 avss 4.24544f
C1906 avdd.n330 avss 0.71752f
C1907 avdd.n331 avss 0.6018f
C1908 avdd.n332 avss 4.25129f
C1909 avdd.n333 avss 0.11823f
C1910 avdd.t195 avss 3.30665f
C1911 avdd.n334 avss 0.10988f
C1912 avdd.n335 avss 0.49764f
C1913 avdd.n336 avss 0.6018f
C1914 avdd.n337 avss 4.29558f
C1915 avdd.t248 avss 3.84551f
C1916 avdd.n338 avss 4.27103f
C1917 avdd.t54 avss 3.35519f
C1918 avdd.t249 avss 3.30029f
C1919 avdd.n339 avss 0.2344f
C1920 avdd.t250 avss 3.84669f
C1921 avdd.n341 avss 4.29558f
C1922 avdd.n342 avss 0.71752f
C1923 avdd.n344 avss 0.1122f
C1924 avdd.t98 avss 3.30644f
C1925 avdd.n345 avss 0.14191f
C1926 avdd.n346 avss 0.90101f
C1927 avdd.n347 avss 0.82168f
C1928 avdd.n348 avss 1.93456f
C1929 avdd.n349 avss 1.67527f
C1930 avdd.n350 avss 4.71366f
C1931 avdd.t220 avss 4.49632f
C1932 avdd.n351 avss 4.7882f
C1933 avdd.t180 avss 4.30994f
C1934 avdd.n352 avss 4.85387f
C1935 avdd.n353 avss 0.10879f
C1936 avdd.n354 avss 1.44662f
C1937 avdd.n355 avss 1.44662f
C1938 avdd.n356 avss 4.77794f
C1939 avdd.t42 avss 4.49812f
C1940 avdd.n357 avss 4.77708f
C1941 avdd.t43 avss 4.49957f
C1942 avdd.n358 avss 4.77083f
C1943 avdd.n359 avss 1.06635f
C1944 avdd.n360 avss 4.95055f
C1945 avdd.n361 avss 0.27914f
C1946 avdd.n362 avss 0.16838f
C1947 avdd.n364 avss 2.87f
C1948 avdd.t205 avss 0.30367f
C1949 avdd.n367 avss 0.98194f
C1950 avdd.n368 avss 1.03535f
C1951 avdd.t71 avss 4.51601f
C1952 avdd.n369 avss 0.14316f
C1953 avdd.n370 avss 0.15629f
C1954 avdd.t107 avss 3.80748f
C1955 avdd.n371 avss 4.22677f
C1956 avdd.n372 avss 0.17587f
C1957 avdd.t208 avss 3.80631f
C1958 avdd.n373 avss 4.21625f
C1959 avdd.n374 avss 0.71752f
C1960 avdd.n375 avss 0.71752f
C1961 avdd.n376 avss 4.22212f
C1962 avdd.n377 avss 0.17587f
C1963 avdd.t109 avss 3.80631f
C1964 avdd.n378 avss 4.21625f
C1965 avdd.n379 avss 0.11324f
C1966 avdd.t99 avss 3.80748f
C1967 avdd.n380 avss 4.1994f
C1968 avdd.n381 avss 1.06471f
C1969 avdd.n382 avss 1.08786f
C1970 avdd.n383 avss 4.2251f
C1971 avdd.t255 avss 3.80631f
C1972 avdd.n384 avss 4.24195f
C1973 avdd.t256 avss 3.27179f
C1974 avdd.t207 avss 3.30113f
C1975 avdd.n385 avss 0.26761f
C1976 avdd.t101 avss 3.80748f
C1977 avdd.n387 avss 4.26652f
C1978 avdd.n388 avss 0.71752f
C1979 avdd.n389 avss 0.71752f
C1980 avdd.n390 avss 0.88358f
C1981 avdd.n391 avss 0.69438f
C1982 avdd.n392 avss 4.28065f
C1983 avdd.n393 avss 0.13381f
C1984 avdd.t102 avss 3.32809f
C1985 avdd.t5 avss 3.27639f
C1986 avdd.n394 avss 0.33166f
C1987 avdd.n395 avss 0.1165f
C1988 avdd.n396 avss 4.18346f
C1989 avdd.n397 avss 0.6018f
C1990 avdd.n398 avss 0.88445f
C1991 avdd.n400 avss 0.1266f
C1992 avdd.n402 avss 4.18904f
C1993 avdd.n403 avss 0.6018f
C1994 avdd.n404 avss 0.9076f
C1995 avdd.t136 avss 5.45403f
C1996 avdd.n406 avss 0.13256f
C1997 avdd.n408 avss 1.87542f
C1998 avdd.t66 avss 1.73157f
C1999 avdd.n409 avss 1.85772f
C2000 avdd.n410 avss 0.57865f
C2001 avdd.t30 avss 2.10589f
C2002 avdd.n411 avss 2.60773f
C2003 avdd.n412 avss 0.48607f
C2004 avdd.t33 avss 2.10753f
C2005 avdd.n414 avss 2.62251f
C2006 avdd.n415 avss 0.48607f
C2007 avdd.t32 avss 2.10589f
C2008 avdd.n417 avss 2.65314f
C2009 avdd.t31 avss 2.23496f
C2010 avdd.n419 avss 2.60203f
C2011 avdd.n420 avss 0.81904f
C2012 avdd.n421 avss 0.15909f
C2013 avdd.t68 avss 1.6004f
C2014 avdd.n422 avss 1.96944f
C2015 avdd.t76 avss 1.73382f
C2016 avdd.t69 avss 1.86059f
C2017 avdd.t77 avss 1.8421f
C2018 avdd.t79 avss 1.8421f
C2019 avdd.n423 avss 0.11147f
C2020 avdd.n425 avss 0.12921f
C2021 avdd.n426 avss 1.02002f
C2022 avdd.n427 avss 1.98552f
C2023 avdd.t78 avss 1.73382f
C2024 avdd.n428 avss 1.86472f
C2025 avdd.t7 avss 1.73382f
C2026 avdd.n429 avss 1.95131f
C2027 avdd.n430 avss 2.00426f
C2028 avdd.t213 avss 1.84718f
C2029 avdd.n434 avss 0.10751f
C2030 avdd.n435 avss 0.13806f
C2031 avdd.n436 avss 3.99709f
C2032 avdd.n438 avss 0.5555f
C2033 avdd.n439 avss 1.89899f
C2034 avdd.t210 avss 1.73131f
C2035 avdd.n440 avss 1.85861f
C2036 avdd.n442 avss 0.50247f
C2037 avdd.n443 avss 0.48607f
C2038 avdd.n444 avss 2.5796f
C2039 avdd.n445 avss 2.59496f
C2040 avdd.n447 avss 0.47946f
C2041 avdd.n448 avss 0.52203f
C2042 avdd.n449 avss 2.58759f
C2043 avdd.t115 avss 2.41397f
C2044 avdd.n450 avss 2.68566f
C2045 avdd.n451 avss 0.81069f
C2046 avdd.t113 avss 2.41594f
C2047 avdd.n455 avss 0.39348f
C2048 avdd.n456 avss 0.13149f
C2049 avdd.t156 avss 1.668f
C2050 avdd.n458 avss 0.13807f
C2051 avdd.t154 avss 1.66791f
C2052 avdd.n459 avss 0.37468f
C2053 avdd.n460 avss 0.14322f
C2054 avdd.n461 avss 0.87955f
C2055 avdd.n462 avss 6.87531f
C2056 b3.n0 avss 11.7415f
C2057 b3.n1 avss 6.4235f
C2058 b4.n0 avss 7.45157f
C2059 b4.n1 avss 6.38802f
C2060 b0.n0 avss 2.11658f
C2061 b0.n1 avss 0.95234f
C2062 b0.n2 avss 5.04094f
C2063 b5.n0 avss 3.41489f
C2064 b5.n1 avss 6.25357f
C2065 b6.n0 avss 3.13222f
C2066 b6.n1 avss 5.89105f
C2067 b2.n0 avss 4.59191f
C2068 b2.n1 avss 6.03827f
C2069 b1.n0 avss 3.00379f
C2070 b1.n1 avss 6.2636f
C2071 vref.t1 avss 11.24425f
C2072 net4 avss 12.78002f
C2073 net3 avss 27.03643f
C2074 vq2 avss 8.91043f
C2075 v1 avss 17.05551f
C2076 vq3 avss 31.44154f
.ends
