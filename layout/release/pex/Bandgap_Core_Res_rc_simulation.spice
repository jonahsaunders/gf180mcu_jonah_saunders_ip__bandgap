* NGSPICE file created from Bandgap_Core_Res.ext - technology: gf180mcuD

.subckt Bandgap_Core_Res avdd avss vref b0 b1 b2 b3 b4 b5 b6 dvss dvdd
Xpnp_05p00x05p00_0 avss avss vq3 pnp_05p00x05p00
Xpnp_05p00x05p00_1 avss avss vq2 pnp_05p00x05p00
Xpnp_05p00x05p00_2 avss avss vq2 pnp_05p00x05p00
Xpnp_05p00x05p00_4 avss avss vq2 pnp_05p00x05p00
Xpnp_05p00x05p00_3 avss avss vq2 pnp_05p00x05p00
Xpnp_05p00x05p00_5 avss avss v1 pnp_05p00x05p00
Xpnp_05p00x05p00_6 avss avss vq2 pnp_05p00x05p00
Xpnp_05p00x05p00_7 avss avss vq2 pnp_05p00x05p00
Xpnp_05p00x05p00_8 avss avss vq2 pnp_05p00x05p00
Xpnp_05p00x05p00_9 avss avss vq2 pnp_05p00x05p00
Xnwell_0 net3 net4 avss nwell r_length=20.19u r_width=2u
X0 rbit0top.t9 b0.t2 rbit1top.t13 dvss nfet_03v3 ad=17.6p pd=80.88u as=17.6p ps=80.88u w=40u l=0.28u
X1 vref.t4 vcasp vx3.t2 avdd.t39 pfet_05v0 ad=7.2248p pd=33.72u as=7.2248p ps=33.72u w=16.42u l=4u
X2 vx2.t7 psrg_m3_feed.t14 avdd.t117 avdd.t116 pfet_05v0 ad=7.37p pd=34.38u as=7.37p ps=34.38u w=16.75u l=2u
X3 vbn_sink.t4 vbn_sink.t3 avss avss nfet_05v0 ad=5.4164p pd=25.5u as=5.4164p ps=25.5u w=12.31u l=8u
X4 vbn_fold.t12 vbp_i.t14 avdd.t201 avdd.t200 pfet_05v0 ad=8.3556p pd=38.86u as=8.3556p ps=38.86u w=18.99u l=8u
X5 vx3.t0 psrg_m3_feed.t26 avdd.t25 avdd.t24 pfet_05v0 ad=7.37p pd=34.38u as=7.37p ps=34.38u w=16.75u l=2u
X6 vbp_bias.t8 vbp_bias.t7 avdd.t191 avdd.t190 pfet_03v3 ad=8.3864p pd=39u as=8.3864p ps=39u w=19.06u l=8u
X7 vgn2.t7 avss cap_mim_2f0fF c_width=59u c_length=59u
X8 vbn_sink.t7 vbp_i.t24 avdd.t142 avdd.t141 pfet_05v0 ad=8.338p pd=38.78u as=8.338p ps=38.78u w=18.95u l=8u
X9 b3_b.t1 b3.t0 dvdd.t19 dvdd.t18 pfet_03v3 ad=1.32p pd=6.88u as=1.32p ps=6.88u w=3u l=0.5u
X10 vref.t1 vcasp vx3.t4 avdd.t44 pfet_05v0 ad=7.2248p pd=33.72u as=7.2248p ps=33.72u w=16.42u l=4u
X11 vbn_sink.t8 vbp_i.t25 avdd.t144 avdd.t143 pfet_05v0 ad=8.338p pd=38.78u as=8.338p ps=38.78u w=18.95u l=8u
X12 vref.t7 avss cap_mim_2f0fF c_width=70.7u c_length=70.7u
X13 su_state.t0 vbp_tail.t7 avdd.t2 avdd.t1 pfet_05v0 ad=0.44p pd=2.88u as=0.44p ps=2.88u w=1u l=8u
X14 vbn_i.t5 vbp_i.t40 avdd.t193 avdd.t192 pfet_05v0 ad=8.25p pd=38.38u as=8.25p ps=38.38u w=18.75u l=8u
X15 rbit3top.t3 b2_b.t3 rbit2top.t1 dvdd.t4 pfet_03v3 ad=8.8p pd=40.88u as=8.8p ps=40.88u w=20u l=0.28u
X16 xf2.t8 vbn_sink.t32 avss avss nfet_05v0 ad=7.1896p pd=33.56u as=7.1896p ps=33.56u w=16.34u l=8u
X17 rbit6top.t0 b5_b.t2 rbit5top.t0 dvdd.t6 pfet_03v3 ad=3.3p pd=15.88u as=3.3p ps=15.88u w=7.5u l=0.28u
X18 rbit4top.t4 rbit3top.t6 avss ppolyf_u_1k r_width=6.6u r_length=16u
X19 vbp_bias.t4 vbp_bias.t3 avdd.t207 avdd.t206 pfet_03v3 ad=8.3864p pd=39u as=8.3864p ps=39u w=19.06u l=8u
X20 rb_mid rb_mid avss avss nfet_05v0 ad=0.2376p pd=1.96u as=0.2376p ps=1.96u w=0.54u l=20u
X21 vgn1.t2 vcasp vx1.t2 avdd.t41 pfet_05v0 ad=7.2248p pd=33.72u as=7.2248p ps=33.72u w=16.42u l=4u
X22 xf1.t2 v1.t2 vsp.t5 avdd.t100 pfet_05v0 ad=24.1516p pd=0.11066m as=24.1516p ps=0.11066m w=54.89u l=4u
X23 rfix2 rfix1 avss ppolyf_u_1k r_width=6.6u r_length=0.128m
X24 vx3.t8 psrg_m3_feed.t25 avdd.t74 avdd.t73 pfet_05v0 ad=7.37p pd=34.38u as=7.37p ps=34.38u w=16.75u l=2u
X25 vgn2.t3 vbp_cas.t21 pm2.t2 avdd.t93 pfet_05v0 ad=9.7724p pd=45.3u as=9.7724p ps=45.3u w=22.21u l=8u
X26 vbp_bias.t16 vbp_bias.t15 avdd.t127 avdd.t126 pfet_03v3 ad=8.3864p pd=39u as=8.3864p ps=39u w=19.06u l=8u
X27 aux_gate vcasp avdd.t37 avdd.t36 pfet_05v0 ad=0.22p pd=1.88u as=0.22p ps=1.88u w=0.5u l=10u
X28 xf2.t0 v2.t5 vsp.t0 avdd.t0 pfet_05v0 ad=24.1516p pd=0.11066m as=24.1516p ps=0.11066m w=54.89u l=4u
X29 vsu vsu bgsu1 avss nfet_05v0 ad=0.44p pd=2.88u as=0.44p ps=2.88u w=1u l=2u
X30 vbp_cas.t18 vbp_cas.t17 vbp_bias.t22 avdd.t189 pfet_05v0 ad=8.3292p pd=38.74u as=8.3292p ps=38.74u w=18.93u l=8u
X31 rbit6top.t1 rbit5top.t2 avss ppolyf_u_1k r_width=6.6u r_length=64u
X32 vx1.t7 psrg_m3_feed.t16 avdd.t62 avdd.t61 pfet_05v0 ad=7.37p pd=34.38u as=7.37p ps=34.38u w=16.75u l=2u
X33 psrg_m3_feed.t2 vcasp vx2.t2 avdd.t46 pfet_05v0 ad=7.2248p pd=33.72u as=7.2248p ps=33.72u w=16.42u l=4u
X34 vbp_bias.t6 vbp_bias.t5 avdd.t228 avdd.t227 pfet_03v3 ad=8.3864p pd=39u as=8.3864p ps=39u w=19.06u l=8u
X35 xf1.t6 vbn_sink.t26 avss avss nfet_05v0 ad=7.1896p pd=33.56u as=7.1896p ps=33.56u w=16.34u l=8u
X36 xf1.t7 vbn_sink.t27 avss avss nfet_05v0 ad=7.1896p pd=33.56u as=7.1896p ps=33.56u w=16.34u l=8u
X37 vbp_cas.t16 vbp_cas.t15 vbp_bias.t21 avdd.t188 pfet_05v0 ad=8.3292p pd=38.74u as=8.3292p ps=38.74u w=18.93u l=8u
X38 su_state.t1 vsu avdd.t18 avdd.t17 pfet_05v0 ad=0.44p pd=2.88u as=0.44p ps=2.88u w=1u l=8u
X39 vx2.t6 psrg_m3_feed.t23 avdd.t99 avdd.t98 pfet_05v0 ad=7.37p pd=34.38u as=7.37p ps=34.38u w=16.75u l=2u
X40 psrg_vnc.t0 vbp_i.t50 avdd.t10 avdd.t9 pfet_05v0 ad=7.8056p pd=36.36u as=7.8056p ps=36.36u w=17.74u l=4u
X41 pm1.t7 y1.t16 avdd.t242 avdd.t241 pfet_05v0 ad=9.1344p pd=42.4u as=9.1344p ps=42.4u w=20.76u l=4u
X42 vsu psrg_m3_feed.t8 avdd.t258 avdd.t257 pfet_05v0 ad=0.88p pd=4.88u as=0.88p ps=4.88u w=2u l=2u
X43 vbp_cas.t14 vbp_cas.t13 vbp_bias.t0 avdd.t125 pfet_05v0 ad=8.3292p pd=38.74u as=8.3292p ps=38.74u w=18.93u l=8u
X44 vbn_sink.t10 vbp_i.t26 avdd.t160 avdd.t159 pfet_05v0 ad=8.338p pd=38.78u as=8.338p ps=38.78u w=18.95u l=8u
X45 b2_b.t1 b2.t0 dvdd.t25 dvdd.t24 pfet_03v3 ad=1.32p pd=6.88u as=1.32p ps=6.88u w=3u l=0.5u
X46 vbn_sink.t11 vbp_i.t27 avdd.t162 avdd.t161 pfet_05v0 ad=8.338p pd=38.78u as=8.338p ps=38.78u w=18.95u l=8u
X47 b5_b.t1 b5.t0 dvdd.t23 dvdd.t22 pfet_03v3 ad=1.32p pd=6.88u as=1.32p ps=6.88u w=3u l=0.5u
X48 psrg_m3_feed.t0 vcasp vx2.t4 avdd.t38 pfet_05v0 ad=7.2248p pd=33.72u as=7.2248p ps=33.72u w=16.42u l=4u
X49 vgn2.t2 vbp_cas.t25 pm2.t1 avdd.t22 pfet_05v0 ad=9.7724p pd=45.3u as=9.7724p ps=45.3u w=22.21u l=8u
X50 xf2.t4 vbn_sink.t21 avss avss nfet_05v0 ad=7.1896p pd=33.56u as=7.1896p ps=33.56u w=16.34u l=8u
X51 vbp_cas.t12 vbp_cas.t11 vbp_bias.t24 avdd.t224 pfet_05v0 ad=8.3292p pd=38.74u as=8.3292p ps=38.74u w=18.93u l=8u
X52 vx1.t9 psrg_m3_feed.t13 avdd.t79 avdd.t78 pfet_05v0 ad=7.37p pd=34.38u as=7.37p ps=34.38u w=16.75u l=2u
X53 vref.t15 avss cap_mim_2f0fF c_width=70.7u c_length=70.7u
X54 vref.t2 vcasp vx3.t3 avdd.t43 pfet_05v0 ad=7.2248p pd=33.72u as=7.2248p ps=33.72u w=16.42u l=4u
X55 rbit1top.t8 b0_b.t3 rbit0top.t6 dvdd.t0 pfet_03v3 ad=17.6p pd=80.88u as=17.6p ps=80.88u w=40u l=0.28u
X56 vbp_i.t8 vbp_i.t7 avdd.t20 avdd.t19 pfet_05v0 ad=8.25p pd=38.38u as=8.25p ps=38.38u w=18.75u l=8u
X57 y1.t6 psrg_vnc.t9 psrg_mf1_protected.t0 avss nfet_05v0 ad=8.1356p pd=37.86u as=8.1356p ps=37.86u w=18.49u l=6u
X58 rbit0top.t7 rfix2 avss ppolyf_u_1k r_width=6.6u r_length=0.128m
X59 vbn_fold.t10 vbp_i.t19 avdd.t108 avdd.t107 pfet_05v0 ad=8.3556p pd=38.86u as=8.3556p ps=38.86u w=18.99u l=8u
X60 rbit4top.t1 b3_b.t2 rbit3top.t0 dvdd.t5 pfet_03v3 ad=13.2p pd=60.88u as=13.2p ps=60.88u w=30u l=0.28u
X61 rbit5top.t5 b4_b.t2 rbit4top.t5 dvdd.t9 pfet_03v3 ad=6.6p pd=30.88u as=6.6p ps=30.88u w=15u l=0.28u
X62 xf2.t6 vbn_sink.t29 avss avss nfet_05v0 ad=7.1896p pd=33.56u as=7.1896p ps=33.56u w=16.34u l=8u
X63 vbp_i.t4 vbp_i.t3 avdd.t111 avdd.t110 pfet_05v0 ad=8.25p pd=38.38u as=8.25p ps=38.38u w=18.75u l=8u
X64 rbit2top.t3 b1_b.t4 rbit1top.t1 dvdd.t11 pfet_03v3 ad=17.6p pd=80.88u as=17.6p ps=80.88u w=40u l=0.28u
X65 xf2.t5 v2.t4 vsp.t7 avdd.t124 pfet_05v0 ad=24.1516p pd=0.11066m as=24.1516p ps=0.11066m w=54.89u l=4u
X66 rbit4top.t2 b4.t2 rbit5top.t3 dvss nfet_03v3 ad=2.2p pd=10.88u as=2.2p ps=10.88u w=5u l=0.28u
X67 vbp_bias.t2 vbp_bias.t1 avdd.t81 avdd.t80 pfet_03v3 ad=8.3864p pd=39u as=8.3864p ps=39u w=19.06u l=8u
X68 vbn.t2 vbn.t1 avss avss nfet_05v0 ad=3.322p pd=15.98u as=3.322p ps=15.98u w=7.55u l=4u
X69 vbn_fold.t5 vbp_i.t16 avdd.t88 avdd.t87 pfet_05v0 ad=8.3556p pd=38.86u as=8.3556p ps=38.86u w=18.99u l=8u
X70 vsp.t14 vbp_tail.t9 avdd.t218 avdd.t217 pfet_03v3 ad=12.7204p pd=58.7u as=12.7204p ps=58.7u w=28.91u l=6u
X71 vx1.t8 psrg_m3_feed.t24 avdd.t72 avdd.t71 pfet_05v0 ad=7.37p pd=34.38u as=7.37p ps=34.38u w=16.75u l=2u
X72 vref.t6 avss cap_mim_2f0fF c_width=70.7u c_length=70.7u
X73 vbp_cas.t8 vbp_cas.t7 vbp_bias.t25 avdd.t245 pfet_05v0 ad=8.3292p pd=38.74u as=8.3292p ps=38.74u w=18.93u l=8u
X74 xf1.t10 v1.t3 vsp.t15 avdd.t255 pfet_05v0 ad=24.1516p pd=0.11066m as=24.1516p ps=0.11066m w=54.89u l=4u
X75 vaux.t2 psrg_m3_feed.t21 avdd.t154 avdd.t153 pfet_05v0 ad=4.4p pd=20.88u as=4.4p ps=20.88u w=10u l=2u
X76 vbp_tail.t6 vbn_i.t10 avss avss nfet_05v0 ad=6.138p pd=28.78u as=6.138p ps=28.78u w=13.95u l=8u
X77 xf1.t11 vbn_sink.t23 avss avss nfet_05v0 ad=7.1896p pd=33.56u as=7.1896p ps=33.56u w=16.34u l=8u
X78 y1.t0 vbp_cas.t26 pm1.t0 avdd.t23 pfet_05v0 ad=9.7724p pd=45.3u as=9.7724p ps=45.3u w=22.21u l=8u
X79 pm1.t9 y1.t12 avdd.t179 avdd.t178 pfet_05v0 ad=9.1344p pd=42.4u as=9.1344p ps=42.4u w=20.76u l=4u
X80 vbn_i.t6 vbp_i.t41 avdd.t195 avdd.t194 pfet_05v0 ad=8.25p pd=38.38u as=8.25p ps=38.38u w=18.75u l=8u
X81 vbp_cas.t10 vbp_cas.t9 vbp_bias.t26 avdd.t246 pfet_05v0 ad=8.3292p pd=38.74u as=8.3292p ps=38.74u w=18.93u l=8u
X82 psrg_vnc.t5 psrg_vnc.t4 rb_mid avss nfet_05v0 ad=0.3124p pd=2.3u as=0.3124p ps=2.3u w=0.71u l=20u
X83 psrg_vnc.t1 vbp_i.t51 avdd.t12 avdd.t11 pfet_05v0 ad=7.8056p pd=36.36u as=7.8056p ps=36.36u w=17.74u l=4u
X84 rfix0 vref.t5 avss ppolyf_u_1k r_width=6.6u r_length=0.128m
X85 vsp.t8 vbp_tail.t13 avdd.t131 avdd.t130 pfet_03v3 ad=12.7204p pd=58.7u as=12.7204p ps=58.7u w=28.91u l=6u
X86 vbp_cas.t6 vbp_cas.t5 vbp_bias.t23 avdd.t223 pfet_05v0 ad=8.3292p pd=38.74u as=8.3292p ps=38.74u w=18.93u l=8u
X87 pm2.t9 y1.t11 avdd.t164 avdd.t163 pfet_05v0 ad=9.1344p pd=42.4u as=9.1344p ps=42.4u w=20.76u l=4u
X88 vbp_cas.t4 vbp_cas.t3 vbp_bias.t20 avdd.t175 pfet_05v0 ad=8.3292p pd=38.74u as=8.3292p ps=38.74u w=18.93u l=8u
X89 vref.t14 avss cap_mim_2f0fF c_width=70.7u c_length=70.7u
X90 vbn_fold.t3 vbp_i.t21 avdd.t58 avdd.t57 pfet_05v0 ad=8.3556p pd=38.86u as=8.3556p ps=38.86u w=18.99u l=8u
X91 rbit3top.t1 rbit2top.t6 avss ppolyf_u_1k r_width=6.6u r_length=8u
X92 psrg_m3_feed.t6 psrg_vnc.t10 psrg_m3_protected.t1 avss nfet_05v0 ad=6.424p pd=30.08u as=6.424p ps=30.08u w=14.6u l=4u
X93 vbn_fold.t1 vbn_fold.t0 vnx_bias avss nfet_05v0 ad=2.0328p pd=10.12u as=2.0328p ps=10.12u w=4.62u l=6u
X94 vx3.t9 psrg_m3_feed.t12 avdd.t77 avdd.t76 pfet_05v0 ad=7.37p pd=34.38u as=7.37p ps=34.38u w=16.75u l=2u
X95 vbn_sink.t14 vbp_i.t34 avdd.t183 avdd.t182 pfet_05v0 ad=8.338p pd=38.78u as=8.338p ps=38.78u w=18.95u l=8u
X96 vbn_sink.t16 vbp_i.t47 avdd.t199 avdd.t198 pfet_05v0 ad=8.338p pd=38.78u as=8.338p ps=38.78u w=18.95u l=8u
X97 pm1.t8 y1.t13 avdd.t181 avdd.t180 pfet_05v0 ad=9.1344p pd=42.4u as=9.1344p ps=42.4u w=20.76u l=4u
X98 iref_gate.t1 vbp_i.t42 vsu1 avss nfet_05v0 ad=0.22p pd=1.88u as=0.22p ps=1.88u w=0.5u l=50u
X99 vbp_tail.t1 vbp_tail.t0 avdd.t4 avdd.t3 pfet_03v3 ad=6.05p pd=28.38u as=6.05p ps=28.38u w=13.75u l=6u
X100 vbp_i.t10 vbp_i.t9 avdd.t213 avdd.t212 pfet_05v0 ad=8.25p pd=38.38u as=8.25p ps=38.38u w=18.75u l=8u
X101 vbn_fold.t9 vbp_i.t18 avdd.t106 avdd.t105 pfet_05v0 ad=8.3556p pd=38.86u as=8.3556p ps=38.86u w=18.99u l=8u
X102 rfix1 rfix0 avss ppolyf_u_1k r_width=6.6u r_length=0.128m
X103 vbn_fold.t11 vbp_i.t11 avdd.t115 avdd.t114 pfet_05v0 ad=8.3556p pd=38.86u as=8.3556p ps=38.86u w=18.99u l=8u
X104 xf2.t7 vbn_sink.t28 avss avss nfet_05v0 ad=7.1896p pd=33.56u as=7.1896p ps=33.56u w=16.34u l=8u
X105 y1.t1 vbp_cas.t22 pm1.t1 avdd.t94 pfet_05v0 ad=9.7724p pd=45.3u as=9.7724p ps=45.3u w=22.21u l=8u
X106 vbp_bias.t12 vbp_bias.t11 avdd.t146 avdd.t145 pfet_03v3 ad=8.3864p pd=39u as=8.3864p ps=39u w=19.06u l=8u
X107 vref.t8 avss cap_mim_2f0fF c_width=70.7u c_length=70.7u
X108 rbit3top.t5 b3.t2 rbit4top.t3 dvss nfet_03v3 ad=4.4p pd=20.88u as=4.4p ps=20.88u w=10u l=0.28u
X109 vx2.t10 psrg_m3_feed.t20 avdd.t152 avdd.t151 pfet_05v0 ad=7.37p pd=34.38u as=7.37p ps=34.38u w=16.75u l=2u
X110 vx3.t10 psrg_m3_feed.t11 avdd.t123 avdd.t122 pfet_05v0 ad=7.37p pd=34.38u as=7.37p ps=34.38u w=16.75u l=2u
X111 y1.t2 vbp_cas.t23 pm1.t2 avdd.t95 pfet_05v0 ad=9.7724p pd=45.3u as=9.7724p ps=45.3u w=22.21u l=8u
X112 bgsu1 bgsu1 bgsu2 avss nfet_03v3 ad=0.44p pd=2.88u as=0.44p ps=2.88u w=1u l=2u
X113 vbp_cas.t2 vbp_cas.t1 vbp_bias.t19 avdd.t134 pfet_05v0 ad=8.3292p pd=38.74u as=8.3292p ps=38.74u w=18.93u l=8u
X114 rbit1top.t4 b0_b.t7 rbit0top.t2 dvdd.t13 pfet_03v3 ad=17.6p pd=80.88u as=17.6p ps=80.88u w=40u l=0.28u
X115 rbit1top.t7 b0_b.t4 rbit0top.t3 dvdd.t1 pfet_03v3 ad=17.6p pd=80.88u as=17.6p ps=80.88u w=40u l=0.28u
X116 vref.t12 avss cap_mim_2f0fF c_width=70.7u c_length=70.7u
X117 xf2.t2 v2.t3 vsp.t4 avdd.t82 pfet_05v0 ad=24.1516p pd=0.11066m as=24.1516p ps=0.11066m w=54.89u l=4u
X118 b3_b.t0 b3.t1 dvss dvss nfet_03v3 ad=0.44p pd=2.88u as=0.44p ps=2.88u w=1u l=0.5u
X119 y1.t5 vbp_cas.t27 pm1.t5 avdd.t172 pfet_05v0 ad=9.7724p pd=45.3u as=9.7724p ps=45.3u w=22.21u l=8u
X120 xf1.t3 vbn_sink.t22 avss avss nfet_05v0 ad=7.1896p pd=33.56u as=7.1896p ps=33.56u w=16.34u l=8u
X121 xf1.t5 vbn_sink.t31 avss avss nfet_05v0 ad=7.1896p pd=33.56u as=7.1896p ps=33.56u w=16.34u l=8u
X122 vbn_sink.t20 vbp_i.t29 avdd.t236 avdd.t235 pfet_05v0 ad=8.338p pd=38.78u as=8.338p ps=38.78u w=18.95u l=8u
X123 vx2.t0 psrg_m3_feed.t9 avdd.t14 avdd.t13 pfet_05v0 ad=7.37p pd=34.38u as=7.37p ps=34.38u w=16.75u l=2u
X124 vgn1.t6 vgn1.t5 v1.t0 avss nfet_05v0 ad=6.424p pd=30.08u as=6.424p ps=30.08u w=14.6u l=4u
X125 vbp_i.t2 vbp_i.t1 avdd.t244 avdd.t243 pfet_05v0 ad=8.25p pd=38.38u as=8.25p ps=38.38u w=18.75u l=8u
X126 iref_gate.t0 vbp_i.t36 avdd.t6 avdd.t5 pfet_05v0 ad=35.2p pd=0.16088m as=35.2p ps=0.16088m w=80u l=1u
X127 vsp.t10 vbp_tail.t11 avdd.t138 avdd.t137 pfet_03v3 ad=12.7204p pd=58.7u as=12.7204p ps=58.7u w=28.91u l=6u
X128 su_state.t2 vgn2.t8 avss avss nfet_05v0 ad=1.76p pd=8.88u as=1.76p ps=8.88u w=4u l=1u
X129 b5_b.t0 b5.t2 dvss dvss nfet_03v3 ad=0.44p pd=2.88u as=0.44p ps=2.88u w=1u l=0.5u
X130 b6_b.t1 b6.t0 dvdd.t29 dvdd.t28 pfet_03v3 ad=1.32p pd=6.88u as=1.32p ps=6.88u w=3u l=0.5u
X131 psrg_m3_feed.t3 vcasp vx2.t5 avdd.t50 pfet_05v0 ad=7.2248p pd=33.72u as=7.2248p ps=33.72u w=16.42u l=4u
X132 vbn_sink.t9 vbp_i.t43 avdd.t148 avdd.t147 pfet_05v0 ad=8.338p pd=38.78u as=8.338p ps=38.78u w=18.95u l=8u
X133 psrg_m3_feed.t5 psrg_vnc.t11 psrg_m3_protected.t3 avss nfet_05v0 ad=6.424p pd=30.08u as=6.424p ps=30.08u w=14.6u l=4u
X134 pm1.t10 y1.t9 avdd.t250 avdd.t249 pfet_05v0 ad=9.1344p pd=42.4u as=9.1344p ps=42.4u w=20.76u l=4u
X135 vbn_sink.t12 vbp_i.t30 avdd.t169 avdd.t168 pfet_05v0 ad=8.338p pd=38.78u as=8.338p ps=38.78u w=18.95u l=8u
X136 vbp_tail.t5 vbp_tail.t4 avdd.t177 avdd.t176 pfet_03v3 ad=6.05p pd=28.38u as=6.05p ps=28.38u w=13.75u l=6u
X137 vbn_fold.t2 vbp_i.t20 avdd.t56 avdd.t55 pfet_05v0 ad=8.3556p pd=38.86u as=8.3556p ps=38.86u w=18.99u l=8u
X138 vbn_sink.t17 vbp_i.t44 avdd.t220 avdd.t219 pfet_05v0 ad=8.338p pd=38.78u as=8.338p ps=38.78u w=18.95u l=8u
X139 xf2.t11 vbn_sink.t25 avss avss nfet_05v0 ad=7.1896p pd=33.56u as=7.1896p ps=33.56u w=16.34u l=8u
X140 vbn_sink.t13 vbp_i.t31 avdd.t171 avdd.t170 pfet_05v0 ad=8.338p pd=38.78u as=8.338p ps=38.78u w=18.95u l=8u
X141 b1_b.t1 b1.t2 dvdd.t15 dvdd.t14 pfet_03v3 ad=1.32p pd=6.88u as=1.32p ps=6.88u w=3u l=0.5u
X142 vq3.t1 b6_b.t2 rbit6top.t3 dvdd.t21 pfet_03v3 ad=1.65p pd=8.38u as=1.65p ps=8.38u w=3.75u l=0.28u
X143 vq3.t0 rbit6top.t2 avss ppolyf_u_1k r_width=6.6u r_length=0.128m
X144 psrg_vnc.t7 vbp_i.t48 avdd.t252 avdd.t251 pfet_05v0 ad=7.8056p pd=36.36u as=7.8056p ps=36.36u w=17.74u l=4u
X145 y1.t4 vbp_cas.t31 pm1.t4 avdd.t166 pfet_05v0 ad=9.7724p pd=45.3u as=9.7724p ps=45.3u w=22.21u l=8u
X146 rbit3top.t2 b2_b.t4 rbit2top.t2 dvdd.t8 pfet_03v3 ad=8.8p pd=40.88u as=8.8p ps=40.88u w=20u l=0.28u
X147 vgn2.t0 vbn_fold.t15 xf2.t9 avss nfet_05v0 ad=8.1356p pd=37.86u as=8.1356p ps=37.86u w=18.49u l=6u
X148 vgn2.t1 vbp_cas.t24 pm2.t0 avdd.t21 pfet_05v0 ad=9.7724p pd=45.3u as=9.7724p ps=45.3u w=22.21u l=8u
X149 vbn_i.t4 vbp_i.t39 avdd.t158 avdd.t157 pfet_05v0 ad=8.25p pd=38.38u as=8.25p ps=38.38u w=18.75u l=8u
X150 vbp_tail.t3 vbp_tail.t2 avdd.t133 avdd.t132 pfet_03v3 ad=6.05p pd=28.38u as=6.05p ps=28.38u w=13.75u l=6u
X151 vbp_i.t6 vbp_i.t5 avdd.t113 avdd.t112 pfet_05v0 ad=8.25p pd=38.38u as=8.25p ps=38.38u w=18.75u l=8u
X152 vbn.t0 vcasp vaux.t0 avdd.t53 pfet_05v0 ad=7.04p pd=32.88u as=7.04p ps=32.88u w=16u l=4u
X153 vsua vcasp avdd.t35 avdd.t34 pfet_05v0 ad=0.88p pd=4.88u as=0.88p ps=4.88u w=2u l=2u
X154 rbit2top.t9 b2.t2 rbit3top.t7 dvss nfet_03v3 ad=8.8p pd=40.88u as=8.8p ps=40.88u w=20u l=0.28u
X155 pm2.t6 y1.t18 avdd.t232 avdd.t231 pfet_05v0 ad=9.1344p pd=42.4u as=9.1344p ps=42.4u w=20.76u l=4u
X156 vx2.t9 psrg_m3_feed.t28 avdd.t150 avdd.t149 pfet_05v0 ad=7.37p pd=34.38u as=7.37p ps=34.38u w=16.75u l=2u
X157 vsp.t9 vbp_tail.t10 avdd.t136 avdd.t135 pfet_03v3 ad=12.7204p pd=58.7u as=12.7204p ps=58.7u w=28.91u l=6u
X158 rbit5top.t4 b5.t1 rbit6top.t4 dvss nfet_03v3 ad=1.1p pd=5.88u as=1.1p ps=5.88u w=2.5u l=0.28u
X159 rbit1top.t0 rbit0top.t0 avss ppolyf_u_1k r_width=6.6u r_length=2u
X160 vx1.t10 psrg_m3_feed.t10 avdd.t121 avdd.t120 pfet_05v0 ad=7.37p pd=34.38u as=7.37p ps=34.38u w=16.75u l=2u
X161 vx1.t1 psrg_m3_feed.t19 avdd.t31 avdd.t30 pfet_05v0 ad=7.37p pd=34.38u as=7.37p ps=34.38u w=16.75u l=2u
X162 vaux.t1 psrg_m3_feed.t22 avdd.t97 avdd.t96 pfet_05v0 ad=4.4p pd=20.88u as=4.4p ps=20.88u w=10u l=2u
X163 vsp.t12 vbp_tail.t8 avdd.t215 avdd.t214 pfet_03v3 ad=12.7204p pd=58.7u as=12.7204p ps=58.7u w=28.91u l=6u
X164 b4_b.t1 b4.t0 dvdd.t17 dvdd.t16 pfet_03v3 ad=1.32p pd=6.88u as=1.32p ps=6.88u w=3u l=0.5u
X165 vbn_sink.t18 vbp_i.t45 avdd.t222 avdd.t221 pfet_05v0 ad=8.338p pd=38.78u as=8.338p ps=38.78u w=18.95u l=8u
X166 vbn_sink.t0 vbp_i.t32 avdd.t84 avdd.t83 pfet_05v0 ad=8.338p pd=38.78u as=8.338p ps=38.78u w=18.95u l=8u
X167 rbit2top.t5 b1_b.t2 rbit1top.t2 dvdd.t10 pfet_03v3 ad=17.6p pd=80.88u as=17.6p ps=80.88u w=40u l=0.28u
X168 pm1.t11 y1.t8 avdd.t211 avdd.t210 pfet_05v0 ad=9.1344p pd=42.4u as=9.1344p ps=42.4u w=20.76u l=4u
X169 pm2.t8 y1.t14 avdd.t238 avdd.t237 pfet_05v0 ad=9.1344p pd=42.4u as=9.1344p ps=42.4u w=20.76u l=4u
X170 vbn_sink.t15 vbp_i.t46 avdd.t197 avdd.t196 pfet_05v0 ad=8.338p pd=38.78u as=8.338p ps=38.78u w=18.95u l=8u
X171 vbp_bias.t10 vbp_bias.t9 avdd.t209 avdd.t208 pfet_03v3 ad=8.3864p pd=39u as=8.3864p ps=39u w=19.06u l=8u
X172 vbn_fold.t4 vbp_i.t13 avdd.t60 avdd.t59 pfet_05v0 ad=8.3556p pd=38.86u as=8.3556p ps=38.86u w=18.99u l=8u
X173 vbn_sink.t1 vbp_i.t33 avdd.t86 avdd.t85 pfet_05v0 ad=8.338p pd=38.78u as=8.338p ps=38.78u w=18.95u l=8u
X174 b1_b.t0 b1.t1 dvss dvss nfet_03v3 ad=0.44p pd=2.88u as=0.44p ps=2.88u w=1u l=0.5u
X175 vgn2.t4 vbp_cas.t32 pm2.t3 avdd.t167 pfet_05v0 ad=9.7724p pd=45.3u as=9.7724p ps=45.3u w=22.21u l=8u
X176 xf1.t4 vbn_sink.t30 avss avss nfet_05v0 ad=7.1896p pd=33.56u as=7.1896p ps=33.56u w=16.34u l=8u
X177 rbit1top.t10 b1.t0 rbit2top.t7 dvss nfet_03v3 ad=17.6p pd=80.88u as=17.6p ps=80.88u w=40u l=0.28u
X178 vq2 v2.t0 avss ppolyf_u_1k r_width=4u r_length=42.1u
X179 psrg_m3_feed.t1 vcasp vx2.t1 avdd.t40 pfet_05v0 ad=7.2248p pd=33.72u as=7.2248p ps=33.72u w=16.42u l=4u
X180 b4_b.t0 b4.t1 dvss dvss nfet_03v3 ad=0.44p pd=2.88u as=0.44p ps=2.88u w=1u l=0.5u
X181 xf2.t1 v2.t6 vsp.t3 avdd.t54 pfet_05v0 ad=24.1516p pd=0.11066m as=24.1516p ps=0.11066m w=54.89u l=4u
X182 pm2.t10 y1.t10 avdd.t70 avdd.t69 pfet_05v0 ad=9.1344p pd=42.4u as=9.1344p ps=42.4u w=20.76u l=4u
X183 vref.t0 vcasp vx3.t6 avdd.t52 pfet_05v0 ad=7.2248p pd=33.72u as=7.2248p ps=33.72u w=16.42u l=4u
X184 vref.t10 avss cap_mim_2f0fF c_width=70.7u c_length=70.7u
X185 vref.t11 avss cap_mim_2f0fF c_width=70.7u c_length=70.7u
X186 vgn1.t4 vcasp vx1.t4 avdd.t45 pfet_05v0 ad=7.2248p pd=33.72u as=7.2248p ps=33.72u w=16.42u l=4u
X187 vbn_i.t7 iref_gate.t3 avdd.t248 avdd.t247 pfet_05v0 ad=0.22p pd=1.88u as=0.22p ps=1.88u w=0.5u l=8u
X188 vnx_bias vnx_bias avss avss nfet_03v3 ad=0.7128p pd=4.12u as=0.7128p ps=4.12u w=1.62u l=8u
X189 xf2.t10 vbn_sink.t24 avss avss nfet_05v0 ad=7.1896p pd=33.56u as=7.1896p ps=33.56u w=16.34u l=8u
X190 xf1.t9 v1.t5 vsp.t13 avdd.t216 pfet_05v0 ad=24.1516p pd=0.11066m as=24.1516p ps=0.11066m w=54.89u l=4u
X191 vbp_i.t0 vbn_i.t11 net4 avss nfet_05v0 ad=4.0172p pd=19.14u as=4.0172p ps=19.14u w=9.13u l=8u
X192 pm1.t6 y1.t17 avdd.t230 avdd.t229 pfet_05v0 ad=9.1344p pd=42.4u as=9.1344p ps=42.4u w=20.76u l=4u
X193 iref_gate.t2 vbp_i.t35 avdd.t185 avdd.t184 pfet_05v0 ad=35.2p pd=0.16088m as=35.2p ps=0.16088m w=80u l=1u
X194 xf2.t3 v2.t7 vsp.t6 avdd.t109 pfet_05v0 ad=24.1516p pd=0.11066m as=24.1516p ps=0.11066m w=54.89u l=4u
X195 rbit1top.t6 b0_b.t5 rbit0top.t5 dvdd.t3 pfet_03v3 ad=17.6p pd=80.88u as=17.6p ps=80.88u w=40u l=0.28u
X196 bgsu2 bgsu2 avss avss nfet_03v3 ad=0.44p pd=2.88u as=0.44p ps=2.88u w=1u l=2u
X197 vbn_i.t3 vbp_i.t38 avdd.t156 avdd.t155 pfet_05v0 ad=8.25p pd=38.38u as=8.25p ps=38.38u w=18.75u l=8u
X198 b0_b.t0 b0.t0 dvss dvss nfet_03v3 ad=0.44p pd=2.88u as=0.44p ps=2.88u w=1u l=0.5u
X199 rbit6top.t5 b6.t1 vq3.t2 dvss nfet_03v3 ad=0.55p pd=3.38u as=0.55p ps=3.38u w=1.25u l=0.28u
X200 psrg_vnc.t3 vbp_i.t53 avdd.t68 avdd.t67 pfet_05v0 ad=7.8056p pd=36.36u as=7.8056p ps=36.36u w=17.74u l=4u
X201 vbn_fold.t8 vbp_i.t22 avdd.t102 avdd.t101 pfet_05v0 ad=8.3556p pd=38.86u as=8.3556p ps=38.86u w=18.99u l=8u
X202 auxsu1 auxsu1 auxsu2 avss nfet_03v3 ad=0.44p pd=2.88u as=0.44p ps=2.88u w=1u l=2u
X203 psrg_m3_protected.t0 vgn2.t10 v2.t1 avss nfet_05v0 ad=6.424p pd=30.08u as=6.424p ps=30.08u w=14.6u l=4u
X204 vbn_fold.t13 vbp_i.t15 avdd.t203 avdd.t202 pfet_05v0 ad=8.3556p pd=38.86u as=8.3556p ps=38.86u w=18.99u l=8u
X205 aux_gate vbn_i.t8 avss avss nfet_05v0 ad=0.44p pd=2.88u as=0.44p ps=2.88u w=1u l=8u
X206 vsu1 vbp_i.t56 vsu2 avss nfet_05v0 ad=0.22p pd=1.88u as=0.22p ps=1.88u w=0.5u l=50u
X207 vgn1.t1 vcasp vx1.t6 avdd.t49 pfet_05v0 ad=7.2248p pd=33.72u as=7.2248p ps=33.72u w=16.42u l=4u
X208 vbp_cas.t0 vbn_i.t9 avss avss nfet_05v0 ad=0.286p pd=2.18u as=0.286p ps=2.18u w=0.65u l=8u
X209 pm2.t11 y1.t7 avdd.t187 avdd.t186 pfet_05v0 ad=9.1344p pd=42.4u as=9.1344p ps=42.4u w=20.76u l=4u
X210 vx1.t0 psrg_m3_feed.t27 avdd.t27 avdd.t26 pfet_05v0 ad=7.37p pd=34.38u as=7.37p ps=34.38u w=16.75u l=2u
X211 b6_b.t0 b6.t2 dvss dvss nfet_03v3 ad=0.44p pd=2.88u as=0.44p ps=2.88u w=1u l=0.5u
X212 psrg_mf1_protected.t1 vbn_fold.t14 xf1.t8 avss nfet_05v0 ad=8.1356p pd=37.86u as=8.1356p ps=37.86u w=18.49u l=6u
X213 vbn.t3 aux_gate avdd.t261 avdd.t260 pfet_05v0 ad=0.22p pd=1.88u as=0.22p ps=1.88u w=0.5u l=8u
X214 vsu2 vbp_i.t55 avss avss nfet_05v0 ad=0.22p pd=1.88u as=0.22p ps=1.88u w=0.5u l=50u
X215 vx3.t1 psrg_m3_feed.t18 avdd.t29 avdd.t28 pfet_05v0 ad=7.37p pd=34.38u as=7.37p ps=34.38u w=16.75u l=2u
X216 vgn2.t5 vbp_cas.t28 pm2.t4 avdd.t173 pfet_05v0 ad=9.7724p pd=45.3u as=9.7724p ps=45.3u w=22.21u l=8u
X217 vbp_bias.t18 vbp_bias.t17 avdd.t129 avdd.t128 pfet_03v3 ad=8.3864p pd=39u as=8.3864p ps=39u w=19.06u l=8u
X218 vcasp vbn.t4 avss avss nfet_05v0 ad=3.322p pd=15.98u as=3.322p ps=15.98u w=7.55u l=4u
X219 avss net3 avdd.t75 pplus_u r_width=1u r_length=0.23253m
X220 vgn1.t9 aux_gate psrg_m3_feed.t7 avdd.t259 pfet_05v0 ad=0.88p pd=4.88u as=0.88p ps=4.88u w=2u l=2u
X221 vcasp vcasp avdd.t33 avdd.t32 pfet_05v0 ad=0.396p pd=2.68u as=0.396p ps=2.68u w=0.9u l=2u
X222 psrg_vnc.t8 vbp_i.t49 avdd.t254 avdd.t253 pfet_05v0 ad=7.8056p pd=36.36u as=7.8056p ps=36.36u w=17.74u l=4u
X223 vsp.t11 vbp_tail.t12 avdd.t140 avdd.t139 pfet_03v3 ad=12.7204p pd=58.7u as=12.7204p ps=58.7u w=28.91u l=6u
X224 b2_b.t0 b2.t1 dvss dvss nfet_03v3 ad=0.44p pd=2.88u as=0.44p ps=2.88u w=1u l=0.5u
X225 vgn2.t6 vbp_cas.t29 pm2.t5 avdd.t174 pfet_05v0 ad=9.7724p pd=45.3u as=9.7724p ps=45.3u w=22.21u l=8u
X226 vbn_i.t1 vbn_i.t0 avss avss nfet_05v0 ad=3.4232p pd=16.44u as=3.4232p ps=16.44u w=7.78u l=8u
X227 vbp_bias.t14 vbp_bias.t13 avdd.t226 avdd.t225 pfet_03v3 ad=8.3864p pd=39u as=8.3864p ps=39u w=19.06u l=8u
X228 rbit3top.t4 b2_b.t2 rbit2top.t0 dvdd.t2 pfet_03v3 ad=8.8p pd=40.88u as=8.8p ps=40.88u w=20u l=0.28u
X229 rbit5top.t1 rbit4top.t0 avss ppolyf_u_1k r_width=6.6u r_length=32u
X230 vbn_i.t2 vbp_i.t37 avdd.t8 avdd.t7 pfet_05v0 ad=8.25p pd=38.38u as=8.25p ps=38.38u w=18.75u l=8u
X231 auxsu2 auxsu2 avss avss nfet_03v3 ad=0.44p pd=2.88u as=0.44p ps=2.88u w=1u l=2u
X232 vbn_sink.t19 vbp_i.t28 avdd.t234 avdd.t233 pfet_05v0 ad=8.338p pd=38.78u as=8.338p ps=38.78u w=18.95u l=8u
X233 vbn_sink.t6 vbn_sink.t5 avss avss nfet_05v0 ad=5.4164p pd=25.5u as=5.4164p ps=25.5u w=12.31u l=8u
X234 vgn1.t8 vgn1.t7 v1.t1 avss nfet_05v0 ad=6.424p pd=30.08u as=6.424p ps=30.08u w=14.6u l=4u
X235 b0_b.t1 b0.t1 dvdd.t27 dvdd.t26 pfet_03v3 ad=1.32p pd=6.88u as=1.32p ps=6.88u w=3u l=0.5u
X236 rbit2top.t8 rbit1top.t11 avss ppolyf_u_1k r_width=6.6u r_length=4u
X237 vref.t9 avss cap_mim_2f0fF c_width=70.7u c_length=70.7u
X238 vbn_fold.t7 vbp_i.t12 avdd.t92 avdd.t91 pfet_05v0 ad=8.3556p pd=38.86u as=8.3556p ps=38.86u w=18.99u l=8u
X239 vref.t13 avss cap_mim_2f0fF c_width=70.7u c_length=70.7u
X240 xf1.t0 v1.t4 vsp.t1 avdd.t15 pfet_05v0 ad=24.1516p pd=0.11066m as=24.1516p ps=0.11066m w=54.89u l=4u
X241 psrg_m3_feed.t4 vcasp vx2.t3 avdd.t51 pfet_05v0 ad=7.2248p pd=33.72u as=7.2248p ps=33.72u w=16.42u l=4u
X242 rbit1top.t9 b0_b.t2 rbit0top.t4 dvdd.t20 pfet_03v3 ad=17.6p pd=80.88u as=17.6p ps=80.88u w=40u l=0.28u
X243 vgn1.t3 vcasp vx1.t3 avdd.t42 pfet_05v0 ad=7.2248p pd=33.72u as=7.2248p ps=33.72u w=16.42u l=4u
X244 vsua vsua auxsu1 avss nfet_05v0 ad=0.44p pd=2.88u as=0.44p ps=2.88u w=1u l=2u
X245 xf1.t1 v1.t6 vsp.t2 avdd.t16 pfet_05v0 ad=24.1516p pd=0.11066m as=24.1516p ps=0.11066m w=54.89u l=4u
X246 vx3.t7 psrg_m3_feed.t17 avdd.t64 avdd.t63 pfet_05v0 ad=7.37p pd=34.38u as=7.37p ps=34.38u w=16.75u l=2u
X247 psrg_vnc.t2 vbp_i.t52 avdd.t66 avdd.t65 pfet_05v0 ad=7.8056p pd=36.36u as=7.8056p ps=36.36u w=17.74u l=4u
X248 rbit1top.t5 b0_b.t6 rbit0top.t1 dvdd.t7 pfet_03v3 ad=17.6p pd=80.88u as=17.6p ps=80.88u w=40u l=0.28u
X249 vref.t3 vcasp vx3.t5 avdd.t47 pfet_05v0 ad=7.2248p pd=33.72u as=7.2248p ps=33.72u w=16.42u l=4u
X250 psrg_m3_protected.t2 vgn2.t9 v2.t2 avss nfet_05v0 ad=6.424p pd=30.08u as=6.424p ps=30.08u w=14.6u l=4u
X251 rbit2top.t4 b1_b.t3 rbit1top.t3 dvdd.t12 pfet_03v3 ad=17.6p pd=80.88u as=17.6p ps=80.88u w=40u l=0.28u
X252 psrg_vnc.t6 vbp_i.t54 avdd.t205 avdd.t204 pfet_05v0 ad=7.8056p pd=36.36u as=7.8056p ps=36.36u w=17.74u l=4u
X253 vbn_fold.t6 vbp_i.t17 avdd.t90 avdd.t89 pfet_05v0 ad=8.3556p pd=38.86u as=8.3556p ps=38.86u w=18.99u l=8u
X254 vx2.t8 psrg_m3_feed.t15 avdd.t119 avdd.t118 pfet_05v0 ad=7.37p pd=34.38u as=7.37p ps=34.38u w=16.75u l=2u
X255 pm2.t7 y1.t15 avdd.t240 avdd.t239 pfet_05v0 ad=9.1344p pd=42.4u as=9.1344p ps=42.4u w=20.76u l=4u
X256 vbp_cas.t20 vbp_cas.t19 vbp_bias.t27 avdd.t256 pfet_05v0 ad=8.3292p pd=38.74u as=8.3292p ps=38.74u w=18.93u l=8u
X257 vbn_sink.t2 vbp_i.t23 avdd.t104 avdd.t103 pfet_05v0 ad=8.338p pd=38.78u as=8.338p ps=38.78u w=18.95u l=8u
X258 y1.t3 vbp_cas.t30 pm1.t3 avdd.t165 pfet_05v0 ad=9.7724p pd=45.3u as=9.7724p ps=45.3u w=22.21u l=8u
X259 rbit0top.t8 b0.t3 rbit1top.t12 dvss nfet_03v3 ad=17.6p pd=80.88u as=17.6p ps=80.88u w=40u l=0.28u
X260 vgn1.t0 vcasp vx1.t5 avdd.t48 pfet_05v0 ad=7.2248p pd=33.72u as=7.2248p ps=33.72u w=16.42u l=4u
R0 vref.n6 vref.n5 54.8555
R1 vref vref.n14 53.933
R2 vref.n11 vref.t12 34.6185
R3 vref.n13 vref.t11 34.6113
R4 vref.n9 vref.t13 34.6062
R5 vref.n0 vref.t14 26.519
R6 vref.n6 vref.n0 25.385
R7 vref.n1 vref.t0 18.6289
R8 vref.n5 vref.n4 18.4955
R9 vref.n8 vref.n7 17.2532
R10 vref.n3 vref.t2 15.7039
R11 vref.n1 vref.t3 13.8139
R12 vref.n2 vref.n1 10.4855
R13 vref.n5 vref.t5 10.0775
R14 vref.n2 vref.t1 9.27598
R15 vref.n4 vref.t4 9.27277
R16 vref.n0 vref.t15 9.22104
R17 vref.n7 vref.t10 9.22104
R18 vref.n8 vref.t9 9.22104
R19 vref.n10 vref.t8 9.22104
R20 vref.n12 vref.t7 9.22104
R21 vref.n14 vref.t6 9.22104
R22 vref.n4 vref.n3 9.1355
R23 vref.n9 vref.n8 9.08246
R24 vref.n11 vref.n10 9.01336
R25 vref.n13 vref.n12 8.98764
R26 vref.n14 vref.n13 8.303
R27 vref.n7 vref.n6 8.2805
R28 vref.n12 vref.n11 8.24996
R29 vref.n10 vref.n9 8.20496
R30 vref.n3 vref.n2 4.6355
R31 b1.n1 b1.t0 553.995
R32 b1.n0 b1.t2 52.3518
R33 b1.n0 b1.t1 34.9128
R34 b1 b1.n1 34.0655
R35 b1.n1 b1.n0 8.7305
R36 b2.n0 b2.t2 299.99
R37 b2.n1 b2.t0 44.8554
R38 b2.n0 b2.t1 30.7964
R39 b2 b2.n1 27.8105
R40 b2.n1 b2.n0 23.4005
R41 b6 b6.n1 46.0805
R42 b6.n1 b6.t0 44.9115
R43 b6.n0 b6.t2 44.5322
R44 b6.n0 b6.t1 42.8627
R45 b6.n1 b6.n0 11.8355
R46 b5.n0 b5.t1 63.7544
R47 b5.n0 b5.t2 49.1564
R48 b5.n1 b5.t0 45.1489
R49 b5 b5.n1 37.0805
R50 b5.n1 b5.n0 6.2105
R51 b0.n0 b0.t3 557.883
R52 b0.n0 b0.t2 547.923
R53 b0.n1 b0.t1 44.9587
R54 b0 b0.n2 44.2355
R55 b0.n2 b0.t0 37.0514
R56 b0.n1 b0.n0 19.4405
R57 b0.n2 b0.n1 8.9555
R58 b4.n0 b4.t2 109.124
R59 b4.n1 b4.t0 49.3969
R60 b4 b4.n1 41.0855
R61 b4.n0 b4.t1 35.1074
R62 b4.n1 b4.n0 25.2455
R63 b3.n0 b3.t2 178.858
R64 b3.n1 b3.t0 44.8894
R65 b3 b3.n1 38.0705
R66 b3.n0 b3.t1 37.0593
R67 b3.n1 b3.n0 17.2355
R68 avdd.n56 avdd.t36 770.683
R69 avdd.n160 avdd.t247 648.068
R70 avdd.n163 avdd.t260 648.035
R71 avdd.n158 avdd.t17 582.449
R72 avdd.n166 avdd.t1 577.782
R73 avdd.n49 avdd.t32 243.499
R74 avdd.n293 avdd.t257 202.047
R75 avdd.n159 avdd.t259 200.303
R76 avdd.n325 avdd.t34 197.447
R77 avdd.n126 avdd.t200 139.305
R78 avdd.n127 avdd.t87 139.125
R79 avdd.n178 avdd.t202 134.719
R80 avdd.n105 avdd.t132 131.555
R81 avdd.n287 avdd.t3 131.519
R82 avdd.n106 avdd.t176 131.492
R83 avdd.n122 avdd.t114 130.624
R84 avdd.n185 avdd.t101 130.395
R85 avdd.n123 avdd.t59 129.543
R86 avdd.n363 avdd.t112 128.993
R87 avdd.n367 avdd.t192 128.993
R88 avdd.n372 avdd.t194 128.993
R89 avdd.n360 avdd.t157 128.993
R90 avdd.n356 avdd.t19 128.993
R91 avdd.n351 avdd.t7 128.993
R92 avdd.n364 avdd.t110 128.962
R93 avdd.n97 avdd.t243 128.962
R94 avdd.n358 avdd.t155 128.962
R95 avdd.n353 avdd.t212 128.962
R96 avdd.n231 avdd.t198 128.25
R97 avdd.n46 avdd.t182 128.185
R98 avdd.n131 avdd.t246 128.081
R99 avdd.n154 avdd.t189 128.081
R100 avdd.n152 avdd.t125 128.081
R101 avdd.n228 avdd.t245 128.043
R102 avdd.n226 avdd.t175 128.043
R103 avdd.n155 avdd.t256 128.02
R104 avdd.n153 avdd.t188 128.02
R105 avdd.n217 avdd.t233 128.012
R106 avdd.n146 avdd.t141 128.012
R107 avdd.n138 avdd.t159 128.012
R108 avdd.n252 avdd.t168 128.005
R109 avdd.n256 avdd.t83 128.005
R110 avdd.n244 avdd.t147 127.98
R111 avdd.n240 avdd.t221 127.98
R112 avdd.n133 avdd.t103 127.98
R113 avdd.n136 avdd.t143 127.98
R114 avdd.n253 avdd.t170 127.974
R115 avdd.n117 avdd.t85 127.974
R116 avdd.n243 avdd.t219 127.942
R117 avdd.n86 avdd.t128 127.885
R118 avdd.n122 avdd.t91 127.785
R119 avdd.n176 avdd.t55 127.785
R120 avdd.n180 avdd.t57 127.727
R121 avdd.n171 avdd.t107 127.727
R122 avdd.n376 avdd.t190 127.188
R123 avdd.n87 avdd.t126 127.169
R124 avdd.n10 avdd.t208 127.151
R125 avdd.n2 avdd.t206 127.151
R126 avdd.n381 avdd.t227 127.118
R127 avdd.n93 avdd.t145 127.102
R128 avdd.n88 avdd.t225 127.102
R129 avdd.n227 avdd.t223 123.581
R130 avdd.n225 avdd.t134 123.581
R131 avdd.n151 avdd.t224 123.52
R132 avdd.n119 avdd.t161 123.48
R133 avdd.n249 avdd.t235 123.474
R134 avdd.n232 avdd.t196 123.442
R135 avdd.n169 avdd.t105 123.285
R136 avdd.n168 avdd.t89 123.227
R137 avdd.n384 avdd.t80 122.688
R138 avdd.n111 avdd.t93 121.54
R139 avdd.n267 avdd.t172 114.653
R140 avdd.n279 avdd.t22 114.159
R141 avdd.n113 avdd.t95 114.159
R142 avdd.n115 avdd.t166 114.147
R143 avdd.n109 avdd.t23 114.127
R144 avdd.n114 avdd.t21 114.127
R145 avdd.n266 avdd.t173 114.088
R146 avdd.n264 avdd.t165 114.088
R147 avdd.n277 avdd.t167 114.088
R148 avdd.n265 avdd.t174 109.647
R149 avdd.n111 avdd.t94 109.627
R150 avdd.n247 avdd.t53 92.712
R151 avdd.n318 avdd.t49 91.1774
R152 avdd.n312 avdd.t51 91.1774
R153 avdd.n399 avdd.t44 91.1774
R154 avdd.n424 avdd.t39 91.1774
R155 avdd.n429 avdd.t42 91.1297
R156 avdd.n425 avdd.t40 91.1297
R157 avdd.n62 avdd.t38 91.1297
R158 avdd.n317 avdd.t48 91.1225
R159 avdd.n319 avdd.t50 91.1225
R160 avdd.n51 avdd.t153 89.0865
R161 avdd.n394 avdd.t46 86.6774
R162 avdd.n60 avdd.t41 86.6774
R163 avdd.n29 avdd.t67 86.6575
R164 avdd.n274 avdd.t251 86.644
R165 avdd.n272 avdd.t9 86.644
R166 avdd.n58 avdd.t47 86.6261
R167 avdd.n397 avdd.t45 86.6261
R168 avdd.n391 avdd.t43 86.6261
R169 avdd.n323 avdd.t52 86.6225
R170 avdd.n273 avdd.t253 86.6125
R171 avdd.n430 avdd.t204 86.5945
R172 avdd.n53 avdd.t96 85.7565
R173 avdd.n57 avdd.t65 82.144
R174 avdd.n270 avdd.t11 82.1125
R175 avdd.n307 avdd.t180 80.126
R176 avdd.n329 avdd.t231 79.5545
R177 avdd.n349 avdd.t130 78.7294
R178 avdd.n296 avdd.t217 78.7114
R179 avdd.n297 avdd.t135 78.7024
R180 avdd.n298 avdd.t137 78.6817
R181 avdd.n103 avdd.t214 78.6784
R182 avdd.n102 avdd.t139 78.6732
R183 avdd.n308 avdd.t239 78.146
R184 avdd.n330 avdd.t229 78.146
R185 avdd.n301 avdd.t186 78.1168
R186 avdd.n344 avdd.t249 78.1168
R187 avdd.n307 avdd.t237 78.1145
R188 avdd.n304 avdd.t178 78.0547
R189 avdd.n345 avdd.t210 78.0547
R190 avdd.n341 avdd.t163 73.6168
R191 avdd.n331 avdd.t241 73.6145
R192 avdd.n342 avdd.t69 73.5547
R193 avdd.n409 avdd.t28 65.028
R194 avdd.n408 avdd.t63 65.028
R195 avdd.n407 avdd.t61 65.028
R196 avdd.n389 avdd.t116 64.9641
R197 avdd.n82 avdd.t78 64.9641
R198 avdd.n388 avdd.t76 64.9641
R199 avdd.n81 avdd.t122 64.9641
R200 avdd.n314 avdd.t120 64.9641
R201 avdd.n315 avdd.t13 64.9641
R202 avdd.n420 avdd.t71 64.9569
R203 avdd.n419 avdd.t73 64.9569
R204 avdd.n64 avdd.t24 64.9569
R205 avdd.n416 avdd.t149 62.8419
R206 avdd.n402 avdd.t118 60.528
R207 avdd.n75 avdd.t30 60.528
R208 avdd.n410 avdd.t151 60.528
R209 avdd.n416 avdd.t26 60.4569
R210 avdd.n63 avdd.t98 60.4569
R211 avdd avdd.n50 54.7205
R212 avdd.n198 avdd.t109 45.3505
R213 avdd.n202 avdd.t54 45.3505
R214 avdd.n196 avdd.t15 45.3505
R215 avdd.n207 avdd.t0 45.3505
R216 avdd.n209 avdd.t255 45.3505
R217 avdd.n213 avdd.t82 45.3505
R218 avdd.n201 avdd.t16 45.3082
R219 avdd.n203 avdd.t216 45.3082
R220 avdd.n208 avdd.t124 45.3082
R221 avdd.n194 avdd.t100 45.3082
R222 avdd.n120 avdd.t75 39.2557
R223 avdd.n214 avdd.t184 31.9694
R224 avdd.n214 avdd.t5 30.7859
R225 avdd.n241 avdd.t148 25.7055
R226 avdd.n374 avdd.t193 25.6402
R227 avdd.n164 avdd.t261 22.6651
R228 avdd.n55 avdd.t37 22.4086
R229 avdd.n159 avdd.t248 22.3548
R230 avdd.n89 avdd.t129 21.5447
R231 avdd.n235 avdd.t222 21.2055
R232 avdd.n254 avdd.t169 21.2055
R233 avdd.n365 avdd.t113 21.1402
R234 avdd.n305 avdd.t187 20.5222
R235 avdd.n76 avdd.t14 20.0217
R236 avdd.n8 avdd.n78 19.5755
R237 avdd.n248 avdd.n247 19.3505
R238 avdd.n439 avdd.n6 18.4955
R239 avdd.n49 avdd.t33 18.4294
R240 avdd.n215 avdd.n214 17.9443
R241 avdd.n125 avdd.t115 16.8673
R242 avdd.n303 avdd.t158 16.5502
R243 avdd.n416 avdd.n415 16.4705
R244 avdd.n380 avdd.t228 16.3562
R245 avdd.n135 avdd.t142 16.3005
R246 avdd.n228 avdd.n227 16.2905
R247 avdd.n352 avdd.t8 16.2802
R248 avdd.n357 avdd.t20 16.2802
R249 avdd.n137 avdd.t144 16.2763
R250 avdd.n101 avdd.t213 16.2583
R251 avdd.n224 avdd.t236 16.0722
R252 avdd.n116 avdd.t84 15.8505
R253 avdd.n6 avdd.t252 15.8393
R254 avdd.n324 avdd.t35 15.8275
R255 avdd.n278 avdd.n277 15.3005
R256 avdd.n78 avdd.n77 15.1756
R257 avdd.n405 avdd.t119 14.3056
R258 avdd.n65 avdd.t99 14.2617
R259 avdd.n108 avdd.t4 14.212
R260 avdd.n41 avdd.t207 14.0162
R261 avdd.n39 avdd.t209 14.0027
R262 avdd.n8 avdd.t79 13.9467
R263 avdd.n45 avdd.t203 13.9423
R264 avdd.n43 avdd.t60 13.9423
R265 avdd.n335 avdd.t164 13.9072
R266 avdd.n34 avdd.t31 13.9006
R267 avdd.n44 avdd.t201 13.893
R268 avdd.n33 avdd.t162 13.8913
R269 avdd.n374 avdd.t244 13.8733
R270 avdd.n37 avdd.t136 13.8579
R271 avdd.n310 avdd.t240 13.8558
R272 avdd.n328 avdd.t230 13.8558
R273 avdd.n74 avdd.t29 13.8556
R274 avdd.n414 avdd.t152 13.8556
R275 avdd.n283 avdd.t177 13.848
R276 avdd.n35 avdd.t218 13.8399
R277 avdd.n66 avdd.t72 13.8117
R278 avdd.n42 avdd.t117 13.8117
R279 avdd.n69 avdd.t150 13.8117
R280 avdd.n96 avdd.t195 13.8052
R281 avdd.n38 avdd.t138 13.8022
R282 avdd.n83 avdd.t81 13.8005
R283 avdd.n186 avdd.t102 13.7999
R284 avdd.n6 avdd.t254 13.7976
R285 avdd.n48 avdd.t205 13.7976
R286 avdd.n336 avdd.t179 13.7941
R287 avdd.n378 avdd.t191 13.787
R288 avdd.n24 avdd.t215 13.7819
R289 avdd.n262 avdd.t183 13.7805
R290 avdd.n220 avdd.t234 13.7805
R291 avdd.n236 avdd.t199 13.7805
R292 avdd.n30 avdd.t66 13.7693
R293 avdd.n438 avdd.t10 13.7693
R294 avdd.n327 avdd.t232 13.7604
R295 avdd.n128 avdd.t88 13.758
R296 avdd.n148 avdd.t104 13.7563
R297 avdd.n216 avdd.t185 13.7345
R298 avdd.n304 avdd.n303 13.7255
R299 avdd.n7 avdd.t131 13.7229
R300 avdd.n215 avdd.t6 13.6082
R301 avdd.n158 avdd.t18 13.4369
R302 avdd.n165 avdd.t2 13.435
R303 avdd.n173 avdd.t90 13.03
R304 avdd.n350 avdd.n7 12.3755
R305 avdd.n333 avdd.n332 12.1055
R306 avdd.n375 avdd.n374 11.9705
R307 avdd.n182 avdd.n175 11.9705
R308 avdd.n230 avdd.n116 11.8805
R309 avdd.n169 avdd.n168 11.8805
R310 avdd.n387 avdd.n41 11.7905
R311 avdd.n383 avdd.n39 11.6105
R312 avdd.n219 avdd.n46 11.6105
R313 avdd.n309 avdd.t181 11.3808
R314 avdd.n242 avdd.n241 11.335
R315 avdd.n292 avdd.t258 11.2672
R316 avdd.n306 avdd.n305 11.0705
R317 avdd.n328 avdd.n327 10.9805
R318 avdd.n77 avdd.n76 10.7105
R319 avdd.n426 avdd.n425 10.6205
R320 avdd.n414 avdd.n413 10.4405
R321 avdd.n161 avdd.n160 9.8105
R322 avdd.n50 avdd.t154 9.50051
R323 avdd.n54 avdd.t97 9.50051
R324 avdd.n248 avdd.n225 9.4955
R325 avdd.n91 avdd.t146 9.45774
R326 avdd.n182 avdd.t56 9.43487
R327 avdd.n365 avdd.t111 9.41833
R328 avdd.n284 avdd.t133 9.38192
R329 avdd.n404 avdd.t62 9.3556
R330 avdd.n403 avdd.t64 9.3556
R331 avdd.n183 avdd.t58 9.33997
R332 avdd.n175 avdd.t108 9.33997
R333 avdd.n67 avdd.t74 9.31173
R334 avdd.n72 avdd.t25 9.31173
R335 avdd.n76 avdd.t121 9.31173
R336 avdd.n77 avdd.t123 9.31173
R337 avdd.n68 avdd.t27 9.31173
R338 avdd.n173 avdd.t106 9.29987
R339 avdd.n437 avdd.t12 9.29763
R340 avdd.n433 avdd.t68 9.29763
R341 avdd.n305 avdd.t211 9.2941
R342 avdd.n334 avdd.t70 9.2941
R343 avdd.n89 avdd.t127 9.29299
R344 avdd.n90 avdd.t226 9.28695
R345 avdd.n100 avdd.t156 9.28333
R346 avdd.n139 avdd.t160 9.28054
R347 avdd.n306 avdd.t250 9.27224
R348 avdd.n309 avdd.t238 9.26035
R349 avdd.n311 avdd.t242 9.26035
R350 avdd.n124 avdd.t92 9.25804
R351 avdd.n254 avdd.t171 9.23217
R352 avdd.n261 avdd.t86 9.23217
R353 avdd.n294 avdd.t140 9.16723
R354 avdd.n24 avdd.n293 9.0455
R355 avdd.n198 avdd.n103 8.5505
R356 avdd.n283 avdd.n282 8.0105
R357 avdd.n236 avdd.n235 7.4705
R358 avdd.n180 avdd.n178 7.4705
R359 avdd.n410 avdd.n42 7.4255
R360 avdd.n265 avdd.n264 7.3805
R361 avdd.n133 avdd.n130 7.3805
R362 avdd.n226 avdd.n225 7.3805
R363 avdd.n139 avdd.n33 7.2905
R364 avdd.n266 avdd.n265 7.2005
R365 avdd.n152 avdd.n151 7.2005
R366 avdd.n227 avdd.n226 7.2005
R367 avdd.n217 avdd.n119 7.1105
R368 avdd.n140 avdd.n139 7.0205
R369 avdd.n285 avdd.n283 6.9755
R370 avdd.n359 avdd.n100 6.9755
R371 avdd.n38 avdd.n294 6.9305
R372 avdd.n294 avdd.n7 6.9305
R373 avdd.n261 avdd.n260 6.8405
R374 avdd.n124 avdd.n123 6.8405
R375 avdd.n255 avdd.n254 6.8405
R376 avdd.n234 avdd.n233 6.83504
R377 avdd.n366 avdd.n365 6.7955
R378 avdd.n438 avdd.n437 6.7055
R379 avdd.n73 avdd.n72 6.6155
R380 avdd.n182 avdd.n181 6.6155
R381 avdd.n92 avdd.n91 6.6155
R382 avdd.n311 avdd.n310 6.5705
R383 avdd.n63 avdd.n62 6.5255
R384 avdd.n328 avdd.n311 6.4355
R385 avdd.n429 avdd.n60 6.3905
R386 avdd.n394 avdd.n393 6.3905
R387 avdd.n335 avdd.n334 6.3905
R388 avdd.n310 avdd.n309 6.3905
R389 avdd.n331 avdd.n330 6.3005
R390 avdd.n384 avdd.n383 6.3005
R391 avdd.n399 avdd.n391 6.2105
R392 avdd.n397 avdd.n396 6.2105
R393 avdd.n67 avdd.n66 6.1655
R394 avdd.n432 avdd.n58 6.1655
R395 avdd.n403 avdd.n74 6.1655
R396 avdd.n402 avdd.n401 6.1655
R397 avdd.n333 avdd.n306 6.1205
R398 avdd.n286 avdd.n285 6.0755
R399 avdd.n69 avdd.n68 6.0755
R400 avdd.n168 avdd.n167 5.97949
R401 avdd.n284 avdd.n108 5.93792
R402 avdd.n411 avdd.n410 5.8955
R403 avdd.n233 avdd.n231 5.8505
R404 avdd.n407 avdd.n402 5.8505
R405 avdd.n409 avdd.n75 5.8505
R406 avdd.n72 avdd.n71 5.8055
R407 avdd.n51 avdd.n50 5.7155
R408 avdd.n165 avdd.n164 5.7155
R409 avdd.n131 avdd.n130 5.7155
R410 avdd.n326 avdd.n323 5.6705
R411 avdd.n56 avdd.n55 5.5805
R412 avdd.n405 avdd.n404 5.4905
R413 avdd.n292 avdd.n291 5.4455
R414 avdd.n334 avdd.n333 5.3555
R415 avdd.n112 avdd.n111 5.24672
R416 avdd.n174 avdd.n172 5.22849
R417 avdd.n151 avdd.n150 5.21723
R418 avdd.n18 avdd.n433 5.0855
R419 avdd.n341 avdd.n340 5.0405
R420 avdd.n323 avdd.n322 4.9505
R421 avdd.n417 avdd.n416 4.9505
R422 avdd.n412 avdd.n75 4.8605
R423 avdd.n303 avdd.n100 4.8605
R424 avdd.n439 avdd.n56 4.8155
R425 avdd.n185 avdd.n184 4.8155
R426 avdd.n78 avdd.t77 4.81173
R427 avdd.n401 avdd.n391 4.7705
R428 avdd.n271 avdd.n270 4.7705
R429 avdd.n241 avdd.t220 4.74502
R430 avdd.n234 avdd.t197 4.74502
R431 avdd.n32 avdd.n261 4.6355
R432 avdd.n421 avdd.n63 4.5905
R433 avdd.n440 avdd.n54 4.5905
R434 avdd.n343 avdd.n342 4.5905
R435 avdd.n71 avdd.n68 4.5905
R436 avdd.n426 avdd.n60 4.5005
R437 avdd.n398 avdd.n397 4.5005
R438 avdd.n396 avdd.n394 4.5005
R439 avdd.n393 avdd.n58 4.5005
R440 avdd.n433 avdd.n432 4.5005
R441 avdd.n434 avdd.n57 4.5005
R442 avdd.n437 avdd.n436 4.5005
R443 avdd.n235 avdd.n234 4.5005
R444 avdd.n232 avdd.n230 4.5005
R445 avdd.n250 avdd.n249 4.5005
R446 avdd.n162 avdd.n158 4.5005
R447 avdd.n166 avdd.n165 4.5005
R448 avdd.n170 avdd.n169 4.5005
R449 avdd.n332 avdd.n331 4.5005
R450 avdd.n385 avdd.n384 4.5005
R451 avdd.n125 avdd.n124 4.5005
R452 avdd.n178 avdd.n177 4.5005
R453 avdd.n141 avdd.n119 4.5005
R454 avdd avdd.n442 4.3285
R455 avdd.n440 avdd.n439 3.8705
R456 avdd.n207 avdd.n196 3.6005
R457 avdd.n249 avdd.n248 3.5555
R458 avdd.n49 avdd.n155 3.5105
R459 avdd.n246 avdd.n228 3.23972
R460 avdd.n153 avdd.n152 2.8805
R461 avdd.n155 avdd.n154 2.8805
R462 avdd.n90 avdd.n89 2.8805
R463 avdd.n217 avdd.n216 2.8805
R464 avdd.n193 avdd.n192 2.81079
R465 avdd.n277 avdd.n115 2.7905
R466 avdd.n183 avdd.n182 2.7905
R467 avdd.n91 avdd.n90 2.7905
R468 avdd.n43 avdd.n125 2.7905
R469 avdd.n264 avdd.n115 2.7005
R470 avdd.n240 avdd.n230 2.7005
R471 avdd.n244 avdd.n243 2.7005
R472 avdd.n256 avdd.n117 2.7005
R473 avdd.n253 avdd.n252 2.7005
R474 avdd.n154 avdd.n153 2.7005
R475 avdd.n114 avdd.n113 2.7005
R476 avdd.n367 avdd.n97 2.7005
R477 avdd.n364 avdd.n363 2.7005
R478 avdd.n262 avdd.n32 2.6105
R479 avdd.n430 avdd.n48 2.5655
R480 avdd.n171 avdd.n170 2.5205
R481 avdd.n279 avdd.n114 2.5205
R482 avdd.n372 avdd.n97 2.5205
R483 avdd.n93 avdd.n88 2.5205
R484 avdd.n88 avdd.n87 2.5205
R485 avdd.n220 avdd.n219 2.5205
R486 avdd.n163 avdd.n162 2.4305
R487 avdd.n329 avdd.n328 2.4305
R488 avdd.n279 avdd.n278 2.4305
R489 avdd.n148 avdd.n147 2.3855
R490 avdd.n386 avdd.n385 2.3855
R491 avdd.n373 avdd.n372 2.3405
R492 avdd.n184 avdd.n183 2.2505
R493 avdd.n276 avdd.n268 2.16964
R494 avdd.n296 avdd.n103 2.1605
R495 avdd.n298 avdd.n297 2.1605
R496 avdd.n298 avdd.n102 2.1605
R497 avdd.n349 avdd.n102 2.1605
R498 avdd.n106 avdd.n105 2.1605
R499 avdd.n377 avdd.n376 2.1605
R500 avdd.n35 avdd.n24 2.08831
R501 avdd.n29 avdd.n18 2.0705
R502 avdd.n6 avdd.n438 2.0705
R503 avdd.n37 avdd.n36 0.525448
R504 avdd.n297 avdd.n296 1.9805
R505 avdd.n336 avdd.n335 1.9805
R506 avdd.n332 avdd.n308 1.9805
R507 avdd.n276 avdd.n275 1.9285
R508 avdd.n436 avdd.n30 1.8905
R509 avdd.n184 avdd.n130 1.8905
R510 avdd.n202 avdd.n201 1.8905
R511 avdd.n317 avdd.n315 1.8905
R512 avdd.n37 avdd.n35 1.8905
R513 avdd.n376 avdd.n375 1.8905
R514 avdd.n351 avdd.n350 1.8905
R515 avdd.n174 avdd.n173 1.8905
R516 avdd.n377 avdd.n39 1.8455
R517 avdd.n41 avdd.n386 1.8455
R518 avdd.n425 avdd.n424 1.8005
R519 avdd.n399 avdd.n398 1.8005
R520 avdd.n270 avdd.n57 1.8005
R521 avdd.n274 avdd.n273 1.8005
R522 avdd.n213 avdd.n194 1.8005
R523 avdd.n209 avdd.n208 1.8005
R524 avdd.n203 avdd.n196 1.8005
R525 avdd.n342 avdd.n341 1.8005
R526 avdd.n345 avdd.n301 1.8005
R527 avdd.n308 avdd.n307 1.8005
R528 avdd.n319 avdd.n318 1.8005
R529 avdd.n127 avdd.n45 1.8005
R530 avdd.n413 avdd.n412 1.7555
R531 avdd.n374 avdd.n373 1.7555
R532 avdd.n273 avdd.n272 1.7105
R533 avdd.n242 avdd.n240 1.7105
R534 avdd.n256 avdd.n255 1.7105
R535 avdd.n252 avdd.n224 1.7105
R536 avdd.n138 avdd.n137 1.7105
R537 avdd.n136 avdd.n135 1.7105
R538 avdd.n147 avdd.n146 1.7105
R539 avdd.n181 avdd.n180 1.7105
R540 avdd.n344 avdd.n343 1.7105
R541 avdd.n345 avdd.n344 1.7105
R542 avdd.n367 avdd.n366 1.7105
R543 avdd.n92 avdd.n10 1.7105
R544 avdd.n353 avdd.n352 1.7105
R545 avdd.n356 avdd.n101 1.7105
R546 avdd.n358 avdd.n357 1.7105
R547 avdd.n360 avdd.n359 1.7105
R548 avdd.n380 avdd.n2 1.7105
R549 avdd.n326 avdd.n325 1.7105
R550 avdd.n126 avdd.n43 1.7105
R551 avdd.n141 avdd.n140 1.7105
R552 avdd.n8 avdd.n79 1.6655
R553 avdd.n404 avdd.n403 1.6655
R554 avdd.n13 avdd.n49 1.6485
R555 avdd.n72 avdd.n67 1.6205
R556 avdd.n424 avdd.n62 1.6205
R557 avdd.n434 avdd.n29 1.6205
R558 avdd.n214 avdd.n213 1.6205
R559 avdd.n209 avdd.n194 1.6205
R560 avdd.n208 avdd.n207 1.6205
R561 avdd.n203 avdd.n202 1.6205
R562 avdd.n319 avdd.n312 1.6205
R563 avdd.n318 avdd.n317 1.6205
R564 avdd.n215 avdd.n118 1.5535
R565 avdd.n272 avdd.n271 1.5305
R566 avdd.n53 avdd.n50 1.5305
R567 avdd.n177 avdd.n44 1.5305
R568 avdd.n48 avdd.n429 1.4855
R569 avdd.n192 avdd.n191 1.46907
R570 avdd.n237 avdd.n236 1.4415
R571 avdd.n219 avdd.n33 1.4405
R572 avdd.n291 avdd.n105 1.3955
R573 avdd.n36 avdd.n38 0.618683
R574 avdd.n337 avdd.n336 1.3775
R575 avdd.n251 avdd.n250 1.3655
R576 avdd.n180 avdd.n179 1.3655
R577 avdd.n170 avdd.n121 1.3655
R578 avdd.n4 avdd.n381 1.3655
R579 avdd.n419 avdd.n64 1.3505
R580 avdd.n420 avdd.n419 1.3505
R581 avdd.n201 avdd.n200 1.3505
R582 avdd.n340 avdd.n304 1.3505
R583 avdd.n327 avdd.n326 1.3505
R584 avdd.n315 avdd.n314 1.3505
R585 avdd.n314 avdd.n81 1.3505
R586 avdd.n388 avdd.n81 1.3505
R587 avdd.n408 avdd.n407 1.3505
R588 avdd.n409 avdd.n408 1.3505
R589 avdd.n287 avdd.n286 1.3505
R590 avdd.n260 avdd.n46 1.3505
R591 avdd.n407 avdd.n406 1.3295
R592 avdd.n401 avdd.n400 1.3175
R593 avdd.n327 avdd.n22 1.3175
R594 avdd.n18 avdd.n30 1.3055
R595 avdd.n1 avdd.n8 0.429826
R596 avdd.n277 avdd.n276 1.3015
R597 avdd.n65 avdd.n21 1.2975
R598 avdd.n436 avdd.n9 1.2975
R599 avdd.n25 avdd.n409 1.2855
R600 avdd.n222 avdd.n33 1.2825
R601 avdd.n142 avdd.n141 1.2815
R602 avdd.n143 avdd.n138 1.2815
R603 avdd.n144 avdd.n136 1.2815
R604 avdd.n146 avdd.n145 1.2815
R605 avdd.n160 avdd.n157 1.2775
R606 avdd.n70 avdd.n69 1.2695
R607 avdd.n322 avdd.n312 1.2605
R608 avdd.n324 avdd.n22 1.24379
R609 avdd.n32 avdd.n31 1.2375
R610 avdd.n1 avdd.n0 0.39598
R611 avdd.n370 avdd.n96 1.2215
R612 avdd.n267 avdd.n266 1.2207
R613 avdd.n442 avdd.n51 1.2175
R614 avdd.n149 avdd.n148 1.2175
R615 avdd.n339 avdd.n338 1.2175
R616 avdd.n84 avdd.n83 1.2175
R617 avdd.n379 avdd.n378 1.2175
R618 avdd.n348 avdd.n7 1.2155
R619 avdd.n17 avdd.n414 1.2055
R620 avdd.n1 avdd.n42 0.421088
R621 avdd.n192 avdd.n120 1.1855
R622 avdd.n5 avdd.n43 1.1825
R623 avdd.n24 avdd.n23 1.17792
R624 avdd.n431 avdd.n430 1.1735
R625 avdd.n421 avdd.n420 1.1705
R626 avdd.n415 avdd.n74 1.1705
R627 avdd.n48 avdd.n47 1.1705
R628 avdd.n46 avdd.n259 1.1705
R629 avdd.n41 avdd.n40 1.1705
R630 avdd.n39 avdd.n382 1.1705
R631 avdd.n295 avdd.n35 1.1705
R632 avdd.n20 avdd.n18 1.1705
R633 avdd.n29 avdd.n19 1.1705
R634 avdd.n288 avdd.n287 1.1575
R635 avdd.n55 avdd.n52 1.1535
R636 avdd.n188 avdd.n128 1.13808
R637 avdd.n189 avdd.n45 1.1375
R638 avdd.n190 avdd.n44 1.1375
R639 avdd.n441 avdd.n440 1.1255
R640 avdd.n429 avdd.n428 1.1255
R641 avdd.n422 avdd.n62 1.1255
R642 avdd.n424 avdd.n423 1.1255
R643 avdd.n425 avdd.n61 1.1255
R644 avdd.n427 avdd.n426 1.1255
R645 avdd.n21 avdd.n421 1.1255
R646 avdd.n419 avdd.n418 1.1255
R647 avdd.n14 avdd.n417 1.1255
R648 avdd.n71 avdd.n70 1.1255
R649 avdd.n432 avdd.n20 1.1255
R650 avdd.n400 avdd.n399 1.1255
R651 avdd.n398 avdd.n392 1.1255
R652 avdd.n396 avdd.n395 1.1255
R653 avdd.n393 avdd.n59 1.1255
R654 avdd.n435 avdd.n434 1.1255
R655 avdd.n271 avdd.n9 1.1255
R656 avdd.n273 avdd.n269 1.1255
R657 avdd.n275 avdd.n274 1.1255
R658 avdd.n263 avdd.n262 1.1255
R659 avdd.n238 avdd.n230 1.1255
R660 avdd.n240 avdd.n239 1.1255
R661 avdd.n243 avdd.n229 1.1255
R662 avdd.n245 avdd.n244 1.1255
R663 avdd.n237 avdd.n231 1.1255
R664 avdd.n258 avdd.n117 1.1255
R665 avdd.n257 avdd.n256 1.1255
R666 avdd.n253 avdd.n223 1.1255
R667 avdd.n252 avdd.n251 1.1255
R668 avdd.n221 avdd.n220 1.1255
R669 avdd.n163 avdd.n156 1.1255
R670 avdd.n162 avdd.n157 1.1255
R671 avdd.n162 avdd.n161 1.1255
R672 avdd.n179 avdd.n176 1.1255
R673 avdd.n134 avdd.n132 1.1255
R674 avdd.n214 avdd.n193 1.1255
R675 avdd.n213 avdd.n212 1.1255
R676 avdd.n211 avdd.n194 1.1255
R677 avdd.n210 avdd.n209 1.1255
R678 avdd.n208 avdd.n195 1.1255
R679 avdd.n207 avdd.n206 1.1255
R680 avdd.n205 avdd.n196 1.1255
R681 avdd.n204 avdd.n203 1.1255
R682 avdd.n202 avdd.n197 1.1255
R683 avdd.n200 avdd.n199 1.1255
R684 avdd.n104 avdd.n103 1.1255
R685 avdd.n296 avdd.n28 1.1255
R686 avdd.n297 avdd.n27 1.1255
R687 avdd.n299 avdd.n298 1.1255
R688 avdd.n300 avdd.n102 1.1255
R689 avdd.n349 avdd.n16 1.1255
R690 avdd.n337 avdd.n304 1.1255
R691 avdd.n346 avdd.n345 1.1255
R692 avdd.n347 avdd.n301 1.1255
R693 avdd.n343 avdd.n302 1.1255
R694 avdd.n340 avdd.n339 1.1255
R695 avdd.n322 avdd.n22 1.1255
R696 avdd.n321 avdd.n312 1.1255
R697 avdd.n320 avdd.n319 1.1255
R698 avdd.n318 avdd.n313 1.1255
R699 avdd.n317 avdd.n316 1.1255
R700 avdd.n314 avdd.n80 1.1255
R701 avdd.n26 avdd.n388 1.1255
R702 avdd.n411 avdd.n25 1.1255
R703 avdd.n34 avdd.n17 1.1255
R704 avdd.n406 avdd.n405 1.1255
R705 avdd.n390 avdd.n389 1.1255
R706 avdd.n385 avdd.n3 1.1255
R707 avdd.n4 avdd.n2 1.1255
R708 avdd.n88 avdd.n85 1.1255
R709 avdd.n376 avdd.n11 1.1255
R710 avdd.n12 avdd.n10 1.1255
R711 avdd.n94 avdd.n93 1.1255
R712 avdd.n374 avdd.n95 1.1255
R713 avdd.n361 avdd.n360 1.1255
R714 avdd.n358 avdd.n99 1.1255
R715 avdd.n356 avdd.n355 1.1255
R716 avdd.n354 avdd.n353 1.1255
R717 avdd.n351 avdd.n15 1.1255
R718 avdd.n369 avdd.n97 1.1255
R719 avdd.n368 avdd.n367 1.1255
R720 avdd.n364 avdd.n98 1.1255
R721 avdd.n363 avdd.n362 1.1255
R722 avdd.n372 avdd.n371 1.1255
R723 avdd.n291 avdd.n290 1.1255
R724 avdd.n107 avdd.n106 1.1255
R725 avdd.n289 avdd.n105 1.1255
R726 avdd.n282 avdd.n281 1.1255
R727 avdd.n280 avdd.n279 1.1255
R728 avdd.n114 avdd.n110 1.1255
R729 avdd.n187 avdd.n186 1.1255
R730 avdd.n218 avdd.n217 1.1255
R731 avdd.n247 avdd.n246 1.1255
R732 avdd.n216 avdd.n215 1.11425
R733 avdd.n140 avdd.n138 0.9905
R734 avdd.n146 avdd.n135 0.9905
R735 avdd.n373 avdd.n96 0.9905
R736 avdd.n352 avdd.n351 0.9905
R737 avdd.n357 avdd.n356 0.9905
R738 avdd.n383 avdd.n2 0.9905
R739 avdd.n389 avdd.n79 0.9905
R740 avdd.n175 avdd.n174 0.9905
R741 avdd.n66 avdd.n65 0.9455
R742 avdd.n339 avdd.n335 0.9455
R743 avdd.n177 avdd.n45 0.9455
R744 avdd.n44 avdd.n126 0.9455
R745 avdd.n47 avdd.n52 0.9365
R746 avdd.n233 avdd.n232 0.9005
R747 avdd.n387 avdd.n82 0.9005
R748 avdd.n122 avdd.n120 0.9005
R749 avdd.n123 avdd.n122 0.9005
R750 avdd.n243 avdd.n242 0.8105
R751 avdd.n260 avdd.n117 0.8105
R752 avdd.n255 avdd.n253 0.8105
R753 avdd.n250 avdd.n224 0.8105
R754 avdd.n137 avdd.n136 0.8105
R755 avdd.n164 avdd.n163 0.8105
R756 avdd.n181 avdd.n176 0.8105
R757 avdd.n366 avdd.n364 0.8105
R758 avdd.n375 avdd.n10 0.8105
R759 avdd.n93 avdd.n92 0.8105
R760 avdd.n353 avdd.n101 0.8105
R761 avdd.n359 avdd.n358 0.8105
R762 avdd.n381 avdd.n380 0.8105
R763 avdd.n386 avdd.n83 0.8105
R764 avdd.n378 avdd.n377 0.8105
R765 avdd.n128 avdd.n127 0.8105
R766 avdd.n281 avdd.n107 0.791357
R767 avdd.n199 avdd.n104 0.7765
R768 avdd.n32 avdd.n116 0.7655
R769 avdd.n268 avdd.n263 0.7445
R770 avdd.n191 avdd.n5 0.7365
R771 avdd.n150 avdd.n149 0.65143
R772 avdd.n350 avdd.n349 0.6305
R773 avdd.n286 avdd.n105 0.6305
R774 avdd.n150 avdd.n131 0.584461
R775 avdd.n87 avdd.n86 0.584461
R776 avdd.n112 avdd.n110 0.572252
R777 avdd.n246 avdd.n245 0.5685
R778 avdd.n113 avdd.n112 0.547843
R779 avdd.n288 avdd.n108 0.544175
R780 avdd.n330 avdd.n329 0.5405
R781 avdd.n86 avdd.n85 0.53943
R782 avdd.n167 avdd.n166 0.527202
R783 avdd.n268 avdd.n267 0.512058
R784 avdd.n362 avdd.n361 0.4965
R785 avdd.n348 avdd.n347 0.4885
R786 avdd.n290 avdd.n23 0.467611
R787 avdd.n188 avdd.n187 0.467268
R788 avdd.n147 avdd.n134 0.4505
R789 avdd.n388 avdd.n387 0.4505
R790 avdd.n412 avdd.n411 0.4505
R791 avdd.n417 avdd.n73 0.4505
R792 avdd.n186 avdd.n185 0.4505
R793 avdd.n441 avdd.n52 0.4485
R794 avdd.n172 avdd.n171 0.447879
R795 avdd.n73 avdd.n64 0.3605
R796 avdd.n82 avdd.n79 0.3605
R797 avdd.n278 avdd.n109 0.3605
R798 avdd.n282 avdd.n109 0.3605
R799 avdd.n172 avdd.n121 0.359922
R800 avdd.n206 avdd.n205 0.3365
R801 avdd.n167 avdd.n13 0.325735
R802 avdd.n346 avdd.n302 0.3205
R803 avdd.n161 avdd.n159 0.3155
R804 avdd.n293 avdd.n292 0.3155
R805 avdd.n269 avdd.n9 0.3045
R806 avdd.n316 avdd.n80 0.3045
R807 avdd.n199 avdd.n197 0.3045
R808 avdd.n28 avdd.n295 0.2965
R809 avdd.n221 avdd.n218 0.2965
R810 avdd.n16 avdd.n348 0.2805
R811 avdd.n134 avdd.n133 0.2705
R812 avdd.n200 avdd.n198 0.2705
R813 avdd.n325 avdd.n324 0.2705
R814 avdd.n239 avdd.n238 0.2565
R815 avdd.n245 avdd.n229 0.2565
R816 avdd.n258 avdd.n257 0.2565
R817 avdd.n251 avdd.n223 0.2565
R818 avdd.n179 avdd.n121 0.2565
R819 avdd.n143 avdd.n142 0.2565
R820 avdd.n145 avdd.n144 0.2565
R821 avdd.n26 avdd.n80 0.2565
R822 avdd.n369 avdd.n368 0.2565
R823 avdd.n362 avdd.n98 0.2565
R824 avdd.n355 avdd.n99 0.2565
R825 avdd.n354 avdd.n15 0.2565
R826 avdd.n5 avdd.n190 0.2565
R827 avdd.n189 avdd.n188 0.245307
R828 avdd.n239 avdd.n229 0.2405
R829 avdd.n257 avdd.n223 0.2405
R830 avdd.n142 avdd.n118 0.2405
R831 avdd.n144 avdd.n143 0.2405
R832 avdd.n12 avdd.n94 0.2405
R833 avdd.n94 avdd.n85 0.2405
R834 avdd.n371 avdd.n369 0.2405
R835 avdd.n368 avdd.n98 0.2405
R836 avdd.n361 avdd.n99 0.2405
R837 avdd.n355 avdd.n354 0.2405
R838 avdd.n190 avdd.n189 0.2405
R839 avdd.n281 avdd.n280 0.237325
R840 avdd.n95 avdd.n12 0.2325
R841 avdd.n280 avdd.n110 0.231611
R842 avdd.n338 avdd.n302 0.2245
R843 avdd.n20 avdd.n431 0.2205
R844 avdd.n17 avdd.n14 0.2165
R845 avdd.n237 avdd.n31 0.2165
R846 avdd.n259 avdd.n222 0.2165
R847 avdd.n0 avdd.n25 0.2165
R848 avdd.n26 avdd.n40 0.2165
R849 avdd.n3 avdd.n84 0.2165
R850 avdd.n406 avdd.n21 0.2165
R851 avdd.n418 avdd.n14 0.2085
R852 avdd.n238 avdd.n237 0.2085
R853 avdd.n259 avdd.n258 0.2085
R854 avdd.n145 avdd.n129 0.2085
R855 avdd.n16 avdd.n300 0.2085
R856 avdd.n300 avdd.n299 0.2085
R857 avdd.n299 avdd.n27 0.2085
R858 avdd.n28 avdd.n104 0.2085
R859 avdd.n295 avdd.n23 0.2085
R860 avdd.n289 avdd.n107 0.2085
R861 avdd.n187 avdd.n129 0.2045
R862 avdd.n157 avdd.n156 0.2005
R863 avdd.n382 avdd.n4 0.2005
R864 avdd.n379 avdd.n11 0.2005
R865 avdd.n371 avdd.n370 0.2005
R866 avdd.n295 avdd.n36 0.542125
R867 avdd.n5 avdd.n121 0.3445
R868 avdd.n390 avdd.n26 0.2565
R869 avdd.n12 avdd.n11 0.2565
R870 avdd.n4 avdd.n3 0.2565
R871 avdd.n17 avdd.n25 0.2485
R872 avdd.n0 avdd.n390 0.2485
R873 avdd.n16 avdd.n15 0.2405
R874 avdd.n418 avdd.n21 0.234786
R875 avdd.n70 avdd.n14 0.2165
R876 avdd.n28 avdd.n27 0.1925
R877 avdd.n9 avdd.n435 0.1925
R878 avdd.n422 avdd.n21 0.186786
R879 avdd.n191 avdd.n13 0.1845
R880 avdd.n22 avdd.n321 0.1845
R881 avdd.n20 avdd.n59 0.1845
R882 avdd.n415 avdd.n34 0.1805
R883 avdd.n423 avdd.n61 0.1765
R884 avdd.n400 avdd.n392 0.1765
R885 avdd.n395 avdd.n59 0.1765
R886 avdd.n275 avdd.n269 0.1765
R887 avdd.n347 avdd.n346 0.1765
R888 avdd.n320 avdd.n313 0.1765
R889 avdd.n205 avdd.n204 0.1765
R890 avdd.n210 avdd.n195 0.1765
R891 avdd.n212 avdd.n211 0.1765
R892 avdd.n428 avdd.n427 0.170786
R893 avdd.n431 avdd.n47 0.1685
R894 avdd.n442 avdd.n441 0.1605
R895 avdd.n423 avdd.n422 0.1605
R896 avdd.n427 avdd.n61 0.1605
R897 avdd.n395 avdd.n392 0.1605
R898 avdd.n435 avdd.n19 0.1605
R899 avdd.n316 avdd.n313 0.1605
R900 avdd.n321 avdd.n320 0.1605
R901 avdd.n84 avdd.n40 0.1605
R902 avdd.n382 avdd.n379 0.1605
R903 avdd.n370 avdd.n95 0.1605
R904 avdd.n289 avdd.n288 0.1605
R905 avdd.n204 avdd.n197 0.1605
R906 avdd.n206 avdd.n195 0.1605
R907 avdd.n211 avdd.n210 0.1605
R908 avdd.n212 avdd.n193 0.154786
R909 avdd.n20 avdd.n19 0.1525
R910 avdd.n156 avdd.n13 0.1525
R911 avdd.n428 avdd.n47 0.138786
R912 avdd.n132 avdd.n129 0.1365
R913 avdd.n218 avdd.n118 0.1365
R914 avdd.n54 avdd.n53 0.1355
R915 avdd.n413 avdd.n34 0.1355
R916 avdd.n285 avdd.n284 0.1355
R917 avdd.n263 avdd.n31 0.1285
R918 avdd.n222 avdd.n221 0.1285
R919 avdd.n338 avdd.n337 0.1285
R920 avdd.n149 avdd.n132 0.1205
R921 avdd.n290 avdd.n289 0.115611
R922 dvdd.n31 dvdd.t28 109.894
R923 dvdd.n30 dvdd.t18 109.692
R924 dvdd.n10 dvdd.t24 109.422
R925 dvdd.n6 dvdd.t26 109.272
R926 dvdd.n26 dvdd.t16 109.264
R927 dvdd.n12 dvdd.t22 104.746
R928 dvdd.n9 dvdd.t14 100.174
R929 dvdd.n7 dvdd.t21 82.4916
R930 dvdd.n1 dvdd.t6 60.7437
R931 dvdd.n14 dvdd.t9 45.3749
R932 dvdd.n38 dvdd.t8 39.4649
R933 dvdd.n39 dvdd.t4 39.4347
R934 dvdd.n13 dvdd.t5 33.4172
R935 dvdd.n18 dvdd.t10 31.6601
R936 dvdd.n15 dvdd.t13 31.4969
R937 dvdd.n20 dvdd.t20 30.6194
R938 dvdd.n18 dvdd.t12 30.6149
R939 dvdd.n17 dvdd.t1 30.6059
R940 dvdd.n21 dvdd.t0 30.578
R941 dvdd.n19 dvdd.t11 30.5714
R942 dvdd.n16 dvdd.t3 30.5689
R943 dvdd.n15 dvdd.t7 30.5667
R944 dvdd.n3 dvdd.t2 30.4271
R945 dvdd.n8 dvdd.n7 24.3348
R946 dvdd.n33 dvdd.n30 19.1255
R947 dvdd.n5 dvdd.n3 15.8855
R948 dvdd.n11 dvdd.t23 15.5386
R949 dvdd.n31 dvdd.t29 15.1483
R950 dvdd.n29 dvdd.t25 15.0481
R951 dvdd.n34 dvdd.t19 15.0481
R952 dvdd.n40 dvdd.n0 14.8505
R953 dvdd.n9 dvdd.n8 14.186
R954 dvdd dvdd.n1 12.4205
R955 dvdd.n7 dvdd.n6 11.5239
R956 dvdd.n5 dvdd.t27 10.5249
R957 dvdd.n8 dvdd.t15 10.5033
R958 dvdd.n27 dvdd.t17 10.4782
R959 dvdd.n33 dvdd.n32 9.8105
R960 dvdd.n0 dvdd.n3 9.37175
R961 dvdd.n35 dvdd.n9 9.288
R962 dvdd.n13 dvdd.n12 6.5255
R963 dvdd.n28 dvdd.n27 6.0305
R964 dvdd.n6 dvdd.n5 5.3555
R965 dvdd.n27 dvdd.n26 5.0405
R966 dvdd.n12 dvdd.n11 4.5005
R967 dvdd.n40 dvdd.n1 4.5005
R968 dvdd.n35 dvdd.n34 2.4755
R969 dvdd.n23 dvdd.n22 1.79223
R970 dvdd.n25 dvdd.n13 1.40779
R971 dvdd.n32 dvdd.n4 1.3015
R972 dvdd.n20 dvdd.n19 1.2605
R973 dvdd.n41 dvdd.n40 1.2375
R974 dvdd.n26 dvdd.n11 1.1705
R975 dvdd.n38 dvdd.n2 1.1255
R976 dvdd.n0 dvdd.n37 1.1255
R977 dvdd.n36 dvdd.n35 1.1255
R978 dvdd.n26 dvdd.n25 1.1255
R979 dvdd.n30 dvdd.n29 1.0805
R980 dvdd.n21 dvdd.n20 1.0805
R981 dvdd.n16 dvdd.n15 1.0805
R982 dvdd.n14 dvdd.n10 0.9905
R983 dvdd.n23 dvdd.n14 0.966612
R984 dvdd.n19 dvdd.n18 0.9005
R985 dvdd.n17 dvdd.n16 0.9005
R986 dvdd.n39 dvdd.n38 0.8105
R987 dvdd.n37 dvdd.n36 0.6965
R988 dvdd.n22 dvdd.n17 0.5855
R989 dvdd dvdd.n41 0.4925
R990 dvdd.n41 dvdd.n2 0.4885
R991 dvdd.n32 dvdd.n31 0.4505
R992 dvdd.n0 dvdd.n39 0.4505
R993 dvdd.n28 dvdd.n10 0.2705
R994 dvdd.n25 dvdd.n24 0.234786
R995 dvdd.n22 dvdd.n21 0.2255
R996 dvdd.n24 dvdd.n4 0.1845
R997 dvdd.n34 dvdd.n33 0.1355
R998 dvdd.n29 dvdd.n28 0.1355
R999 dvdd.n37 dvdd.n2 0.1285
R1000 dvdd.n36 dvdd.n4 0.1205
R1001 dvdd.n24 dvdd.n23 0.103319
R1002 psrg_mf1_protected psrg_mf1_protected.t0 24.2068
R1003 psrg_mf1_protected psrg_mf1_protected.t1 4.75063
R1004 su_state su_state.n0 21.9515
R1005 su_state.n0 su_state.t1 17.9745
R1006 su_state.n0 su_state.t2 16.4814
R1007 su_state su_state.t0 8.9205
R1008 xf1.n0 xf1.t8 42.5749
R1009 xf1.n5 xf1.t6 27.3149
R1010 xf1.n0 xf1.t7 18.355
R1011 xf1.n3 xf1.n2 16.2005
R1012 xf1.n4 xf1.t5 14.035
R1013 xf1.n2 xf1.t11 13.9
R1014 xf1.n1 xf1.t3 13.8599
R1015 xf1.n3 xf1.t4 13.8599
R1016 xf1.n8 xf1.t0 13.6805
R1017 xf1.n7 xf1.t10 13.6805
R1018 xf1.n9 xf1.t9 13.6404
R1019 xf1 xf1.n9 13.0678
R1020 xf1.n6 xf1.n5 12.3305
R1021 xf1.n6 xf1.t2 9.14039
R1022 xf1.n8 xf1.n7 7.7405
R1023 xf1.n7 xf1.n6 6.6605
R1024 xf1 xf1.t1 4.5781
R1025 xf1.n2 xf1.n1 3.0605
R1026 xf1.n4 xf1.n3 2.9705
R1027 xf1.n1 xf1.n0 2.7905
R1028 xf1.n5 xf1.n4 2.7005
R1029 xf1.n9 xf1.n8 1.9805
R1030 vsp.n0 vsp.t8 16.0674
R1031 vsp.n5 vsp.t4 15.7916
R1032 vsp.n13 vsp.n4 14.8955
R1033 vsp.n3 vsp.t14 13.7319
R1034 vsp.n0 vsp.t11 13.7004
R1035 vsp.n2 vsp.t9 13.6959
R1036 vsp.n1 vsp.t10 13.6717
R1037 vsp.n4 vsp.t12 13.6659
R1038 vsp.n12 vsp.t2 13.6535
R1039 vsp.n10 vsp.t13 13.6535
R1040 vsp.n5 vsp.t5 13.6535
R1041 vsp.n7 vsp.t7 13.6535
R1042 vsp.n8 vsp.t0 13.6316
R1043 vsp.n11 vsp.t3 13.6316
R1044 vsp.n9 vsp.t1 13.6316
R1045 vsp.n6 vsp.t15 13.6316
R1046 vsp.n13 vsp.n12 6.5255
R1047 vsp vsp.t6 4.5781
R1048 vsp vsp.n13 4.55402
R1049 vsp.n9 vsp.n8 3.9605
R1050 vsp.n4 vsp.n3 2.5205
R1051 vsp.n2 vsp.n1 2.5205
R1052 vsp.n1 vsp.n0 2.5205
R1053 vsp.n3 vsp.n2 2.3405
R1054 vsp.n10 vsp.n9 2.1605
R1055 vsp.n12 vsp.n11 2.1605
R1056 vsp.n7 vsp.n6 2.1605
R1057 vsp.n11 vsp.n10 1.9805
R1058 vsp.n8 vsp.n7 1.9805
R1059 vsp.n6 vsp.n5 1.9805
R1060 iref_gate.n1 iref_gate.t1 79.3175
R1061 iref_gate.n0 iref_gate.t3 74.4705
R1062 iref_gate.n0 iref_gate.t2 13.8913
R1063 iref_gate iref_gate.n1 9.18991
R1064 iref_gate iref_gate.t0 4.55384
R1065 iref_gate.n1 iref_gate.n0 1.0805
R1066 xf2.n6 xf2.t9 37.1877
R1067 xf2.n1 xf2.t4 24.115
R1068 xf2.n4 xf2.n3 20.3855
R1069 xf2 xf2.n9 17.6529
R1070 xf2.n9 xf2.n8 16.8305
R1071 xf2.n0 xf2.t7 16.8299
R1072 xf2.n0 xf2.t6 14.035
R1073 xf2.n3 xf2.t11 13.9
R1074 xf2.n8 xf2.n7 11.2505
R1075 xf2.n4 xf2.t8 9.6749
R1076 xf2.n2 xf2.t10 9.3599
R1077 xf2.n8 xf2.t0 9.18048
R1078 xf2.n5 xf2.t2 9.18048
R1079 xf2.n9 xf2.t1 9.18048
R1080 xf2.n7 xf2.t5 9.14039
R1081 xf2.n1 xf2.n0 8.7305
R1082 xf2.n3 xf2.n2 7.5605
R1083 xf2.n5 xf2.n4 5.9405
R1084 xf2 xf2.t3 4.5781
R1085 xf2.n7 xf2.n6 3.0155
R1086 xf2.n6 xf2.n5 2.7905
R1087 xf2.n2 xf2.n1 2.7905
R1088 vbn_fold.n6 vbn_fold.t15 66.9311
R1089 vbn_fold.n7 vbn_fold.t14 28.7855
R1090 vbn_fold.n0 vbn_fold.t0 18.9113
R1091 vbn_fold.n0 vbn_fold.t1 14.4891
R1092 vbn_fold.n4 vbn_fold.t2 13.813
R1093 vbn_fold.n2 vbn_fold.t9 13.813
R1094 vbn_fold.n5 vbn_fold.t3 13.7911
R1095 vbn_fold.n1 vbn_fold.t6 13.7911
R1096 vbn_fold.n3 vbn_fold.t10 13.7911
R1097 vbn_fold.n8 vbn_fold.t7 13.7803
R1098 vbn_fold.n10 vbn_fold.t12 13.7803
R1099 vbn_fold.n7 vbn_fold.t11 13.7512
R1100 vbn_fold.n9 vbn_fold.t4 13.7512
R1101 vbn_fold.n11 vbn_fold.t13 13.7512
R1102 vbn_fold.n6 vbn_fold.t8 9.31296
R1103 vbn_fold.n12 vbn_fold.n11 7.4255
R1104 vbn_fold.n6 vbn_fold.n5 7.3805
R1105 vbn_fold.n1 vbn_fold.n0 5.4005
R1106 vbn_fold.n12 vbn_fold.n6 5.3555
R1107 vbn_fold vbn_fold.t5 4.72634
R1108 vbn_fold vbn_fold.n12 4.5545
R1109 vbn_fold.n5 vbn_fold.n4 3.0605
R1110 vbn_fold.n11 vbn_fold.n10 3.0605
R1111 vbn_fold.n9 vbn_fold.n8 3.0605
R1112 vbn_fold.n3 vbn_fold.n2 3.0605
R1113 vbn_fold.n10 vbn_fold.n9 2.8805
R1114 vbn_fold.n8 vbn_fold.n7 2.8805
R1115 vbn_fold.n4 vbn_fold.n3 2.8805
R1116 vbn_fold.n2 vbn_fold.n1 2.8805
R1117 vbp_tail.n1 vbp_tail.n0 69.0755
R1118 vbp_tail.n0 vbp_tail.t6 41.9642
R1119 vbp_tail.n8 vbp_tail.t9 32.3537
R1120 vbp_tail.n9 vbp_tail.t10 32.3447
R1121 vbp_tail.n10 vbp_tail.t11 32.29
R1122 vbp_tail.n11 vbp_tail.t12 32.2887
R1123 vbp_tail.n1 vbp_tail.t8 27.7895
R1124 vbp_tail.n2 vbp_tail.t0 25.2678
R1125 vbp_tail.n3 vbp_tail.t4 24.8343
R1126 vbp_tail.n7 vbp_tail.n6 23.5355
R1127 vbp_tail vbp_tail.t13 23.284
R1128 vbp_tail.n2 vbp_tail.t2 23.1438
R1129 vbp_tail.n0 vbp_tail.t7 17.1211
R1130 vbp_tail.n3 vbp_tail.t5 14.5794
R1131 vbp_tail.n6 vbp_tail.t1 13.9791
R1132 vbp_tail.n4 vbp_tail.t3 13.8954
R1133 vbp_tail vbp_tail.n11 11.4282
R1134 vbp_tail.n7 vbp_tail.n1 6.1205
R1135 vbp_tail.n11 vbp_tail.n10 2.3405
R1136 vbp_tail.n10 vbp_tail.n9 2.3405
R1137 vbp_tail.n9 vbp_tail.n8 2.1605
R1138 vbp_tail.n5 vbp_tail.n2 1.7105
R1139 vbp_tail.n4 vbp_tail.n3 1.6205
R1140 vbp_tail.n6 vbp_tail.n5 1.5305
R1141 vbp_tail.n5 vbp_tail.n4 0.9005
R1142 vbp_tail.n8 vbp_tail.n7 0.7205
R1143 psrg_m3_protected.n0 psrg_m3_protected.t1 15.8499
R1144 psrg_m3_protected.n1 psrg_m3_protected.t2 13.8481
R1145 psrg_m3_protected.n0 psrg_m3_protected.t3 13.8481
R1146 psrg_m3_protected psrg_m3_protected.n1 11.0795
R1147 psrg_m3_protected psrg_m3_protected.t0 4.81592
R1148 psrg_m3_protected.n1 psrg_m3_protected.n0 1.2605
R1149 v2.n4 v2.t6 65.4785
R1150 v2.n3 v2.t5 65.4785
R1151 v2.n2 v2.t4 65.4173
R1152 v2.n1 v2.t3 60.9785
R1153 v2 v2.t7 56.411
R1154 v2.n1 v2.n0 43.4705
R1155 v2.n5 v2.t0 38.5239
R1156 v2.n0 v2.t2 15.9669
R1157 v2.n0 v2.t1 13.9918
R1158 v2.n2 v2.n1 10.4405
R1159 v2.n5 v2.n4 8.4605
R1160 v2.n4 v2.n3 7.7405
R1161 v2 v2.n5 4.568
R1162 v2.n3 v2.n2 1.8005
R1163 v1.n3 v1.t4 65.4785
R1164 v1.n2 v1.t3 65.4785
R1165 v1.n4 v1.t5 65.4173
R1166 v1.n1 v1.t2 60.9173
R1167 v1 v1.t6 56.411
R1168 v1.n1 v1.n0 41.2205
R1169 v1.n5 v1 30.488
R1170 v1.n0 v1.t1 15.9181
R1171 v1.n0 v1.t0 14.0049
R1172 v1 v1.n5 9.1418
R1173 v1.n3 v1.n2 7.7405
R1174 v1.n2 v1.n1 6.3005
R1175 v1.n5 v1.n4 3.8705
R1176 v1.n4 v1.n3 1.9805
R1177 vbn vbn.n2 59.162
R1178 vbn.n0 vbn.t1 22.2684
R1179 vbn.n1 vbn.t4 22.2196
R1180 vbn.n2 vbn.t3 17.9215
R1181 vbn.n0 vbn.t2 15.5707
R1182 vbn.n2 vbn.n1 10.1255
R1183 vbn vbn.t0 4.76719
R1184 vbn.n1 vbn.n0 4.3655
R1185 vbp_bias.n23 vbp_bias.n22 97.3355
R1186 vbp_bias.n6 vbp_bias.t1 26.1327
R1187 vbp_bias.n1 vbp_bias.t25 25.8148
R1188 vbp_bias.n19 vbp_bias.t15 25.6872
R1189 vbp_bias.n15 vbp_bias.t11 25.6575
R1190 vbp_bias.n17 vbp_bias.t13 25.6514
R1191 vbp_bias.n7 vbp_bias.t5 25.32
R1192 vbp_bias.n11 vbp_bias.t7 24.3102
R1193 vbp_bias.n22 vbp_bias.t17 24.1122
R1194 vbp_bias.n6 vbp_bias.t3 23.2167
R1195 vbp_bias.n12 vbp_bias.t9 23.1942
R1196 vbp_bias.n2 vbp_bias.t27 16.8913
R1197 vbp_bias.n13 vbp_bias.t8 15.6757
R1198 vbp_bias.n7 vbp_bias.t6 14.7137
R1199 vbp_bias.n0 vbp_bias.n1 14.1755
R1200 vbp_bias.n10 vbp_bias.t2 13.9342
R1201 vbp_bias.n21 vbp_bias.t18 13.928
R1202 vbp_bias.n18 vbp_bias.t14 13.8407
R1203 vbp_bias.n3 vbp_bias.t21 13.8313
R1204 vbp_bias.n8 vbp_bias.t4 13.8083
R1205 vbp_bias.n20 vbp_bias.t16 13.8047
R1206 vbp_bias.n1 vbp_bias.t23 13.8047
R1207 vbp_bias.n16 vbp_bias.t12 13.8002
R1208 vbp_bias.n14 vbp_bias.t10 13.7948
R1209 vbp_bias.n2 vbp_bias.t22 13.7912
R1210 vbp_bias.n0 vbp_bias.t0 13.7912
R1211 vbp_bias.n4 vbp_bias.t19 12.3647
R1212 vbp_bias.n4 vbp_bias.t20 9.34477
R1213 vbp_bias.n5 vbp_bias.t24 9.33127
R1214 vbp_bias vbp_bias.n23 9.20003
R1215 vbp_bias.n1 vbp_bias.n4 7.5155
R1216 vbp_bias.n23 vbp_bias.n5 7.4705
R1217 vbp_bias.n5 vbp_bias.n0 7.3805
R1218 vbp_bias vbp_bias.t26 4.72664
R1219 vbp_bias.n0 vbp_bias.n3 3.0605
R1220 vbp_bias.n11 vbp_bias.n10 2.9705
R1221 vbp_bias.n3 vbp_bias.n2 2.8805
R1222 vbp_bias.n21 vbp_bias.n20 2.7905
R1223 vbp_bias.n13 vbp_bias.n12 2.4305
R1224 vbp_bias.n9 vbp_bias.n6 2.0705
R1225 vbp_bias.n22 vbp_bias.n21 2.0705
R1226 vbp_bias.n8 vbp_bias.n7 1.9805
R1227 vbp_bias.n19 vbp_bias.n18 1.8905
R1228 vbp_bias.n17 vbp_bias.n16 1.8905
R1229 vbp_bias.n15 vbp_bias.n14 1.8905
R1230 vbp_bias.n10 vbp_bias.n9 1.8905
R1231 vbp_bias.n12 vbp_bias.n11 1.8005
R1232 vbp_bias.n20 vbp_bias.n19 1.1705
R1233 vbp_bias.n18 vbp_bias.n17 0.9905
R1234 vbp_bias.n16 vbp_bias.n15 0.9905
R1235 vbp_bias.n14 vbp_bias.n13 0.9905
R1236 vbp_bias.n9 vbp_bias.n8 0.9005
R1237 vbn_sink.n4 vbn_sink.t27 24.6307
R1238 vbn_sink.n0 vbn_sink.t21 24.6181
R1239 vbn_sink.n16 vbn_sink.t3 22.5236
R1240 vbn_sink.n4 vbn_sink.t28 21.9622
R1241 vbn_sink.n6 vbn_sink.t30 21.9622
R1242 vbn_sink.n29 vbn_sink.t32 21.9622
R1243 vbn_sink.n0 vbn_sink.t22 21.9532
R1244 vbn_sink.n2 vbn_sink.t24 21.9532
R1245 vbn_sink.n5 vbn_sink.t29 21.9307
R1246 vbn_sink.n7 vbn_sink.t31 21.9307
R1247 vbn_sink.n1 vbn_sink.t23 21.9181
R1248 vbn_sink.n3 vbn_sink.t25 21.9181
R1249 vbn_sink.n17 vbn_sink.t5 21.5084
R1250 vbn_sink.n8 vbn_sink.t2 21.2325
R1251 vbn_sink.n12 vbn_sink.t9 16.8101
R1252 vbn_sink.n21 vbn_sink.t20 16.6875
R1253 vbn_sink.n26 vbn_sink.n25 14.1755
R1254 vbn_sink.n18 vbn_sink.t6 13.9332
R1255 vbn_sink.n16 vbn_sink.t4 13.9114
R1256 vbn_sink.n15 vbn_sink.t16 13.8851
R1257 vbn_sink.n12 vbn_sink.t17 13.8075
R1258 vbn_sink.n14 vbn_sink.t15 13.8075
R1259 vbn_sink.n9 vbn_sink.t8 13.8075
R1260 vbn_sink.n11 vbn_sink.t11 13.8075
R1261 vbn_sink.n24 vbn_sink.t1 13.8075
R1262 vbn_sink.n22 vbn_sink.t13 13.8075
R1263 vbn_sink.n10 vbn_sink.t10 13.7644
R1264 vbn_sink.n26 vbn_sink.t19 13.7644
R1265 vbn_sink.n13 vbn_sink.t18 13.7501
R1266 vbn_sink.n23 vbn_sink.t0 13.7337
R1267 vbn_sink.n21 vbn_sink.t12 13.7337
R1268 vbn_sink.n19 vbn_sink.n18 12.9605
R1269 vbn_sink vbn_sink.t26 12.8857
R1270 vbn_sink.n8 vbn_sink.t7 9.26438
R1271 vbn_sink vbn_sink.n30 9.248
R1272 vbn_sink.n20 vbn_sink.t14 9.2337
R1273 vbn_sink.n20 vbn_sink.n19 7.7405
R1274 vbn_sink.n9 vbn_sink.n8 7.5605
R1275 vbn_sink.n30 vbn_sink.n29 4.8605
R1276 vbn_sink.n25 vbn_sink.n20 4.6355
R1277 vbn_sink.n28 vbn_sink.n27 3.1505
R1278 vbn_sink.n24 vbn_sink.n23 3.0605
R1279 vbn_sink.n14 vbn_sink.n13 3.0605
R1280 vbn_sink.n11 vbn_sink.n10 3.0605
R1281 vbn_sink.n22 vbn_sink.n21 3.0605
R1282 vbn_sink.n13 vbn_sink.n12 2.8805
R1283 vbn_sink.n10 vbn_sink.n9 2.8805
R1284 vbn_sink.n7 vbn_sink.n6 2.8805
R1285 vbn_sink.n5 vbn_sink.n4 2.8805
R1286 vbn_sink.n3 vbn_sink.n2 2.8805
R1287 vbn_sink.n1 vbn_sink.n0 2.8805
R1288 vbn_sink.n23 vbn_sink.n22 2.8805
R1289 vbn_sink.n25 vbn_sink.n24 2.7905
R1290 vbn_sink.n15 vbn_sink.n14 2.7905
R1291 vbn_sink.n27 vbn_sink.n11 2.7905
R1292 vbn_sink.n6 vbn_sink.n5 2.7005
R1293 vbn_sink.n2 vbn_sink.n1 2.7005
R1294 vbn_sink.n30 vbn_sink.n3 2.5205
R1295 vbn_sink.n19 vbn_sink.n15 1.9355
R1296 vbn_sink.n17 vbn_sink.n16 1.8905
R1297 vbn_sink.n28 vbn_sink.n7 1.8005
R1298 vbn_sink.n18 vbn_sink.n17 1.1705
R1299 vbn_sink.n29 vbn_sink.n28 0.9005
R1300 vbn_sink.n27 vbn_sink.n26 0.1355
R1301 vbn_i.n5 vbn_i.n4 49.6967
R1302 vbn_i.n3 vbn_i.n1 48.7805
R1303 vbn_i.n0 vbn_i.t7 32.0695
R1304 vbn_i.n1 vbn_i.n0 29.5655
R1305 vbn_i.n6 vbn_i.n5 26.0749
R1306 vbn_i.n2 vbn_i.t1 20.6658
R1307 vbn_i.n1 vbn_i.t10 16.3059
R1308 vbn_i vbn_i.n9 14.87
R1309 vbn_i.n4 vbn_i.t11 14.5102
R1310 vbn_i.n7 vbn_i.t3 13.8322
R1311 vbn_i.n6 vbn_i.t2 13.7921
R1312 vbn_i.n9 vbn_i.t5 13.7921
R1313 vbn_i.n8 vbn_i.t4 13.7921
R1314 vbn_i.n2 vbn_i.t0 13.4854
R1315 vbn_i.n9 vbn_i.n8 11.3405
R1316 vbn_i.n0 vbn_i.t8 10.3992
R1317 vbn_i.n7 vbn_i.n6 8.6405
R1318 vbn_i.n4 vbn_i.n3 7.5605
R1319 vbn_i.n5 vbn_i.t9 5.72603
R1320 vbn_i vbn_i.t6 4.72757
R1321 vbn_i.n3 vbn_i.n2 4.5005
R1322 vbn_i.n8 vbn_i.n7 2.8805
R1323 y1.n13 y1.t6 82.8267
R1324 y1.n16 y1.n10 36.4505
R1325 y1.n0 y1.t12 36.316
R1326 y1.n5 y1.t18 36.2645
R1327 y1.n4 y1.t7 34.3675
R1328 y1.n2 y1.t9 34.3675
R1329 y1.n0 y1.t11 34.3675
R1330 y1.n3 y1.t8 34.336
R1331 y1.n9 y1.t13 34.3349
R1332 y1.n7 y1.t15 34.3349
R1333 y1.n5 y1.t17 34.3349
R1334 y1.n8 y1.t14 34.2845
R1335 y1.n1 y1.t10 29.836
R1336 y1.n6 y1.t16 29.7845
R1337 y1.n11 y1.t5 26.9336
R1338 y1.n14 y1.n13 11.8805
R1339 y1.n12 y1.n11 11.8355
R1340 y1.n12 y1.t4 9.38362
R1341 y1.n11 y1.t3 9.28871
R1342 y1.n13 y1.t1 9.27408
R1343 y1.n14 y1.t2 9.20433
R1344 y1.n2 y1.n1 6.4805
R1345 y1.n7 y1.n6 6.4805
R1346 y1.n1 y1.n0 6.3005
R1347 y1.n6 y1.n5 6.3005
R1348 y1.n15 y1.n12 6.1205
R1349 y1.n15 y1.n14 5.8505
R1350 y1.n10 y1.n4 5.7605
R1351 y1 y1.t0 4.69308
R1352 y1 y1.n16 4.5815
R1353 y1.n16 y1.n15 2.8355
R1354 y1.n4 y1.n3 1.9805
R1355 y1.n9 y1.n8 1.9805
R1356 y1.n3 y1.n2 1.8005
R1357 y1.n8 y1.n7 1.8005
R1358 y1.n10 y1.n9 0.2705
R1359 pm1.n8 pm1.n7 31.9955
R1360 pm1.n5 pm1.t9 28.451
R1361 pm1.n1 pm1.t5 26.8117
R1362 pm1.n4 pm1.t6 20.4924
R1363 pm1.n0 pm1.t1 16.6719
R1364 pm1.n5 pm1.t11 15.851
R1365 pm1.n6 pm1.n5 14.5355
R1366 pm1.n5 pm1.t10 13.9561
R1367 pm1.n0 pm1.t2 13.8821
R1368 pm1.n2 pm1.n1 12.1055
R1369 pm1.n3 pm1.n2 10.3955
R1370 pm1.n7 pm1.t8 9.28735
R1371 pm1.n2 pm1.t4 9.26171
R1372 pm1.n1 pm1.t3 9.23985
R1373 pm1.n4 pm1.t7 9.22476
R1374 pm1.n7 pm1.n6 8.4155
R1375 pm1.n8 pm1.n3 7.2905
R1376 pm1.n6 pm1.n4 6.3905
R1377 pm1.n3 pm1.n0 5.5805
R1378 pm1 pm1.t0 4.69308
R1379 pm1 pm1.n8 4.50934
R1380 vgn2.n7 vgn2.t8 59.0967
R1381 vgn2.n0 vgn2.t10 33.695
R1382 vgn2.n0 vgn2.t9 33.2139
R1383 vgn2.n1 vgn2.t4 20.8087
R1384 vgn2.n1 vgn2.t5 19.102
R1385 vgn2.n2 vgn2.t2 19.031
R1386 vgn2.n5 vgn2.t0 18.3058
R1387 vgn2.n1 vgn2.t6 18.282
R1388 vgn2.n2 vgn2.t1 18.2741
R1389 vgn2.n4 vgn2.t3 18.2377
R1390 vgn2.n7 vgn2.n6 14.7605
R1391 vgn2.n6 vgn2.n5 9.22717
R1392 vgn2.n8 vgn2.t7 9.22128
R1393 vgn2.n8 vgn2.n7 7.3265
R1394 vgn2 vgn2.n8 4.5005
R1395 vgn2.n6 vgn2.n0 2.90717
R1396 vgn2.n3 vgn2.n1 1.78717
R1397 vgn2.n4 vgn2.n3 1.70717
R1398 vgn2.n5 vgn2.n4 0.813833
R1399 vgn2.n3 vgn2.n2 0.813833
R1400 pm2 pm2.n8 45.4055
R1401 pm2.n0 pm2.t3 31.2449
R1402 pm2.n1 pm2.n0 21.1505
R1403 pm2.n4 pm2.t11 19.5811
R1404 pm2.n2 pm2.t2 16.2671
R1405 pm2.n6 pm2.t6 15.4348
R1406 pm2.n2 pm2.n1 15.3905
R1407 pm2.n4 pm2.t10 13.781
R1408 pm2.n8 pm2.t8 13.7248
R1409 pm2.n6 pm2.n5 10.7105
R1410 pm2.n3 pm2.n2 10.6205
R1411 pm2.n5 pm2.t9 9.3211
R1412 pm2.n7 pm2.t7 9.28735
R1413 pm2.n3 pm2.t0 9.20192
R1414 pm2.n7 pm2.n6 8.5505
R1415 pm2 pm2.n3 7.61787
R1416 pm2.n5 pm2.n4 6.7055
R1417 pm2.n8 pm2.n7 6.6605
R1418 pm2.n0 pm2.t5 4.76171
R1419 pm2 pm2.t1 4.74708
R1420 pm2.n1 pm2.t4 4.73985
R1421 vbp_cas.n30 vbp_cas.t0 48.2304
R1422 vbp_cas.n19 vbp_cas.n18 31.2305
R1423 vbp_cas.n10 vbp_cas.t17 30.3349
R1424 vbp_cas.n15 vbp_cas.t13 30.3349
R1425 vbp_cas.n24 vbp_cas.t27 27.5103
R1426 vbp_cas.n0 vbp_cas.t5 25.8619
R1427 vbp_cas.n7 vbp_cas.t19 25.4416
R1428 vbp_cas.n6 vbp_cas.t1 25.2769
R1429 vbp_cas.n1 vbp_cas.t7 25.2454
R1430 vbp_cas.n25 vbp_cas.t29 24.6303
R1431 vbp_cas.n27 vbp_cas.t31 24.6303
R1432 vbp_cas.n23 vbp_cas.t25 24.6303
R1433 vbp_cas.n24 vbp_cas.t28 24.5961
R1434 vbp_cas.n26 vbp_cas.t30 24.5961
R1435 vbp_cas.n28 vbp_cas.t32 24.5961
R1436 vbp_cas.n20 vbp_cas.t22 24.5673
R1437 vbp_cas.n22 vbp_cas.t24 24.5673
R1438 vbp_cas.n17 vbp_cas.t9 23.1349
R1439 vbp_cas.n0 vbp_cas.t3 23.1304
R1440 vbp_cas.n21 vbp_cas.t23 20.1303
R1441 vbp_cas.n19 vbp_cas.t21 20.1303
R1442 vbp_cas.n10 vbp_cas.t15 18.6016
R1443 vbp_cas.n15 vbp_cas.t11 18.6016
R1444 vbp_cas.n3 vbp_cas.n2 16.5605
R1445 vbp_cas vbp_cas.t26 15.5628
R1446 vbp_cas.n29 vbp_cas.n28 15.1655
R1447 vbp_cas.n1 vbp_cas.t8 14.6959
R1448 vbp_cas.n7 vbp_cas.t20 14.6824
R1449 vbp_cas.n14 vbp_cas.t10 13.9393
R1450 vbp_cas.n8 vbp_cas.t18 13.8043
R1451 vbp_cas.n12 vbp_cas.t14 13.8043
R1452 vbp_cas.n3 vbp_cas.t4 13.7959
R1453 vbp_cas.n9 vbp_cas.t16 13.7824
R1454 vbp_cas.n18 vbp_cas.n17 12.2855
R1455 vbp_cas.n5 vbp_cas.t2 9.31777
R1456 vbp_cas.n2 vbp_cas.t6 9.31777
R1457 vbp_cas.n13 vbp_cas.t12 9.28241
R1458 vbp_cas.n13 vbp_cas.n12 7.6055
R1459 vbp_cas.n20 vbp_cas.n19 7.3805
R1460 vbp_cas.n22 vbp_cas.n21 7.3805
R1461 vbp_cas.n14 vbp_cas.n13 7.2905
R1462 vbp_cas.n21 vbp_cas.n20 7.2005
R1463 vbp_cas.n11 vbp_cas.n10 6.8405
R1464 vbp_cas.n5 vbp_cas.n4 6.5255
R1465 vbp_cas.n2 vbp_cas.n1 6.5255
R1466 vbp_cas.n16 vbp_cas.n15 6.3005
R1467 vbp_cas.n6 vbp_cas.n5 5.5805
R1468 vbp_cas.n30 vbp_cas.n29 4.6805
R1469 vbp_cas vbp_cas.n30 4.505
R1470 vbp_cas.n9 vbp_cas.n8 3.0605
R1471 vbp_cas.n28 vbp_cas.n27 2.8805
R1472 vbp_cas.n26 vbp_cas.n25 2.8805
R1473 vbp_cas.n29 vbp_cas.n23 2.7005
R1474 vbp_cas.n23 vbp_cas.n22 2.7005
R1475 vbp_cas.n27 vbp_cas.n26 2.7005
R1476 vbp_cas.n25 vbp_cas.n24 2.7005
R1477 vbp_cas.n4 vbp_cas.n0 2.0705
R1478 vbp_cas.n16 vbp_cas.n14 2.0705
R1479 vbp_cas.n12 vbp_cas.n11 1.9805
R1480 vbp_cas.n8 vbp_cas.n7 1.9805
R1481 vbp_cas.n17 vbp_cas.n16 1.0805
R1482 vbp_cas.n4 vbp_cas.n3 0.9005
R1483 vbp_cas.n11 vbp_cas.n9 0.9005
R1484 vbp_cas.n18 vbp_cas.n6 0.1805
R1485 vaux vaux.n0 72.6164
R1486 vaux.n0 vaux.t1 15.5393
R1487 vaux.n0 vaux.t2 14.1443
R1488 vaux vaux.t0 4.76719
R1489 psrg_vnc.n4 psrg_vnc.n3 83.0705
R1490 psrg_vnc.n2 psrg_vnc.t9 60.8876
R1491 psrg_vnc.n3 psrg_vnc.t11 28.7139
R1492 psrg_vnc.n0 psrg_vnc.t5 24.5053
R1493 psrg_vnc.n2 psrg_vnc.t10 24.1617
R1494 psrg_vnc.n9 psrg_vnc.n1 14.2205
R1495 psrg_vnc.n0 psrg_vnc.t4 14.212
R1496 psrg_vnc.n6 psrg_vnc.t0 13.8246
R1497 psrg_vnc.n7 psrg_vnc.t1 13.7764
R1498 psrg_vnc.n5 psrg_vnc.t8 13.7764
R1499 psrg_vnc.n9 psrg_vnc.n8 11.0255
R1500 psrg_vnc.n8 psrg_vnc.t2 9.32463
R1501 psrg_vnc.n4 psrg_vnc.t7 9.32463
R1502 psrg_vnc.n1 psrg_vnc.t6 9.26409
R1503 psrg_vnc.n1 psrg_vnc.n0 9.1805
R1504 psrg_vnc.n8 psrg_vnc.n7 6.7055
R1505 psrg_vnc.n5 psrg_vnc.n4 6.4805
R1506 psrg_vnc.n3 psrg_vnc.n2 6.3005
R1507 psrg_vnc psrg_vnc.t3 4.74363
R1508 psrg_vnc psrg_vnc.n9 4.53323
R1509 psrg_vnc.n6 psrg_vnc.n5 2.1605
R1510 psrg_vnc.n7 psrg_vnc.n6 1.9805
R1511 vgn1.n4 vgn1.n3 77.1305
R1512 vgn1.n0 vgn1.t9 49.5595
R1513 vgn1.n2 vgn1.t7 30.1539
R1514 vgn1.n3 vgn1.t5 28.6617
R1515 vgn1.n1 vgn1.t6 13.9918
R1516 vgn1.n5 vgn1.t2 13.9078
R1517 vgn1.n4 vgn1.t3 13.8139
R1518 vgn1.n6 vgn1.t4 13.8139
R1519 vgn1.n7 vgn1.t1 13.7792
R1520 vgn1 vgn1.n7 11.0795
R1521 vgn1.n0 vgn1.t8 9.39692
R1522 vgn1.n7 vgn1.n6 6.6605
R1523 vgn1.n1 vgn1.n0 6.3905
R1524 vgn1.n6 vgn1.n5 6.3005
R1525 vgn1 vgn1.t0 4.75991
R1526 vgn1.n5 vgn1.n4 2.0705
R1527 vgn1.n2 vgn1.n1 1.5305
R1528 vgn1.n3 vgn1.n2 0.5405
R1529 vx3.n1 vx3.t6 23.1445
R1530 vx3.n6 vx3.t10 20.0487
R1531 vx3.n0 vx3.t8 19.9587
R1532 vx3.n2 vx3.n1 15.1655
R1533 vx3.n2 vx3.t2 14.1559
R1534 vx3.n4 vx3.n3 13.3655
R1535 vx3.n5 vx3.n4 10.6205
R1536 vx3.n5 vx3.t1 9.3826
R1537 vx3.n4 vx3.t7 9.3826
R1538 vx3.n2 vx3.t4 9.34091
R1539 vx3.n0 vx3.t0 9.33873
R1540 vx3.n3 vx3.t3 9.28037
R1541 vx3.n1 vx3.t5 9.28037
R1542 vx3.n5 vx3.n0 5.0405
R1543 vx3.n6 vx3.n5 4.8605
R1544 vx3 vx3.t9 4.75773
R1545 vx3 vx3.n6 4.5815
R1546 vx3.n3 vx3.n2 2.1605
R1547 vx1.n0 vx1.t8 18.2487
R1548 vx1.n6 vx1.t6 16.0009
R1549 vx1.n2 vx1.t3 15.7563
R1550 vx1.n0 vx1.t0 13.9737
R1551 vx1.n2 vx1.t2 13.8409
R1552 vx1.n7 vx1.t10 13.8387
R1553 vx1.n6 vx1.t5 13.7845
R1554 vx1.n3 vx1.t4 13.7804
R1555 vx1.n4 vx1.n3 11.2055
R1556 vx1.n4 vx1.t7 9.3826
R1557 vx1.n1 vx1.t1 9.3826
R1558 vx1.n1 vx1.n0 9.3155
R1559 vx1.n8 vx1.n5 9.1355
R1560 vx1.n8 vx1.n7 9.0455
R1561 vx1.n5 vx1.n4 8.9105
R1562 vx1.n3 vx1.n2 7.5605
R1563 vx1 vx1.t9 4.75773
R1564 vx1.n5 vx1.n1 4.6355
R1565 vx1 vx1.n8 4.5815
R1566 vx1.n7 vx1.n6 2.8805
R1567 vx2.n0 vx2.t9 23.3787
R1568 vx2.n4 vx2.t2 23.2009
R1569 vx2.n2 vx2.t6 13.9737
R1570 vx2.n3 vx2.t8 13.8826
R1571 vx2.n8 vx2.n0 13.8605
R1572 vx2.n7 vx2.t0 13.8387
R1573 vx2.n1 vx2.t1 13.5063
R1574 vx2.n8 vx2.n7 11.8805
R1575 vx2.n5 vx2.n4 11.2505
R1576 vx2.n6 vx2.n5 9.6305
R1577 vx2.n0 vx2.t10 9.3826
R1578 vx2.n4 vx2.t3 9.34091
R1579 vx2.n5 vx2.t5 9.28446
R1580 vx2.n1 vx2.t4 9.27627
R1581 vx2.n2 vx2.n1 5.7605
R1582 vx2.n3 vx2.n2 4.8155
R1583 vx2 vx2.t7 4.75773
R1584 vx2.n6 vx2.n3 4.6805
R1585 vx2 vx2.n8 4.5815
R1586 vx2.n7 vx2.n6 0.1355
R1587 psrg_m3_feed.n11 psrg_m3_feed.n10 67.6607
R1588 psrg_m3_feed.n12 psrg_m3_feed.n11 51.1655
R1589 psrg_m3_feed.n0 psrg_m3_feed.t9 49.1358
R1590 psrg_m3_feed.n4 psrg_m3_feed.t15 49.0656
R1591 psrg_m3_feed.n0 psrg_m3_feed.t10 47.6958
R1592 psrg_m3_feed.n1 psrg_m3_feed.t11 47.6958
R1593 psrg_m3_feed.n2 psrg_m3_feed.t12 47.6958
R1594 psrg_m3_feed.n3 psrg_m3_feed.t13 47.6958
R1595 psrg_m3_feed.n17 psrg_m3_feed.t23 47.6913
R1596 psrg_m3_feed.n18 psrg_m3_feed.t24 47.6913
R1597 psrg_m3_feed.n19 psrg_m3_feed.t25 47.6913
R1598 psrg_m3_feed.n20 psrg_m3_feed.t26 47.6913
R1599 psrg_m3_feed.n21 psrg_m3_feed.t27 47.6913
R1600 psrg_m3_feed.n22 psrg_m3_feed.t28 47.6913
R1601 psrg_m3_feed.n4 psrg_m3_feed.t16 47.6255
R1602 psrg_m3_feed.n5 psrg_m3_feed.t17 47.6255
R1603 psrg_m3_feed.n6 psrg_m3_feed.t18 47.6255
R1604 psrg_m3_feed.n7 psrg_m3_feed.t19 47.6255
R1605 psrg_m3_feed.n24 psrg_m3_feed.t20 47.6255
R1606 psrg_m3_feed psrg_m3_feed.t14 38.6237
R1607 psrg_m3_feed.n8 psrg_m3_feed.t21 36.8148
R1608 psrg_m3_feed.n8 psrg_m3_feed.t22 35.3747
R1609 psrg_m3_feed.n10 psrg_m3_feed.t7 27.7165
R1610 psrg_m3_feed.n10 psrg_m3_feed.n9 25.5155
R1611 psrg_m3_feed.n15 psrg_m3_feed.n12 21.2855
R1612 psrg_m3_feed.n9 psrg_m3_feed.t6 15.9268
R1613 psrg_m3_feed.n13 psrg_m3_feed.t3 15.7039
R1614 psrg_m3_feed.n9 psrg_m3_feed.t5 14.0319
R1615 psrg_m3_feed.n13 psrg_m3_feed.t4 13.9142
R1616 psrg_m3_feed.n16 psrg_m3_feed.t0 13.8139
R1617 psrg_m3_feed.n14 psrg_m3_feed.t2 13.776
R1618 psrg_m3_feed.n11 psrg_m3_feed.t8 11.7515
R1619 psrg_m3_feed.n15 psrg_m3_feed.n14 11.0255
R1620 psrg_m3_feed.n15 psrg_m3_feed.t1 9.31391
R1621 psrg_m3_feed psrg_m3_feed.n25 9.2525
R1622 psrg_m3_feed.n16 psrg_m3_feed.n15 8.4605
R1623 psrg_m3_feed.n23 psrg_m3_feed.n22 4.8605
R1624 psrg_m3_feed.n25 psrg_m3_feed.n24 4.8605
R1625 psrg_m3_feed.n14 psrg_m3_feed.n13 4.5905
R1626 psrg_m3_feed.n17 psrg_m3_feed.n16 4.4105
R1627 psrg_m3_feed.n12 psrg_m3_feed.n8 3.6005
R1628 psrg_m3_feed.n22 psrg_m3_feed.n21 1.4405
R1629 psrg_m3_feed.n21 psrg_m3_feed.n20 1.4405
R1630 psrg_m3_feed.n20 psrg_m3_feed.n19 1.4405
R1631 psrg_m3_feed.n19 psrg_m3_feed.n18 1.4405
R1632 psrg_m3_feed.n18 psrg_m3_feed.n17 1.4405
R1633 psrg_m3_feed.n7 psrg_m3_feed.n6 1.4405
R1634 psrg_m3_feed.n6 psrg_m3_feed.n5 1.4405
R1635 psrg_m3_feed.n5 psrg_m3_feed.n4 1.4405
R1636 psrg_m3_feed.n3 psrg_m3_feed.n2 1.4405
R1637 psrg_m3_feed.n2 psrg_m3_feed.n1 1.4405
R1638 psrg_m3_feed.n1 psrg_m3_feed.n0 1.4405
R1639 psrg_m3_feed.n23 psrg_m3_feed.n7 1.2605
R1640 psrg_m3_feed.n25 psrg_m3_feed.n3 1.2605
R1641 psrg_m3_feed.n24 psrg_m3_feed.n23 0.1805
R1642 vbp_i.n1 vbp_i.t36 313.836
R1643 vbp_i.n1 vbp_i.t35 312.575
R1644 vbp_i.n31 vbp_i.n30 42.6605
R1645 vbp_i.n36 vbp_i.t53 31.74
R1646 vbp_i.n31 vbp_i.t48 31.5915
R1647 vbp_i.n33 vbp_i.t50 31.5915
R1648 vbp_i.n37 vbp_i.t52 31.5915
R1649 vbp_i.n32 vbp_i.t49 31.56
R1650 vbp_i.n38 vbp_i.t51 31.56
R1651 vbp_i.n35 vbp_i.t54 31.5146
R1652 vbp_i.n34 vbp_i.t56 26.4981
R1653 vbp_i.n7 vbp_i.t17 26.0243
R1654 vbp_i.n25 vbp_i.t43 26.024
R1655 vbp_i.n2 vbp_i.t11 25.9874
R1656 vbp_i.n40 vbp_i.t37 25.953
R1657 vbp_i.n20 vbp_i.t29 25.8017
R1658 vbp_i.n7 vbp_i.t18 23.1758
R1659 vbp_i.n9 vbp_i.t20 23.1758
R1660 vbp_i.n11 vbp_i.t22 23.1758
R1661 vbp_i.n14 vbp_i.t24 23.1643
R1662 vbp_i.n16 vbp_i.t26 23.1643
R1663 vbp_i.n18 vbp_i.t28 23.1643
R1664 vbp_i.n2 vbp_i.t12 23.1623
R1665 vbp_i.n4 vbp_i.t14 23.1623
R1666 vbp_i.n6 vbp_i.t16 23.1623
R1667 vbp_i.n8 vbp_i.t19 23.1443
R1668 vbp_i.n10 vbp_i.t21 23.1443
R1669 vbp_i.n20 vbp_i.t30 23.144
R1670 vbp_i.n22 vbp_i.t32 23.144
R1671 vbp_i.n24 vbp_i.t34 23.144
R1672 vbp_i.n26 vbp_i.t45 23.144
R1673 vbp_i.n28 vbp_i.t47 23.144
R1674 vbp_i.n13 vbp_i.t23 23.1328
R1675 vbp_i.n15 vbp_i.t25 23.1328
R1676 vbp_i.n17 vbp_i.t27 23.1328
R1677 vbp_i.n3 vbp_i.t13 23.1074
R1678 vbp_i.n5 vbp_i.t15 23.1074
R1679 vbp_i.n21 vbp_i.t31 23.1017
R1680 vbp_i.n23 vbp_i.t33 23.1017
R1681 vbp_i.n25 vbp_i.t44 23.0783
R1682 vbp_i.n27 vbp_i.t46 23.0783
R1683 vbp_i.n43 vbp_i.t7 23.073
R1684 vbp_i.n46 vbp_i.t39 23.073
R1685 vbp_i.n47 vbp_i.t5 23.073
R1686 vbp_i.n50 vbp_i.t40 23.073
R1687 vbp_i.n40 vbp_i.t9 23.0415
R1688 vbp_i.n45 vbp_i.t38 23.0415
R1689 vbp_i.n49 vbp_i.t3 23.0415
R1690 vbp_i.n52 vbp_i.t1 23.0415
R1691 vbp_i.n39 vbp_i.n38 17.8205
R1692 vbp_i.n0 vbp_i.t6 16.7621
R1693 vbp_i.n41 vbp_i.t10 16.6222
R1694 vbp_i.n51 vbp_i.t2 15.9472
R1695 vbp_i.n36 vbp_i.n35 14.2655
R1696 vbp_i.n30 vbp_i.t0 14.0219
R1697 vbp_i vbp_i.t41 13.9853
R1698 vbp_i.n0 vbp_i.t4 13.9672
R1699 vbp_i.n41 vbp_i.t8 13.9271
R1700 vbp_i.n34 vbp_i.t55 13.8317
R1701 vbp_i.n39 vbp_i.t42 13.8039
R1702 vbp_i.n19 vbp_i.n18 12.6455
R1703 vbp_i vbp_i.n52 11.7883
R1704 vbp_i.n13 vbp_i.n12 7.4705
R1705 vbp_i.n30 vbp_i.n29 5.7605
R1706 vbp_i.n47 vbp_i.n46 5.5805
R1707 vbp_i.n12 vbp_i.n6 5.4005
R1708 vbp_i.n29 vbp_i.n24 4.8605
R1709 vbp_i.n35 vbp_i.n34 4.1405
R1710 vbp_i.n23 vbp_i.n22 2.8805
R1711 vbp_i.n21 vbp_i.n20 2.8805
R1712 vbp_i.n17 vbp_i.n16 2.8805
R1713 vbp_i.n15 vbp_i.n14 2.8805
R1714 vbp_i.n11 vbp_i.n10 2.8805
R1715 vbp_i.n9 vbp_i.n8 2.8805
R1716 vbp_i.n6 vbp_i.n5 2.8805
R1717 vbp_i.n4 vbp_i.n3 2.8805
R1718 vbp_i.n27 vbp_i.n26 2.8805
R1719 vbp_i.n50 vbp_i.n49 2.7005
R1720 vbp_i.n46 vbp_i.n45 2.7005
R1721 vbp_i.n24 vbp_i.n23 2.7005
R1722 vbp_i.n22 vbp_i.n21 2.7005
R1723 vbp_i.n18 vbp_i.n17 2.7005
R1724 vbp_i.n16 vbp_i.n15 2.7005
R1725 vbp_i.n14 vbp_i.n13 2.7005
R1726 vbp_i.n10 vbp_i.n9 2.7005
R1727 vbp_i.n8 vbp_i.n7 2.7005
R1728 vbp_i.n5 vbp_i.n4 2.7005
R1729 vbp_i.n3 vbp_i.n2 2.7005
R1730 vbp_i.n28 vbp_i.n27 2.7005
R1731 vbp_i.n26 vbp_i.n25 2.7005
R1732 vbp_i.n19 vbp_i.n1 2.1605
R1733 vbp_i.n51 vbp_i.n50 1.9805
R1734 vbp_i.n48 vbp_i.n47 1.9805
R1735 vbp_i.n38 vbp_i.n33 1.9805
R1736 vbp_i.n32 vbp_i.n31 1.9805
R1737 vbp_i.n42 vbp_i.n41 1.8905
R1738 vbp_i.n48 vbp_i.n0 1.8905
R1739 vbp_i.n24 vbp_i.n19 1.8905
R1740 vbp_i.n45 vbp_i.n44 1.8005
R1741 vbp_i.n42 vbp_i.n40 1.8005
R1742 vbp_i.n37 vbp_i.n36 1.8005
R1743 vbp_i.n38 vbp_i.n37 1.8005
R1744 vbp_i.n33 vbp_i.n32 1.8005
R1745 vbp_i.n44 vbp_i.n39 1.6205
R1746 vbp_i.n44 vbp_i.n43 1.0805
R1747 vbp_i.n52 vbp_i.n51 0.9005
R1748 vbp_i.n49 vbp_i.n48 0.9005
R1749 vbp_i.n43 vbp_i.n42 0.9005
R1750 vbp_i.n29 vbp_i.n28 0.6305
R1751 vbp_i.n12 vbp_i.n11 0.1805
R1752 b3_b b3_b.t2 413.057
R1753 b3_b.n0 b3_b.t1 30.5101
R1754 b3_b.n0 b3_b.t0 18.2995
R1755 b3_b b3_b.n0 11.9367
R1756 b1_b.n1 b1_b.t2 552.784
R1757 b1_b.n2 b1_b.t3 552.491
R1758 b1_b b1_b.t4 543.413
R1759 b1_b.n0 b1_b.t0 19.0513
R1760 b1_b.n0 b1_b.t1 17.9371
R1761 b1_b b1_b.n2 9.91021
R1762 b1_b.n1 b1_b.n0 7.6505
R1763 b1_b.n2 b1_b.n1 0.7205
R1764 vq3.n0 vq3 86.063
R1765 vq3.n0 vq3.t0 28.5582
R1766 vq3 vq3.n1 21.2567
R1767 vq3.n1 vq3.n0 14.3555
R1768 vq3.n1 vq3.t2 13.5475
R1769 vq3 vq3.t1 5.63583
R1770 b6_b b6_b.t2 70.8681
R1771 b6_b.n0 b6_b.t0 27.1512
R1772 b6_b.n0 b6_b.t1 24.2956
R1773 b6_b b6_b.n0 8.52575
R1774 b4_b b4_b.t2 217.519
R1775 b4_b.n0 b4_b.t0 38.4035
R1776 b4_b.n0 b4_b.t1 20.5606
R1777 b4_b b4_b.n0 19.2897
R1778 b0_b.n1 b0_b.t2 552.495
R1779 b0_b.n3 b0_b.t4 552.482
R1780 b0_b.n2 b0_b.t3 552.424
R1781 b0_b.n4 b0_b.t5 547.922
R1782 b0_b.n5 b0_b.t6 547.922
R1783 b0_b b0_b.t7 543.413
R1784 b0_b.n0 b0_b.t1 21.7749
R1785 b0_b.n0 b0_b.t0 18.3369
R1786 b0_b b0_b.n5 14.4612
R1787 b0_b.n5 b0_b.n4 10.0805
R1788 b0_b.n1 b0_b.n0 5.8055
R1789 b0_b.n4 b0_b.n3 5.4005
R1790 b0_b.n3 b0_b.n2 1.0805
R1791 b0_b.n2 b0_b.n1 1.0805
R1792 rbit0top.n1 rbit0top.t7 47.8149
R1793 rbit0top.n1 rbit0top.t0 27.35
R1794 rbit0top.n2 rbit0top.n1 24.7955
R1795 rbit0top.n0 rbit0top.t8 14.9729
R1796 rbit0top.n3 rbit0top.t6 13.6904
R1797 rbit0top.n0 rbit0top.t9 13.6898
R1798 rbit0top.n5 rbit0top.t5 13.6634
R1799 rbit0top.n7 rbit0top.t1 13.6544
R1800 rbit0top.n4 rbit0top.t3 13.6145
R1801 rbit0top rbit0top.n7 10.3573
R1802 rbit0top.n6 rbit0top.n0 10.2155
R1803 rbit0top.n2 rbit0top.t4 9.11555
R1804 rbit0top.n3 rbit0top.n2 5.7605
R1805 rbit0top rbit0top.t2 4.60718
R1806 rbit0top.n5 rbit0top.n4 1.2605
R1807 rbit0top.n4 rbit0top.n3 1.0805
R1808 rbit0top.n6 rbit0top.n5 0.8105
R1809 rbit0top.n7 rbit0top.n6 0.2705
R1810 rbit1top.n2 rbit1top.n1 31.9505
R1811 rbit1top.n1 rbit1top.t11 22.274
R1812 rbit1top.n0 rbit1top.t13 14.8598
R1813 rbit1top.n7 rbit1top.t8 13.8254
R1814 rbit1top.n9 rbit1top.t6 13.7984
R1815 rbit1top.n10 rbit1top.t5 13.7894
R1816 rbit1top.n2 rbit1top.t10 13.7888
R1817 rbit1top.n0 rbit1top.t12 13.7579
R1818 rbit1top.n8 rbit1top.t7 13.7495
R1819 rbit1top.n3 rbit1top.t2 13.6949
R1820 rbit1top.n5 rbit1top.t1 13.6724
R1821 rbit1top.n6 rbit1top.t9 13.6155
R1822 rbit1top.n4 rbit1top.t3 13.6152
R1823 rbit1top.n11 rbit1top.n0 10.3055
R1824 rbit1top.n1 rbit1top.t0 10.142
R1825 rbit1top rbit1top.n11 9.00729
R1826 rbit1top rbit1top.t4 4.60718
R1827 rbit1top.n3 rbit1top.n2 1.5305
R1828 rbit1top.n5 rbit1top.n4 1.2605
R1829 rbit1top.n4 rbit1top.n3 1.2605
R1830 rbit1top.n11 rbit1top.n10 1.2155
R1831 rbit1top.n7 rbit1top.n6 1.1705
R1832 rbit1top.n6 rbit1top.n5 1.0805
R1833 rbit1top.n9 rbit1top.n8 1.0805
R1834 rbit1top.n10 rbit1top.n9 0.9005
R1835 rbit1top.n8 rbit1top.n7 0.9005
R1836 rbit2top.n1 rbit2top.n0 34.9521
R1837 rbit2top.n0 rbit2top.t8 25.739
R1838 rbit2top.n4 rbit2top.t2 15.0003
R1839 rbit2top.n5 rbit2top.t0 13.9426
R1840 rbit2top.n4 rbit2top.t1 13.9336
R1841 rbit2top.n6 rbit2top.t9 13.8011
R1842 rbit2top.n3 rbit2top.t4 13.7502
R1843 rbit2top.n2 rbit2top.t5 13.6949
R1844 rbit2top.n7 rbit2top.n6 11.9255
R1845 rbit2top.n6 rbit2top.n5 10.6655
R1846 rbit2top.n0 rbit2top.t6 10.106
R1847 rbit2top rbit2top.n7 9.20075
R1848 rbit2top.n1 rbit2top.t7 9.11557
R1849 rbit2top.n2 rbit2top.n1 5.5805
R1850 rbit2top rbit2top.t3 4.60718
R1851 rbit2top.n3 rbit2top.n2 1.1705
R1852 rbit2top.n7 rbit2top.n3 1.0805
R1853 rbit2top.n5 rbit2top.n4 0.9005
R1854 b2_b.n1 b2_b.t2 291.709
R1855 b2_b.n2 b2_b.t3 291.709
R1856 b2_b b2_b.t4 282.7
R1857 b2_b.n0 b2_b.t1 29.7878
R1858 b2_b.n1 b2_b.n0 29.7455
R1859 b2_b b2_b.n2 9.96125
R1860 b2_b.n0 b2_b.t0 9.37191
R1861 b2_b.n2 b2_b.n1 1.0805
R1862 rbit6top.n2 rbit6top.t2 20.1082
R1863 rbit6top rbit6top.n3 16.4243
R1864 rbit6top.n2 rbit6top.t1 16.2905
R1865 rbit6top.n3 rbit6top.n0 11.8353
R1866 rbit6top.n3 rbit6top.t3 10.197
R1867 rbit6top.n1 rbit6top.n2 9.5405
R1868 rbit6top.n1 rbit6top.t5 9.02203
R1869 rbit6top.n1 rbit6top.n0 4.4644
R1870 rbit6top rbit6top.t0 5.06817
R1871 rbit6top.n0 rbit6top.t4 17.5032
R1872 rbit5top.n2 rbit5top.n1 30.1505
R1873 rbit5top rbit5top.t4 29.4175
R1874 rbit5top.n1 rbit5top.t2 28.961
R1875 rbit5top rbit5top.n2 16.7383
R1876 rbit5top.n2 rbit5top.n0 12.9155
R1877 rbit5top.n0 rbit5top.t0 11.3205
R1878 rbit5top.n0 rbit5top.t3 9.9581
R1879 rbit5top.n1 rbit5top.t1 5.59703
R1880 rbit5top rbit5top.t5 4.78433
R1881 b5_b b5_b.t2 119.752
R1882 b5_b b5_b.n0 34.8211
R1883 b5_b.n0 b5_b.t1 31.9875
R1884 b5_b.n0 b5_b.t0 9.33465
R1885 rbit3top.n0 rbit3top.t1 38.816
R1886 rbit3top.n3 rbit3top.n0 34.9205
R1887 rbit3top.n1 rbit3top.t5 18.735
R1888 rbit3top.n0 rbit3top.t6 15.7715
R1889 rbit3top.n5 rbit3top.n4 15.2105
R1890 rbit3top.n1 rbit3top.t2 13.9653
R1891 rbit3top.n4 rbit3top.t4 13.8076
R1892 rbit3top.n2 rbit3top.t3 13.7986
R1893 rbit3top rbit3top.n5 12.5895
R1894 rbit3top.n5 rbit3top.t7 9.43613
R1895 rbit3top rbit3top.t0 4.64242
R1896 rbit3top.n2 rbit3top.n1 1.0805
R1897 rbit3top.n3 rbit3top.n2 0.9905
R1898 rbit3top.n4 rbit3top.n3 0.1355
R1899 rbit4top.n2 rbit4top.t4 31.76
R1900 rbit4top.n3 rbit4top.n2 20.2505
R1901 rbit4top.n0 rbit4top.t3 17.61
R1902 rbit4top.n1 rbit4top.n0 17.0555
R1903 rbit4top.n0 rbit4top.t2 14.5188
R1904 rbit4top.n1 rbit4top.t5 13.9981
R1905 rbit4top.n3 rbit4top.n1 12.2405
R1906 rbit4top.n2 rbit4top.t0 10.097
R1907 rbit4top rbit4top.t1 4.64242
R1908 rbit4top rbit4top.n3 4.53446
C0 rbit6top rbit0top 0.17868f
C1 rfix1 vref 0.46182f
C2 vsua v2 5.67754f
C3 vsu xf1 2.29109f
C4 y1 avdd 45.8673f
C5 vref vgn1 0.17203f
C6 b1_b b6 0.17833f
C7 psrg_m3_feed vx2 7.14245f
C8 rbit0top dvss 4.70472f
C9 vsua psrg_m3_feed 0.11359f
C10 v1 avdd 10.91031f
C11 rbit2top b2 0.27743f
C12 b2_b b1 0.16476f
C13 vsu1 vref 0.69731f
C14 v2 psrg_m3_feed 0.87255f
C15 vgn1 avdd 12.8104f
C16 b4 b5 0.42193f
C17 vbp_bias vsua 0.41567f
C18 vbp_cas avdd 85.0735f
C19 vbp_bias v2 1.85827f
C20 rbit1top dvss 6.97599f
C21 vsu1 avdd 2.41666f
C22 vsu vbn 0.69666f
C23 vbn_i xf1 0.23103f
C24 vbp_bias psrg_m3_feed 0.30002f
C25 vbn_sink vsua 1.15008f
C26 vbn_sink v2 0.23826f
C27 dvss b1 1.36969f
C28 b3 b6 0.90244f
C29 avdd pm2 29.349f
C30 xf2 vbn_fold 1.89587f
C31 vsua vbp_i 1.30631f
C32 net3 avdd 8.57008f
C33 iref_gate avdd 23.0842f
C34 vbp_i v2 0.48824f
C35 vsp vsu 0.70595f
C36 vbn_sink psrg_m3_feed 1.44591f
C37 b0_b b3 0.44758f
C38 vbp_i psrg_m3_feed 1.83774f
C39 rbit4top rbit5top 2.55451f
C40 vx3 vx2 0.53405f
C41 rbit1top b1_b 1.0224f
C42 vbn_sink vbp_bias 0.7885f
C43 psrg_mf1_protected psrg_vnc 0.77161f
C44 b6_b b1 0.16865f
C45 vbp_bias vbp_i 0.90238f
C46 xf2 vbp_tail 0.59954f
C47 dvdd b2 2.86524f
C48 rbit4top b4_b 0.52889f
C49 psrg_vnc vbn 0.3336f
C50 y1 vbn_fold 0.93704f
C51 b1_b b1 1.99506f
C52 vsp vbn_i 0.56742f
C53 rbit0top b3 0.45793f
C54 vx3 psrg_m3_feed 4.62559f
C55 vcasp vbn 4.01634f
C56 vbn_fold v1 0.53716f
C57 vaux psrg_m3_feed 0.78364f
C58 vbn_fold vgn1 0.14647f
C59 vbn_sink vbp_i 18.2491f
C60 rbit4top rbit2top 1.33249f
C61 vq2 avdd 0.26912f
C62 vbn vgn2 0.10733f
C63 rfix2 rbit2top 0.47492f
C64 rbit1top b3 0.38141f
C65 aux_gate avdd 4.74183f
C66 vsu v2 0.62334f
C67 b4 b2 0.12242f
C68 vbp_tail v1 1.42346f
C69 vsu psrg_m3_feed 1.26952f
C70 rbit0top rfix0 0.19661f
C71 vbp_tail vbp_cas 0.14568f
C72 vbn_sink vaux 0.30193f
C73 vref rfix2 0.46704f
C74 b3 b1 0.15208f
C75 avdd pm1 28.2695f
C76 b0 b0_b 1.57273f
C77 iref_gate vbn_fold 0.67174f
C78 vbp_i vaux 2.72714f
C79 vq3 rbit5top 0.11707f
C80 vbn_i v2 0.98248f
C81 vgn1 vx1 1.70214f
C82 vbp_tail net3 1.05691f
C83 b0 rbit0top 1.14536f
C84 vbn_i psrg_m3_feed 0.19341f
C85 iref_gate vbp_tail 2.77582f
C86 vbn_sink vsu 2.45374f
C87 psrg_vnc v2 0.32706f
C88 rbit4top dvdd 5.19344f
C89 vcasp vx2 4.74669f
C90 vbp_i vsu 2.38741f
C91 vbp_bias vbn_i 0.99182f
C92 vsua vcasp 0.66686f
C93 rbit4top b3_b 0.30008f
C94 xf2 y1 0.5573f
C95 psrg_vnc psrg_m3_feed 1.9522f
C96 vcasp v2 0.30909f
C97 b0 rbit1top 0.957f
C98 xf2 v1 1.09173f
C99 vcasp psrg_m3_feed 5.42682f
C100 vbn_sink vbn_i 0.83284f
C101 v2 vgn2 1.41491f
C102 xf2 vbp_cas 0.14767f
C103 vbp_i vbn_i 9.69237f
C104 vbn_fold aux_gate 0.37711f
C105 vbp_bias vcasp 1.35528f
C106 b0 b1 0.28169f
C107 b5 b2 0.9131f
C108 vq3 avdd 2.66812f
C109 rbit4top b4 0.15644f
C110 b5_b rbit5top 0.32035f
C111 vbn_sink psrg_vnc 1.69866f
C112 vbp_bias vgn2 0.13232f
C113 vbp_i psrg_vnc 9.34187f
C114 b4_b b5_b 0.13196f
C115 y1 v1 0.18075f
C116 vbp_tail aux_gate 1.10491f
C117 xf2 iref_gate 1.57776f
C118 vbn_i vaux 1.03639f
C119 y1 vbp_cas 8.72994f
C120 vbp_i vcasp 0.28897f
C121 b0_b b6 0.2305f
C122 rbit3top rbit5top 5.14549f
C123 v1 vgn1 1.69439f
C124 dvdd vq3 0.5542f
C125 vbn_sink vgn2 0.17331f
C126 v1 vbp_cas 1.66248f
C127 b2_b rbit5top 0.25686f
C128 b4_b rbit3top 0.16324f
C129 vbp_cas vgn1 1.21775f
C130 vaux psrg_vnc 0.1036f
C131 vbp_i vgn2 1.66359f
C132 vbp_i net4 0.58849f
C133 y1 pm2 8.97178f
C134 vsu1 vgn1 0.18706f
C135 vcasp vx3 4.7896f
C136 vsu vbn_i 0.27068f
C137 iref_gate y1 0.10436f
C138 rbit0top b6 0.29145f
C139 aux_gate rb_mid 0.18215f
C140 vcasp vaux 0.65066f
C141 rbit6top rbit5top 1.10728f
C142 rbit2top rbit3top 5.74056f
C143 iref_gate v1 0.47074f
C144 rbit0top b0_b 2.17947f
C145 vbp_cas pm2 9.66366f
C146 vaux vgn2 0.16213f
C147 b4 vq3 0.10345f
C148 b2_b rbit2top 0.62978f
C149 rbit5top dvss 1.32043f
C150 vaux net4 0.26336f
C151 rbit1top b6 0.3938f
C152 b4_b dvss 0.54131f
C153 vsu vcasp 0.16003f
C154 rbit1top b0_b 2.10537f
C155 rbit6top rbit2top 0.27808f
C156 dvdd b5_b 0.80368f
C157 vbn_i psrg_vnc 1.20977f
C158 rbit2top dvss 3.44856f
C159 b4_b b6_b 0.55781f
C160 rbit5top b1_b 0.14972f
C161 b5_b b3_b 0.1262f
C162 vbn_i vcasp 0.41266f
C163 rbit1top rbit0top 17.3003f
C164 vq2 v1 0.22239f
C165 dvdd rbit3top 9.14379f
C166 vq2 vbp_cas 0.11777f
C167 vbn_i vgn2 0.51005f
C168 y1 pm1 8.3798f
C169 aux_gate vgn1 1.56319f
C170 vbn_i net4 0.41992f
C171 vcasp psrg_vnc 0.6292f
C172 rbit3top b3_b 0.474f
C173 rbit0top b1 0.3846f
C174 dvdd b2_b 2.90137f
C175 aux_gate vbp_cas 0.21008f
C176 b4 b5_b 2.37219f
C177 rb_mid vq3 0.10871f
C178 b2_b b3_b 0.12166f
C179 rbit2top b1_b 1.01233f
C180 psrg_vnc vgn2 0.73289f
C181 net4 psrg_vnc 0.71795f
C182 vbp_cas pm1 7.95308f
C183 rbit5top b3 0.31365f
C184 dvdd rbit6top 3.47008f
C185 rfix1 rfix2 0.12712f
C186 rbit1top b1 0.8303f
C187 b4_b b3 0.15984f
C188 dvdd dvss 5.19427f
C189 avdd xf1 25.8176f
C190 b4 b2_b 0.15741f
C191 dvss b3_b 0.58031f
C192 pm2 pm1 6.96945f
C193 rbit4top b2 0.11838f
C194 psrg_mf1_protected avdd 0.147f
C195 b6_b dvdd 0.8878f
C196 avdd vbn 4.68956f
C197 b6_b b3_b 0.12432f
C198 y1 vq3 1.40122f
C199 dvdd b1_b 1.76233f
C200 b4 dvss 1.18675f
C201 v1 vq3 0.68781f
C202 b5 b5_b 0.71797f
C203 b0 rbit5top 0.65409f
C204 vsp avdd 67.7775f
C205 rbit2top rfix0 0.43835f
C206 b6_b b4 0.20318f
C207 vref rfix0 0.4317f
C208 b5 rbit3top 0.11636f
C209 dvdd b3 2.24128f
C210 vq3 b2 0.53362f
C211 vq3 pm2 1.02779f
C212 vbn_fold xf1 0.97203f
C213 vref vx2 0.34943f
C214 b0 rbit2top 0.53646f
C215 b3 b3_b 0.30195f
C216 avdd vx2 22.3199f
C217 psrg_mf1_protected vbn_fold 0.73665f
C218 vbp_tail xf1 0.42214f
C219 vsua avdd 6.92823f
C220 vref psrg_m3_feed 0.78711f
C221 b5 rbit6top 0.24355f
C222 vbn_fold vbn 0.19159f
C223 auxsu2 auxsu1 0.22066f
C224 avdd v2 11.518f
C225 b5 dvss 1.86594f
C226 b4 b3 2.21699f
C227 avdd psrg_m3_feed 49.37762f
C228 vbp_bias avdd 79.66632f
C229 vbp_tail vbn 0.12319f
C230 vq2 vq3 0.59576f
C231 vbp_i vref 0.16971f
C232 dvdd b0 2.27068f
C233 rbit5top b6 0.16596f
C234 vbn_sink avdd 43.3135f
C235 vsp vbp_tail 7.87899f
C236 b4_b b6 0.14274f
C237 vq3 pm1 0.29607f
C238 vbp_i avdd 0.19559p
C239 b0_b rbit5top 0.11709f
C240 rbit4top vq3 0.14224f
C241 vref vx3 1.98951f
C242 su_state vbn 0.30574f
C243 xf2 xf1 4.06665f
C244 rbit3top b2 0.28452f
C245 b2_b b2 0.6365f
C246 vx3 avdd 21.3216f
C247 rbit0top rbit5top 0.17686f
C248 vaux avdd 7.21322f
C249 vbn_fold v2 0.21234f
C250 rbit2top b0_b 0.12093f
C251 bgsu1 bgsu2 0.25045f
C252 b5 b3 0.54458f
C253 y1 xf1 3.57794f
C254 vbn_fold psrg_m3_feed 5.46551f
C255 rbit6top b2 0.32495f
C256 vsua vbp_tail 1.2915f
C257 v1 xf1 10.2886f
C258 vbp_tail v2 0.87659f
C259 dvss b2 1.03242f
C260 vsu avdd 6.58151f
C261 rbit2top rbit0top 1.90102f
C262 vsp xf2 5.00461f
C263 psrg_mf1_protected y1 0.37904f
C264 vx2 vx1 1.13125f
C265 vbn_sink vbn_fold 1.42754f
C266 vbp_bias vbp_tail 0.30831f
C267 b4_b b1 0.20282f
C268 psrg_m3_protected v2 0.48573f
C269 vref rbit0top 2.24313f
C270 vbp_i vbn_fold 11.7335f
C271 v1 vbn 0.14603f
C272 dvdd b6 2.34839f
C273 rbit2top rbit1top 9.50587f
C274 vgn1 vbn 0.53286f
C275 vbp_cas vbn 1.19828f
C276 iref_gate xf1 1.33023f
C277 vbn_i avdd 16.6478f
C278 b3_b b6 0.56436f
C279 psrg_m3_protected psrg_m3_feed 0.49036f
C280 psrg_m3_feed vx1 4.99211f
C281 rbit0top avdd 0.11793f
C282 rbit4top rbit3top 3.7785f
C283 vbn_sink vbp_tail 1.51169f
C284 dvdd b0_b 4.34098f
C285 rb_mid psrg_m3_feed 0.10281f
C286 vref rbit1top 2.25566f
C287 rbit2top b1 0.99261f
C288 vsp v1 10.4163f
C289 vbp_i vbp_tail 2.00872f
C290 vcasp vref 4.61112f
C291 psrg_vnc avdd 20.5436f
C292 rbit4top b2_b 0.17164f
C293 b0_b b3_b 0.16655f
C294 vsua xf2 0.12641f
C295 rbit1top avdd 0.17165f
C296 xf2 v2 10.402f
C297 vcasp avdd 35.3456f
C298 iref_gate vbn 0.11992f
C299 b4 b6 0.12464f
C300 dvdd rbit0top 18.1015f
C301 net4 vref 0.1281f
C302 rbit4top rbit6top 0.61408f
C303 xf2 psrg_m3_feed 0.33254f
C304 vsu bgsu1 0.57239f
C305 b3 b2 0.52757f
C306 avdd vgn2 19.8834f
C307 b4 b0_b 0.21404f
C308 vsu vbn_fold 0.36465f
C309 net4 avdd 3.35642f
C310 rfix1 rfix0 0.12694f
C311 vbp_bias xf2 0.32017f
C312 vsp net3 0.14854f
C313 rbit4top dvss 2.43979f
C314 vsp iref_gate 0.73451f
C315 vsua y1 1.43812f
C316 dvdd rbit1top 25.3609f
C317 y1 v2 1.84313f
C318 vsu2 psrg_m3_feed 0.14487f
C319 vgn1 vx2 0.65346f
C320 vx3 vx1 1.91562f
C321 vsua v1 2.87816f
C322 vsu vnx_bias 0.15585f
C323 v1 v2 7.8404f
C324 b4 rbit0top 0.26882f
C325 y1 psrg_m3_feed 0.36919f
C326 vsu vbp_tail 0.1293f
C327 vbn_sink xf2 6.9701f
C328 dvdd b1 2.00117f
C329 vsua vbp_cas 3.58038f
C330 vbn_i vbn_fold 1.89286f
C331 vsu1 vx2 0.4737f
C332 vbp_bias y1 0.79323f
C333 vbp_cas v2 3.1921f
C334 b3_b b1 0.19611f
C335 vq3 b2_b 0.17063f
C336 v1 psrg_m3_feed 0.72526f
C337 vgn1 psrg_m3_feed 1.05141f
C338 aux_gate vbn 0.32604f
C339 vbp_bias v1 1.72122f
C340 vbp_cas psrg_m3_feed 0.99915f
C341 vbn_fold psrg_vnc 0.16832f
C342 b4 rbit1top 0.30293f
C343 vbp_bias vgn1 0.34369f
C344 vbp_bias vbp_cas 14.834f
C345 vsua pm2 0.22197f
C346 vbp_i vsu2 2.82303f
C347 vbn_i vbp_tail 4.35253f
C348 vbn_sink y1 1.23295f
C349 su_state vsu 0.16289f
C350 vq3 rbit6top 3.4956f
C351 net3 v2 0.55684f
C352 vbp_i y1 2.67429f
C353 iref_gate v2 0.64906f
C354 vbp_bias vsu1 0.89697f
C355 b0 b2 0.23544f
C356 b5 b6 0.72955f
C357 vbn_sink v1 0.23339f
C358 vq3 dvss 0.47982f
C359 vbp_tail psrg_vnc 1.12479f
C360 vbp_i v1 1.34899f
C361 iref_gate psrg_m3_feed 1.04746f
C362 vbn_fold vgn2 0.97834f
C363 vbn_sink vbp_cas 0.61071f
C364 vbp_i vgn1 0.71025f
C365 vbp_bias pm2 0.17135f
C366 vnx_bias vcasp 0.14922f
C367 vbn_i psrg_m3_protected 0.15324f
C368 vbp_bias net3 0.14653f
C369 b5 b0_b 0.18986f
C370 vbp_bias iref_gate 0.12644f
C371 vbp_i vbp_cas 2.95803f
C372 rbit4top b3 1.99837f
C373 xf2 vsu 1.74246f
C374 y1 vaux 0.1621f
C375 b6_b vq3 0.36188f
C376 vbp_i vsu1 0.21392f
C377 rbit3top b5_b 0.10459f
C378 psrg_m3_protected psrg_vnc 1.29451f
C379 vx3 vgn1 0.10755f
C380 b5 rbit0top 0.25231f
C381 vbn_sink net3 0.16702f
C382 vbn_sink iref_gate 2.54328f
C383 rb_mid psrg_vnc 0.71601f
C384 vbp_i pm2 0.84094f
C385 vbp_i net3 2.05358f
C386 vsua vq2 1.1273f
C387 vcasp vx1 4.40079f
C388 vaux vbp_cas 3.00971f
C389 vbp_i iref_gate 6.10108f
C390 vsu1 vx3 0.18446f
C391 rbit4top rfix0 0.13622f
C392 xf2 vbn_i 0.51739f
C393 vcasp rb_mid 0.77152f
C394 psrg_m3_protected vgn2 1.38012f
C395 vq2 psrg_m3_feed 2.83114f
C396 b5 rbit1top 0.26006f
C397 rbit6top b5_b 0.18433f
C398 b2_b rbit3top 1.34734f
C399 vsu v1 0.4387f
C400 vsua pm1 0.2777f
C401 vbp_bias vq2 0.53956f
C402 aux_gate psrg_m3_feed 0.86845f
C403 vaux pm2 0.16405f
C404 su_state vgn2 0.12642f
C405 b5_b dvss 1.27577f
C406 vsu vbp_cas 1.2965f
C407 vq3 b3 0.74007f
C408 rbit4top b0 0.27314f
C409 rbit6top rbit3top 0.66471f
C410 vbp_bias pm1 0.6745f
C411 b4_b rbit5top 0.61845f
C412 rbit3top dvss 2.4747f
C413 rbit6top b2_b 0.2309f
C414 vbn_i v1 1.73482f
C415 xf2 vgn2 0.14172f
C416 vbn_i vgn1 4.93995f
C417 y1 psrg_vnc 1.08148f
C418 rfix1 rbit0top 0.23203f
C419 vsu iref_gate 3.80229f
C420 vbn_i vbp_cas 0.54832f
C421 b2_b dvss 1.28816f
C422 vsu2 vcasp 0.13989f
C423 vbp_i aux_gate 0.22855f
C424 b5_b b1_b 0.2518f
C425 b0_b b2 0.49542f
C426 v1 psrg_vnc 0.17954f
C427 vgn1 psrg_vnc 0.49843f
C428 vq3 rfix0 2.74037f
C429 rbit2top rbit5top 0.12871f
C430 b6_b rbit3top 0.10116f
C431 vbp_cas psrg_vnc 2.86812f
C432 vbp_i pm1 1.51803f
C433 vcasp v1 0.16656f
C434 rbit6top dvss 1.23274f
C435 y1 vgn2 1.53651f
C436 y1 net4 0.81469f
C437 vbn_i net3 0.17037f
C438 vcasp vgn1 12.0098f
C439 iref_gate vbn_i 0.66186f
C440 rbit0top b2 0.27841f
C441 vcasp vbp_cas 2.22645f
C442 vsu1 vcasp 1.96884f
C443 psrg_vnc pm2 0.48016f
C444 net4 vgn1 3.05824f
C445 vaux pm1 0.16751f
C446 vbp_cas vgn2 9.77084f
C447 vbp_cas net4 2.69442f
C448 b5_b b3 0.18047f
C449 b6_b rbit6top 0.131f
C450 vq3 psrg_m3_feed 0.21313f
C451 vsu vq2 0.18863f
C452 rbit1top b2 0.59167f
C453 b6_b dvss 1.21805f
C454 vbp_bias vq3 0.55054f
C455 vsu aux_gate 0.15823f
C456 rbit6top b1_b 0.52663f
C457 vref rbit2top 1.94986f
C458 b2 b1 0.61743f
C459 dvss b1_b 0.52319f
C460 pm2 vgn2 1.26867f
C461 rbit3top b3 0.3502f
C462 rbit4top b6 0.35598f
C463 net3 net4 0.16306f
C464 dvdd rbit5top 3.14552f
C465 b2_b b3 0.85836f
C466 b4_b dvdd 1.92628f
C467 vbp_i vq3 1.93119f
C468 vbn_i aux_gate 3.67685f
C469 rbit4top b0_b 0.10644f
C470 b4_b b3_b 0.35529f
C471 b6_b b1_b 0.2092f
C472 vref avdd 8.862f
C473 rbit6top b3 0.19696f
C474 aux_gate psrg_vnc 0.82529f
C475 dvdd rbit2top 14.9668f
C476 dvss b3 1.77121f
C477 b4 rbit5top 0.3222f
C478 vcasp aux_gate 5.46621f
C479 psrg_vnc pm1 1.85879f
C480 b4_b b4 0.43695f
C481 rfix2 rbit0top 0.24932f
C482 aux_gate vgn2 0.16589f
C483 b6_b b3 0.18423f
C484 b0 rbit3top 0.26929f
C485 rbit6top rfix0 0.2312f
C486 vq3 b6 0.34769f
C487 vsp xf1 4.18477f
C488 b0 b2_b 0.66587f
C489 b4 rbit2top 0.1416f
C490 vgn2 pm1 0.91122f
C491 b0 rbit6top 0.35839f
C492 dvdd b3_b 1.03536f
C493 b0 dvss 1.53675f
C494 psrg_vnc vq3 0.75791f
C495 vbn_fold avdd 33.2305f
C496 b5 rbit5top 0.14245f
C497 b4_b b5 0.53647f
C498 xf1 v2 0.27167f
C499 vcasp vq3 0.29662f
C500 dvdd b4 2.07965f
C501 b5_b b6 0.12009f
C502 vnx_bias avdd 0.38636f
C503 xf1 psrg_m3_feed 0.36299f
C504 vbp_tail avdd 44.571f
C505 b0 b1_b 0.11519f
C506 vbp_bias xf1 0.26006f
C507 net4 vq3 0.41149f
C508 vref vx1 0.59719f
C509 vbn v2 0.32277f
C510 rbit3top b6 0.24596f
C511 psrg_m3_protected avdd 0.30122f
C512 avdd vx1 23.4275f
C513 vbn psrg_m3_feed 0.24799f
C514 vbn_sink xf1 6.67601f
C515 su_state avdd 0.55904f
C516 rb_mid avdd 0.66006f
C517 vsp vsua 0.14888f
C518 vbp_bias vbn 0.13373f
C519 vbp_i xf1 0.73622f
C520 vsp v2 10.8438f
C521 b2_b b0_b 0.36389f
C522 b0 b3 0.1162f
C523 rbit6top b6 0.17396f
C524 vsp psrg_m3_feed 0.30111f
C525 rbit0top rbit3top 0.15601f
C526 vsp vbp_bias 0.48005f
C527 dvss b6 1.64038f
C528 vsua auxsu1 0.24101f
C529 xf2 avdd 24.9025f
C530 rbit6top b0_b 0.40629f
C531 vbp_i vbn 1.35237f
C532 dvdd b5 1.99811f
C533 vnx_bias vbn_fold 0.37466f
C534 rbit5top b2 0.15945f
C535 rfix1 rbit2top 0.47013f
C536 b0_b dvss 0.65552f
C537 vbp_tail vbn_fold 0.20027f
C538 b5 b3_b 0.13851f
C539 rbit1top rbit3top 0.11666f
C540 b6_b b6 0.44031f
C541 vsu2 avdd 0.18862f
C542 vref avss 3.13665p
C543 b1 avss 5.04694f
C544 b2 avss 3.67792f
C545 b6 avss 4.92695f
C546 b5 avss 3.58262f
C547 b0 avss 5.77976f
C548 b4 avss 4.7852f
C549 b3 avss 5.54149f
C550 avdd avss 4.07042p
C551 dvss avss 32.97154f
C552 dvdd avss 0.23269p
C553 psrg_mf1_protected avss 2.4594f
C554 su_state avss 1.62579f
C555 auxsu1 avss 8.10797f
C556 xf1 avss 15.88752f
C557 vsp avss 5.26613f
C558 iref_gate avss 10.37508f
C559 vsu avss 0.21799f
C560 xf2 avss 15.39397f
C561 vbn_fold avss 15.49205f
C562 vbp_tail avss 21.96162f
C563 psrg_m3_protected avss 4.31779f
C564 v2 avss 11.25823f
C565 vbn avss 11.83848f
C566 vbp_bias avss 26.24953f
C567 vbn_sink avss 62.43269f
C568 vbn_i avss 35.53767f
C569 y1 avss 21.65078f
C570 pm1 avss 8.18981f
C571 vgn2 avss 0.24231p
C572 pm2 avss 14.31197f
C573 vbp_cas avss 21.6236f
C574 vaux avss 21.34967f
C575 rb_mid avss 1.44364f
C576 psrg_vnc avss 32.12429f
C577 vgn1 avss 13.90166f
C578 vx3 avss 3.45332f
C579 vx1 avss 3.66575f
C580 vx2 avss 4.65987f
C581 psrg_m3_feed avss 29.86476f
C582 vsu1 avss 8.4925f
C583 vsu2 avss 7.37866f
C584 vbp_i avss 81.56844f
C585 rfix2 avss 11.1718f
C586 rfix1 avss 11.1355f
C587 rfix0 avss 9.75415f
C588 b3_b avss 1.99627f
C589 b1_b avss 1.36413f
C590 b6_b avss 1.94904f
C591 b4_b avss 2.05085f
C592 b0_b avss 2.03388f
C593 rbit0top avss 19.66894f
C594 rbit1top avss 10.39555f
C595 rbit2top avss 11.82814f
C596 b2_b avss 2.30348f
C597 rbit6top avss 16.4594f
C598 rbit5top avss 21.56552f
C599 b5_b avss 6.32989f
C600 rbit3top avss 16.7326f
C601 rbit4top avss 13.50712f
C602 rbit4top.t5 avss 1.61614f
C603 rbit4top.t3 avss 1.34941f
C604 rbit4top.t2 avss 0.67247f
C605 rbit4top.n0 avss 2.75665f
C606 rbit4top.n1 avss 2.74148f
C607 rbit4top.t4 avss 1.72194f
C608 rbit4top.t0 avss 0.68278f
C609 rbit4top.n2 avss 4.26251f
C610 rbit4top.n3 avss 3.34952f
C611 rbit4top.t1 avss 2.98837f
C612 rbit3top.t0 avss 3.13117f
C613 rbit3top.t7 avss 2.19942f
C614 rbit3top.t6 avss 0.7681f
C615 rbit3top.t1 avss 2.57789f
C616 rbit3top.n0 avss 7.46051f
C617 rbit3top.t5 avss 1.45943f
C618 rbit3top.t2 avss 2.17464f
C619 rbit3top.n1 avss 1.27602f
C620 rbit3top.t3 avss 2.19015f
C621 rbit3top.n2 avss 0.33192f
C622 rbit3top.n3 avss 3.15508f
C623 rbit3top.t4 avss 2.18109f
C624 rbit3top.n4 avss 1.14818f
C625 rbit3top.n5 avss 2.95406f
C626 b5_b.t0 avss 0.3685f
C627 b5_b.t1 avss 0.80691f
C628 b5_b.n0 avss 3.72396f
C629 rbit5top.t0 avss 0.68695f
C630 rbit5top.t3 avss 0.57733f
C631 rbit5top.n0 avss 0.57086f
C632 rbit5top.t2 avss 2.40907f
C633 rbit5top.t1 avss 0.5377f
C634 rbit5top.n1 avss 4.82772f
C635 rbit5top.n2 avss 4.23193f
C636 rbit5top.t4 avss 0.62638f
C637 rbit5top.t5 avss 1.35933f
C638 rbit6top.n0 avss 1.18003f
C639 rbit6top.n1 avss 1.08339f
C640 rbit6top.t4 avss 0.32947f
C641 rbit6top.t2 avss 1.74413f
C642 rbit6top.t1 avss 1.39193f
C643 rbit6top.n2 avss 4.42358f
C644 rbit6top.t5 avss 0.13352f
C645 rbit6top.t3 avss 0.37834f
C646 rbit6top.n3 avss 1.85569f
C647 rbit6top.t0 avss 0.66552f
C648 b2_b.t0 avss 0.17518f
C649 b2_b.t1 avss 0.87185f
C650 b2_b.n0 avss 3.07159f
C651 b2_b.n1 avss 2.86839f
C652 b2_b.n2 avss 0.76812f
C653 rbit2top.t3 avss 4.67138f
C654 rbit2top.t4 avss 4.73878f
C655 rbit2top.t7 avss 4.75491f
C656 rbit2top.t6 avss 0.84691f
C657 rbit2top.t8 avss 1.32942f
C658 rbit2top.n0 avss 5.22027f
C659 rbit2top.n1 avss 3.72359f
C660 rbit2top.t5 avss 4.75198f
C661 rbit2top.n2 avss 0.51553f
C662 rbit2top.n3 avss 0.40436f
C663 rbit2top.t0 avss 2.49651f
C664 rbit2top.t1 avss 2.48366f
C665 rbit2top.t2 avss 2.50517f
C666 rbit2top.n4 avss 0.63218f
C667 rbit2top.n5 avss 1.71134f
C668 rbit2top.t9 avss 2.53675f
C669 rbit2top.n6 avss 3.19859f
C670 rbit2top.n7 avss 1.89196f
C671 rbit1top.t4 avss 4.72699f
C672 rbit1top.t12 avss 4.87135f
C673 rbit1top.t13 avss 4.88643f
C674 rbit1top.n0 avss 1.95551f
C675 rbit1top.t5 avss 4.80006f
C676 rbit1top.t6 avss 4.79586f
C677 rbit1top.t7 avss 4.79696f
C678 rbit1top.t8 avss 4.80029f
C679 rbit1top.t10 avss 4.84795f
C680 rbit1top.t0 avss 0.86628f
C681 rbit1top.t11 avss 1.13001f
C682 rbit1top.n1 avss 4.18155f
C683 rbit1top.n2 avss 4.71777f
C684 rbit1top.t2 avss 4.80751f
C685 rbit1top.n3 avss 0.48674f
C686 rbit1top.t3 avss 4.80209f
C687 rbit1top.n4 avss 0.44812f
C688 rbit1top.t1 avss 4.80828f
C689 rbit1top.n5 avss 0.41726f
C690 rbit1top.t9 avss 4.79373f
C691 rbit1top.n6 avss 0.38378f
C692 rbit1top.n7 avss 0.40039f
C693 rbit1top.n8 avss 0.37267f
C694 rbit1top.n9 avss 0.3819f
C695 rbit1top.n10 avss 0.39549f
C696 rbit1top.n11 avss 1.66526f
C697 rbit0top.t8 avss 4.32359f
C698 rbit0top.t9 avss 4.30606f
C699 rbit0top.n0 avss 1.662f
C700 rbit0top.t4 avss 4.20753f
C701 rbit0top.t7 avss 3.55386f
C702 rbit0top.t0 avss 1.21471f
C703 rbit0top.n1 avss 8.93218f
C704 rbit0top.n2 avss 3.0983f
C705 rbit0top.t6 avss 4.2388f
C706 rbit0top.n3 avss 0.50891f
C707 rbit0top.t3 avss 4.22883f
C708 rbit0top.n4 avss 0.36553f
C709 rbit0top.t5 avss 4.23267f
C710 rbit0top.n5 avss 0.33403f
C711 rbit0top.n6 avss 1.38798f
C712 rbit0top.t1 avss 4.22682f
C713 rbit0top.n7 avss 0.35852f
C714 rbit0top.t2 avss 4.16839f
C715 b0_b.t1 avss 0.66859f
C716 b0_b.t0 avss 0.18733f
C717 b0_b.n0 avss 2.12144f
C718 b0_b.n1 avss 1.26466f
C719 b0_b.n2 avss 0.69089f
C720 b0_b.n3 avss 0.67791f
C721 b0_b.n4 avss 0.67115f
C722 b0_b.n5 avss 0.78107f
C723 b4_b.t0 avss 1.00163f
C724 b4_b.t1 avss 0.677f
C725 b4_b.n0 avss 3.7902f
C726 b6_b.t0 avss 0.60533f
C727 b6_b.t1 avss 0.81429f
C728 b6_b.n0 avss 3.43743f
C729 vq3.t0 avss 1.14773f
C730 vq3.n0 avss 8.18305f
C731 vq3.t2 avss 0.13377f
C732 vq3.n1 avss 1.32617f
C733 vq3.t1 avss 0.30357f
C734 b1_b.t0 avss 0.18395f
C735 b1_b.t1 avss 0.48461f
C736 b1_b.n0 avss 1.81746f
C737 b1_b.n1 avss 1.52025f
C738 b1_b.n2 avss 0.76791f
C739 b3_b.t0 avss 0.22994f
C740 b3_b.t1 avss 1.00982f
C741 b3_b.n0 avss 2.04602f
C742 vbp_i.t2 avss 3.12529f
C743 vbp_i.t4 avss 3.11403f
C744 vbp_i.t6 avss 3.13214f
C745 vbp_i.n0 avss 0.28719f
C746 vbp_i.n1 avss 1.64619f
C747 vbp_i.n2 avss 1.47334f
C748 vbp_i.n3 avss 0.82025f
C749 vbp_i.n4 avss 0.82058f
C750 vbp_i.n5 avss 0.82025f
C751 vbp_i.n6 avss 0.91799f
C752 vbp_i.n7 avss 1.47545f
C753 vbp_i.n8 avss 0.82097f
C754 vbp_i.n9 avss 0.82193f
C755 vbp_i.n10 avss 0.82097f
C756 vbp_i.n11 avss 0.73878f
C757 vbp_i.n12 avss 0.43305f
C758 vbp_i.n13 avss 0.97471f
C759 vbp_i.n14 avss 0.8201f
C760 vbp_i.n15 avss 0.81913f
C761 vbp_i.n16 avss 0.8201f
C762 vbp_i.n17 avss 0.81913f
C763 vbp_i.n18 avss 0.88997f
C764 vbp_i.n19 avss 0.2298f
C765 vbp_i.n20 avss 1.4698f
C766 vbp_i.n21 avss 0.81861f
C767 vbp_i.n22 avss 0.81928f
C768 vbp_i.n23 avss 0.81861f
C769 vbp_i.n24 avss 0.95552f
C770 vbp_i.n25 avss 1.46903f
C771 vbp_i.n26 avss 0.8181f
C772 vbp_i.n27 avss 0.81806f
C773 vbp_i.n28 avss 0.74768f
C774 vbp_i.n29 avss 0.37402f
C775 vbp_i.t0 avss 3.21399f
C776 vbp_i.n30 avss 1.61843f
C777 vbp_i.n31 avss 1.89754f
C778 vbp_i.n32 avss 0.54463f
C779 vbp_i.n33 avss 0.54634f
C780 vbp_i.n34 avss 0.81832f
C781 vbp_i.n35 avss 0.76723f
C782 vbp_i.n36 avss 0.6473f
C783 vbp_i.n37 avss 0.54041f
C784 vbp_i.n38 avss 1.13728f
C785 vbp_i.n39 avss 0.67233f
C786 vbp_i.n40 avss 1.42378f
C787 vbp_i.t8 avss 3.11191f
C788 vbp_i.t10 avss 3.13247f
C789 vbp_i.n41 avss 0.27709f
C790 vbp_i.n42 avss 0.15146f
C791 vbp_i.n43 avss 0.69168f
C792 vbp_i.n44 avss 0.14981f
C793 vbp_i.n45 avss 0.77387f
C794 vbp_i.n46 avss 0.89958f
C795 vbp_i.n47 avss 0.87582f
C796 vbp_i.n48 avss 0.1574f
C797 vbp_i.n49 avss 0.74417f
C798 vbp_i.n50 avss 0.78078f
C799 vbp_i.n51 avss 0.23979f
C800 vbp_i.n52 avss 0.81752f
C801 psrg_m3_feed.n0 avss 1.5177f
C802 psrg_m3_feed.n1 avss 0.82074f
C803 psrg_m3_feed.n2 avss 0.82074f
C804 psrg_m3_feed.n3 avss 0.80704f
C805 psrg_m3_feed.n4 avss 1.50019f
C806 psrg_m3_feed.n5 avss 0.81186f
C807 psrg_m3_feed.n6 avss 0.81186f
C808 psrg_m3_feed.n7 avss 0.79817f
C809 psrg_m3_feed.t0 avss 0.9581f
C810 psrg_m3_feed.n8 avss 1.18186f
C811 psrg_m3_feed.t7 avss 0.54432f
C812 psrg_m3_feed.t5 avss 3.11274f
C813 psrg_m3_feed.t6 avss 3.06146f
C814 psrg_m3_feed.n9 avss 1.88305f
C815 psrg_m3_feed.n10 avss 7.02073f
C816 psrg_m3_feed.n11 avss 7.06135f
C817 psrg_m3_feed.n12 avss 4.29438f
C818 psrg_m3_feed.t1 avss 0.94483f
C819 psrg_m3_feed.t2 avss 0.95676f
C820 psrg_m3_feed.t3 avss 0.98147f
C821 psrg_m3_feed.t4 avss 0.95764f
C822 psrg_m3_feed.n13 avss 0.72369f
C823 psrg_m3_feed.n14 avss 0.73781f
C824 psrg_m3_feed.n15 avss 2.05801f
C825 psrg_m3_feed.n16 avss 0.8707f
C826 psrg_m3_feed.n17 avss 1.06734f
C827 psrg_m3_feed.n18 avss 0.82024f
C828 psrg_m3_feed.n19 avss 0.82024f
C829 psrg_m3_feed.n20 avss 0.82024f
C830 psrg_m3_feed.n21 avss 0.82024f
C831 psrg_m3_feed.n22 avss 1.08986f
C832 psrg_m3_feed.n23 avss 0.49055f
C833 psrg_m3_feed.n24 avss 0.98561f
C834 psrg_m3_feed.n25 avss 0.51756f
C835 vx2.t9 avss 3.60229f
C836 vx2.t10 avss 3.26611f
C837 vx2.n0 avss 1.91957f
C838 vx2.t6 avss 3.28526f
C839 vx2.t1 avss 2.20355f
C840 vx2.t4 avss 1.95501f
C841 vx2.n1 avss 1.37495f
C842 vx2.n2 avss 1.25626f
C843 vx2.t8 avss 3.30908f
C844 vx2.n3 avss 1.56822f
C845 vx2.t2 avss 2.35798f
C846 vx2.t3 avss 1.96763f
C847 vx2.n4 avss 1.7372f
C848 vx2.t5 avss 1.95642f
C849 vx2.n5 avss 1.67077f
C850 vx2.n6 avss 1.20249f
C851 vx2.t0 avss 3.2945f
C852 vx2.n7 avss 1.74812f
C853 vx2.n8 avss 1.88701f
C854 vx2.t7 avss 3.12898f
C855 vx1.t0 avss 3.32779f
C856 vx1.t8 avss 3.52334f
C857 vx1.n0 avss 2.26458f
C858 vx1.t1 avss 3.30827f
C859 vx1.n1 avss 0.87003f
C860 vx1.t7 avss 3.30827f
C861 vx1.t3 avss 2.07397f
C862 vx1.t2 avss 2.03686f
C863 vx1.n2 avss 2.04112f
C864 vx1.t4 avss 2.02263f
C865 vx1.n3 avss 2.439f
C866 vx1.n4 avss 1.59856f
C867 vx1.n5 avss 1.92428f
C868 vx1.t10 avss 3.32648f
C869 vx1.t6 avss 2.10039f
C870 vx1.t5 avss 2.02358f
C871 vx1.n6 avss 1.30699f
C872 vx1.n7 avss 1.70535f
C873 vx1.n8 avss 1.16489f
C874 vx1.t9 avss 3.23952f
C875 vx3.t8 avss 3.49037f
C876 vx3.t0 avss 3.2814f
C877 vx3.n0 avss 1.36674f
C878 vx3.t1 avss 3.29198f
C879 vx3.t2 avss 13.31952f
C880 vx3.t4 avss 1.99217f
C881 vx3.t6 avss 2.31709f
C882 vx3.t5 avss 1.9808f
C883 vx3.n1 avss 1.89048f
C884 vx3.n2 avss 3.39255f
C885 vx3.t3 avss 1.9808f
C886 vx3.n3 avss 0.82709f
C887 vx3.t7 avss 3.29198f
C888 vx3.n4 avss 1.48402f
C889 vx3.n5 avss 1.95882f
C890 vx3.t10 avss 3.38846f
C891 vx3.n6 avss 1.40811f
C892 vx3.t9 avss 3.22379f
C893 vgn1.t2 avss 1.11769f
C894 vgn1.t6 avss 3.71189f
C895 vgn1.t8 avss 3.72896f
C896 vgn1.t9 avss 2.08604f
C897 vgn1.n0 avss 3.47189f
C898 vgn1.n1 avss 0.51186f
C899 vgn1.n2 avss 1.28191f
C900 vgn1.n3 avss 7.78314f
C901 vgn1.t3 avss 1.11928f
C902 vgn1.n4 avss 7.09709f
C903 vgn1.n5 avss 0.82616f
C904 vgn1.t4 avss 1.1198f
C905 vgn1.n6 avss 1.21641f
C906 vgn1.t1 avss 1.11824f
C907 vgn1.n7 avss 1.00508f
C908 vgn1.t0 avss 1.07376f
C909 psrg_vnc.t5 avss 1.51182f
C910 psrg_vnc.n0 avss 0.72428f
C911 psrg_vnc.t6 avss 2.18032f
C912 psrg_vnc.n1 avss 0.75786f
C913 psrg_vnc.t1 avss 2.19437f
C914 psrg_vnc.n2 avss 4.6828f
C915 psrg_vnc.n3 avss 6.5905f
C916 psrg_vnc.t7 avss 2.18795f
C917 psrg_vnc.n4 avss 6.11783f
C918 psrg_vnc.t8 avss 2.19437f
C919 psrg_vnc.n5 avss 0.46795f
C920 psrg_vnc.t0 avss 2.20193f
C921 psrg_vnc.n6 avss 0.36125f
C922 psrg_vnc.n7 avss 0.28903f
C923 psrg_vnc.t2 avss 2.18795f
C924 psrg_vnc.n8 avss 0.46021f
C925 psrg_vnc.n9 avss 0.67761f
C926 psrg_vnc.t3 avss 2.16021f
C927 vaux.t2 avss 1.63731f
C928 vaux.t1 avss 1.6495f
C929 vaux.n0 avss 6.48784f
C930 vaux.t0 avss 1.24786f
C931 vbp_cas.t0 avss 0.93156f
C932 vbp_cas.n0 avss 1.51035f
C933 vbp_cas.t6 avss 3.34577f
C934 vbp_cas.t8 avss 3.33652f
C935 vbp_cas.n1 avss 0.87503f
C936 vbp_cas.n2 avss 0.22452f
C937 vbp_cas.t4 avss 3.30244f
C938 vbp_cas.n3 avss 0.19073f
C939 vbp_cas.n4 avss 0.20637f
C940 vbp_cas.t2 avss 3.32866f
C941 vbp_cas.n6 avss 0.83218f
C942 vbp_cas.t10 avss 3.30311f
C943 vbp_cas.t12 avss 3.21394f
C944 vbp_cas.t20 avss 3.35339f
C945 vbp_cas.n7 avss 0.88507f
C946 vbp_cas.t18 avss 3.40081f
C947 vbp_cas.n8 avss 0.19977f
C948 vbp_cas.t16 avss 3.22039f
C949 vbp_cas.n9 avss 0.16067f
C950 vbp_cas.n10 avss 1.62692f
C951 vbp_cas.n11 avss 0.1328f
C952 vbp_cas.t14 avss 3.39354f
C953 vbp_cas.n12 avss 0.24199f
C954 vbp_cas.n13 avss 0.136f
C955 vbp_cas.n14 avss 0.26483f
C956 vbp_cas.n15 avss 1.52661f
C957 vbp_cas.n16 avss 0.21868f
C958 vbp_cas.n17 avss 0.83551f
C959 vbp_cas.n18 avss 1.09188f
C960 vbp_cas.n19 avss 1.96089f
C961 vbp_cas.n20 avss 1.10895f
C962 vbp_cas.n21 avss 1.14739f
C963 vbp_cas.n22 avss 1.09435f
C964 vbp_cas.n23 avss 1.0251f
C965 vbp_cas.n24 avss 1.87579f
C966 vbp_cas.n25 avss 1.03293f
C967 vbp_cas.n26 avss 1.0321f
C968 vbp_cas.n27 avss 1.03293f
C969 vbp_cas.n28 avss 1.22122f
C970 vbp_cas.n29 avss 0.27287f
C971 vbp_cas.n30 avss 1.12317f
C972 pm2.t2 avss 5.95304f
C973 pm2.t4 avss 5.88656f
C974 pm2.t5 avss 5.88806f
C975 pm2.t3 avss 6.57903f
C976 pm2.n0 avss 2.81137f
C977 pm2.n1 avss 1.96874f
C978 pm2.n2 avss 2.69361f
C979 pm2.t0 avss 5.93632f
C980 pm2.n3 avss 1.76829f
C981 pm2.t6 avss 5.01392f
C982 pm2.t11 avss 5.28297f
C983 pm2.t10 avss 4.89309f
C984 pm2.n4 avss 2.01836f
C985 pm2.t9 avss 4.94379f
C986 pm2.n5 avss 2.07849f
C987 pm2.n6 avss 1.76404f
C988 pm2.t7 avss 4.93316f
C989 pm2.n7 avss 1.03024f
C990 pm2.t8 avss 4.9464f
C991 pm2.n8 avss 5.98589f
C992 pm2.t1 avss 5.88631f
C993 vgn2.n0 avss 0.1894f
C994 vgn2.t3 avss 3.21476f
C995 vgn2.t6 avss 3.30919f
C996 vgn2.t5 avss 3.30961f
C997 vgn2.t4 avss 3.31687f
C998 vgn2.n1 avss 0.21886f
C999 vgn2.t2 avss 3.30948f
C1000 vgn2.t1 avss 3.30733f
C1001 vgn2.n3 avss 0.1107f
C1002 vgn2.t0 avss 7.10743f
C1003 vgn2.n5 avss 0.25588f
C1004 vgn2.n6 avss 0.53058f
C1005 vgn2.n7 avss 0.21432f
C1006 pm1.t2 avss 5.89382f
C1007 pm1.t1 avss 6.36095f
C1008 pm1.n0 avss 1.7431f
C1009 pm1.t5 avss 6.58354f
C1010 pm1.t3 avss 5.96225f
C1011 pm1.n1 avss 2.70816f
C1012 pm1.t4 avss 5.9663f
C1013 pm1.n2 avss 2.34758f
C1014 pm1.n3 avss 2.22783f
C1015 pm1.t7 avss 4.8693f
C1016 pm1.t6 avss 5.14026f
C1017 pm1.n4 avss 0.87422f
C1018 pm1.t11 avss 5.03272f
C1019 pm1.t9 avss 5.69916f
C1020 pm1.t10 avss 4.99421f
C1021 pm1.n5 avss 3.30709f
C1022 pm1.n6 avss 2.17015f
C1023 pm1.t8 avss 4.9494f
C1024 pm1.n7 avss 3.27391f
C1025 pm1.n8 avss 4.97928f
C1026 pm1.t0 avss 5.66019f
C1027 y1.n0 avss 2.11563f
C1028 y1.n1 avss 1.12254f
C1029 y1.n2 avss 1.19407f
C1030 y1.n3 avss 1.10863f
C1031 y1.n4 avss 1.35322f
C1032 y1.n5 avss 2.10837f
C1033 y1.n6 avss 1.1188f
C1034 y1.n7 avss 1.19014f
C1035 y1.n8 avss 1.10519f
C1036 y1.n9 avss 1.02858f
C1037 y1.n10 avss 1.84462f
C1038 y1.t4 avss 4.18696f
C1039 y1.t3 avss 4.18926f
C1040 y1.t5 avss 4.51017f
C1041 y1.n11 avss 0.92873f
C1042 y1.n12 avss 0.63668f
C1043 y1.t2 avss 4.08954f
C1044 y1.t1 avss 4.18566f
C1045 y1.t6 avss 9.38519f
C1046 y1.n13 avss 4.36124f
C1047 y1.n14 avss 0.54652f
C1048 y1.n15 avss 0.86213f
C1049 y1.n16 avss 1.3447f
C1050 y1.t0 avss 3.9233f
C1051 vbn_i.t5 avss 3.66272f
C1052 vbn_i.t4 avss 3.66272f
C1053 vbn_i.t3 avss 3.66843f
C1054 vbn_i.t7 avss 3.61802f
C1055 vbn_i.n0 avss 1.94373f
C1056 vbn_i.n1 avss 5.05956f
C1057 vbn_i.t1 avss 3.08678f
C1058 vbn_i.n2 avss 0.77996f
C1059 vbn_i.n3 avss 3.29644f
C1060 vbn_i.n4 avss 3.78498f
C1061 vbn_i.n5 avss 4.4297f
C1062 vbn_i.t2 avss 3.70291f
C1063 vbn_i.n6 avss 2.31402f
C1064 vbn_i.n7 avss 0.87301f
C1065 vbn_i.n8 avss 1.07191f
C1066 vbn_i.n9 avss 1.54045f
C1067 vbn_i.t6 avss 3.42295f
C1068 vbn_sink.n0 avss 1.32381f
C1069 vbn_sink.n1 avss 0.74622f
C1070 vbn_sink.n2 avss 0.74724f
C1071 vbn_sink.n3 avss 0.73986f
C1072 vbn_sink.n4 avss 1.32441f
C1073 vbn_sink.n5 avss 0.74647f
C1074 vbn_sink.n6 avss 0.74758f
C1075 vbn_sink.n7 avss 0.71466f
C1076 vbn_sink.t7 avss 3.1685f
C1077 vbn_sink.t2 avss 3.20954f
C1078 vbn_sink.n8 avss 0.26823f
C1079 vbn_sink.t8 avss 3.17677f
C1080 vbn_sink.n9 avss 0.30471f
C1081 vbn_sink.t10 avss 3.17445f
C1082 vbn_sink.n10 avss 0.23478f
C1083 vbn_sink.t11 avss 3.17677f
C1084 vbn_sink.n11 avss 0.23347f
C1085 vbn_sink.t16 avss 3.17283f
C1086 vbn_sink.t9 avss 3.23604f
C1087 vbn_sink.t17 avss 3.1745f
C1088 vbn_sink.n12 avss 0.3394f
C1089 vbn_sink.t18 avss 3.17263f
C1090 vbn_sink.n13 avss 0.23439f
C1091 vbn_sink.t15 avss 3.1745f
C1092 vbn_sink.n14 avss 0.23308f
C1093 vbn_sink.n15 avss 0.19839f
C1094 vbn_sink.t4 avss 2.31249f
C1095 vbn_sink.n16 avss 0.57882f
C1096 vbn_sink.n17 avss 0.55599f
C1097 vbn_sink.t6 avss 2.30308f
C1098 vbn_sink.n18 avss 0.26657f
C1099 vbn_sink.n19 avss 0.22808f
C1100 vbn_sink.t14 avss 3.16661f
C1101 vbn_sink.n20 avss 0.16799f
C1102 vbn_sink.t1 avss 3.17436f
C1103 vbn_sink.t20 avss 3.23325f
C1104 vbn_sink.t12 avss 3.17217f
C1105 vbn_sink.n21 avss 0.33402f
C1106 vbn_sink.t13 avss 3.17436f
C1107 vbn_sink.n22 avss 0.23604f
C1108 vbn_sink.t0 avss 3.17217f
C1109 vbn_sink.n23 avss 0.23396f
C1110 vbn_sink.n24 avss 0.23264f
C1111 vbn_sink.n25 avss 0.3183f
C1112 vbn_sink.t19 avss 3.17445f
C1113 vbn_sink.n26 avss 0.19542f
C1114 vbn_sink.n27 avss 0.22174f
C1115 vbn_sink.n28 avss 0.2068f
C1116 vbn_sink.n29 avss 0.7583f
C1117 vbn_sink.n30 avss 0.285f
C1118 vbp_bias.n0 avss 0.45263f
C1119 vbp_bias.n1 avss 0.70852f
C1120 vbp_bias.t27 avss 3.59377f
C1121 vbp_bias.t22 avss 3.60583f
C1122 vbp_bias.n2 avss 0.47496f
C1123 vbp_bias.t21 avss 3.43082f
C1124 vbp_bias.n3 avss 0.32453f
C1125 vbp_bias.t23 avss 3.55783f
C1126 vbp_bias.t20 avss 3.50313f
C1127 vbp_bias.t19 avss 3.5791f
C1128 vbp_bias.n4 avss 0.5336f
C1129 vbp_bias.t25 avss 3.65997f
C1130 vbp_bias.t0 avss 3.59856f
C1131 vbp_bias.t24 avss 3.42103f
C1132 vbp_bias.n5 avss 0.3098f
C1133 vbp_bias.t2 avss 4.75434f
C1134 vbp_bias.n6 avss 2.17669f
C1135 vbp_bias.t6 avss 4.74033f
C1136 vbp_bias.n7 avss 1.2844f
C1137 vbp_bias.t4 avss 4.69037f
C1138 vbp_bias.n8 avss 0.17151f
C1139 vbp_bias.n9 avss 0.24255f
C1140 vbp_bias.n10 avss 0.28358f
C1141 vbp_bias.n11 avss 1.25166f
C1142 vbp_bias.n12 avss 1.16352f
C1143 vbp_bias.t8 avss 4.7289f
C1144 vbp_bias.n13 avss 0.37055f
C1145 vbp_bias.t10 avss 4.68862f
C1146 vbp_bias.n14 avss 0.1727f
C1147 vbp_bias.n15 avss 1.23818f
C1148 vbp_bias.t12 avss 4.74208f
C1149 vbp_bias.n16 avss 0.17407f
C1150 vbp_bias.n17 avss 1.23935f
C1151 vbp_bias.t14 avss 4.74497f
C1152 vbp_bias.n18 avss 0.17545f
C1153 vbp_bias.n19 avss 1.24914f
C1154 vbp_bias.t16 avss 4.74413f
C1155 vbp_bias.n20 avss 0.22893f
C1156 vbp_bias.t18 avss 4.70857f
C1157 vbp_bias.n21 avss 0.27982f
C1158 vbp_bias.n22 avss 5.21191f
C1159 vbp_bias.n23 avss 3.99314f
C1160 vbp_bias.t26 avss 3.4823f
C1161 vbn.t3 avss 12.95302f
C1162 vbn.t2 avss 1.81115f
C1163 vbn.n0 avss 0.9321f
C1164 vbn.n1 avss 1.05307f
C1165 vbn.n2 avss 3.69732f
C1166 vbn.t0 avss 0.90299f
C1167 v1.t1 avss 3.18283f
C1168 v1.t0 avss 3.14452f
C1169 v1.n0 avss 1.51572f
C1170 v1.n1 avss 3.58096f
C1171 v1.n2 avss 2.34752f
C1172 v1.n3 avss 2.30621f
C1173 v1.n4 avss 2.15333f
C1174 v1.n5 avss 1.23515f
C1175 v2.t0 avss 0.73677f
C1176 v2.t2 avss 0.65175f
C1177 v2.t1 avss 0.63352f
C1178 v2.n0 avss 1.79183f
C1179 v2.n1 avss 4.23944f
C1180 v2.n2 avss 2.61593f
C1181 v2.n3 avss 2.57492f
C1182 v2.n4 avss 2.77779f
C1183 v2.n5 avss 1.16591f
C1184 psrg_m3_protected.t1 avss 3.00808f
C1185 psrg_m3_protected.t3 avss 3.05253f
C1186 psrg_m3_protected.n0 avss 0.43364f
C1187 psrg_m3_protected.t2 avss 0.95436f
C1188 psrg_m3_protected.n1 avss 0.30882f
C1189 psrg_m3_protected.t0 avss 0.91745f
C1190 vbp_tail.t6 avss 5.30187f
C1191 vbp_tail.n0 avss 3.65238f
C1192 vbp_tail.n1 avss 4.0918f
C1193 vbp_tail.t1 avss 2.23807f
C1194 vbp_tail.n2 avss 1.08012f
C1195 vbp_tail.t3 avss 2.21874f
C1196 vbp_tail.t5 avss 2.23592f
C1197 vbp_tail.n3 avss 0.68913f
C1198 vbp_tail.n4 avss 0.12648f
C1199 vbp_tail.n5 avss 0.17011f
C1200 vbp_tail.n6 avss 0.36874f
C1201 vbp_tail.n7 avss 0.3398f
C1202 vbp_tail.n8 avss 1.32f
C1203 vbp_tail.n9 avss 1.38464f
C1204 vbp_tail.n10 avss 1.391f
C1205 vbp_tail.n11 avss 1.47289f
C1206 vbn_fold.t8 avss 4.05106f
C1207 vbn_fold.t1 avss 2.09802f
C1208 vbn_fold.n0 avss 1.077f
C1209 vbn_fold.t6 avss 4.10713f
C1210 vbn_fold.n1 avss 0.85697f
C1211 vbn_fold.t9 avss 4.06972f
C1212 vbn_fold.n2 avss 0.64259f
C1213 vbn_fold.t10 avss 4.06647f
C1214 vbn_fold.n3 avss 0.64278f
C1215 vbn_fold.t2 avss 4.06972f
C1216 vbn_fold.n4 avss 0.64259f
C1217 vbn_fold.t3 avss 4.06647f
C1218 vbn_fold.n5 avss 0.83043f
C1219 vbn_fold.n6 avss 6.41266f
C1220 vbn_fold.t11 avss 4.1007f
C1221 vbn_fold.n7 avss 2.27263f
C1222 vbn_fold.t7 avss 4.06359f
C1223 vbn_fold.n8 avss 0.64002f
C1224 vbn_fold.t4 avss 4.06002f
C1225 vbn_fold.n9 avss 0.63971f
C1226 vbn_fold.t12 avss 4.06359f
C1227 vbn_fold.n10 avss 0.64002f
C1228 vbn_fold.t13 avss 4.06002f
C1229 vbn_fold.n11 avss 0.83066f
C1230 vbn_fold.n12 avss 0.64401f
C1231 vbn_fold.t5 avss 4.01198f
C1232 xf2.t5 avss 10.1104f
C1233 xf2.t9 avss 10.1683f
C1234 xf2.t8 avss 4.24239f
C1235 xf2.t6 avss 4.27636f
C1236 xf2.t7 avss 4.35012f
C1237 xf2.n0 avss 1.59029f
C1238 xf2.t4 avss 4.62478f
C1239 xf2.n1 avss 2.37755f
C1240 xf2.t10 avss 4.23769f
C1241 xf2.n2 avss 0.65812f
C1242 xf2.t11 avss 4.27514f
C1243 xf2.n3 avss 2.03625f
C1244 xf2.n4 avss 1.81427f
C1245 xf2.t2 avss 10.04191f
C1246 xf2.n5 avss 1.32803f
C1247 xf2.n6 avss 2.59237f
C1248 xf2.n7 avss 0.67884f
C1249 xf2.t0 avss 10.12175f
C1250 xf2.n8 avss 1.17923f
C1251 xf2.t1 avss 10.12175f
C1252 xf2.n9 avss 2.25951f
C1253 xf2.t3 avss 9.88844f
C1254 iref_gate.t1 avss 6.41339f
C1255 iref_gate.t2 avss 9.8439f
C1256 iref_gate.n0 avss 7.56784f
C1257 iref_gate.n1 avss 9.08471f
C1258 iref_gate.t0 avss 9.7596f
C1259 vsp.t8 avss 7.0282f
C1260 vsp.t11 avss 7.18183f
C1261 vsp.n0 avss 1.37022f
C1262 vsp.t10 avss 7.17051f
C1263 vsp.n1 avss 0.97002f
C1264 vsp.t9 avss 7.18211f
C1265 vsp.n2 avss 0.94642f
C1266 vsp.t14 avss 7.19039f
C1267 vsp.n3 avss 0.94724f
C1268 vsp.t12 avss 7.08012f
C1269 vsp.n4 avss 2.83091f
C1270 vsp.t2 avss 10.73437f
C1271 vsp.t3 avss 11.35356f
C1272 vsp.t13 avss 10.88791f
C1273 vsp.t1 avss 10.88505f
C1274 vsp.t4 avss 11.33738f
C1275 vsp.t5 avss 10.81674f
C1276 vsp.n5 avss 1.22904f
C1277 vsp.t15 avss 10.88505f
C1278 vsp.n6 avss 0.82704f
C1279 vsp.t7 avss 11.35629f
C1280 vsp.n7 avss 0.82729f
C1281 vsp.t0 avss 11.35356f
C1282 vsp.n8 avss 1.12124f
C1283 vsp.n9 avss 1.17205f
C1284 vsp.n10 avss 0.82729f
C1285 vsp.n11 avss 0.82704f
C1286 vsp.n12 avss 0.89403f
C1287 vsp.n13 avss 1.60161f
C1288 vsp.t6 avss 11.08393f
C1289 xf1.t9 avss 9.53689f
C1290 xf1.t6 avss 4.37801f
C1291 xf1.t5 avss 4.23681f
C1292 xf1.t7 avss 4.43692f
C1293 xf1.t8 avss 10.01503f
C1294 xf1.n0 avss 4.65295f
C1295 xf1.t3 avss 4.22383f
C1296 xf1.n1 avss 0.88177f
C1297 xf1.t11 avss 4.2356f
C1298 xf1.n2 avss 1.74287f
C1299 xf1.t4 avss 4.22413f
C1300 xf1.n3 avss 1.31564f
C1301 xf1.n4 avss 0.89974f
C1302 xf1.n5 avss 2.13268f
C1303 xf1.t2 avss 9.44141f
C1304 xf1.n6 avss 1.58847f
C1305 xf1.t10 avss 9.55105f
C1306 xf1.n7 avss 1.68897f
C1307 xf1.t0 avss 9.55105f
C1308 xf1.n8 avss 1.43145f
C1309 xf1.n9 avss 1.3333f
C1310 xf1.t1 avss 9.3105f
C1311 su_state.t2 avss 0.27828f
C1312 su_state.n0 avss 0.79837f
C1313 su_state.t0 avss 0.41648f
C1314 psrg_mf1_protected.t0 avss 6.28189f
C1315 psrg_mf1_protected.t1 avss 6.55849f
C1316 dvdd.n0 avss 0.27546f
C1317 dvdd.t6 avss 0.69567f
C1318 dvdd.n1 avss 1.33461f
C1319 dvdd.n2 avss 1.30155f
C1320 dvdd.t2 avss 1.63566f
C1321 dvdd.n3 avss 2.21763f
C1322 dvdd.n4 avss 1.4023f
C1323 dvdd.t15 avss 0.21744f
C1324 dvdd.t26 avss 0.41741f
C1325 dvdd.t27 avss 0.2019f
C1326 dvdd.n5 avss 0.1522f
C1327 dvdd.n6 avss 0.9191f
C1328 dvdd.t21 avss 0.368f
C1329 dvdd.n7 avss 0.97532f
C1330 dvdd.n8 avss 0.1477f
C1331 dvdd.t14 avss 0.34986f
C1332 dvdd.n9 avss 0.86853f
C1333 dvdd.t19 avss 0.24383f
C1334 dvdd.t18 avss 0.42f
C1335 dvdd.t24 avss 0.4181f
C1336 dvdd.n10 avss 0.80311f
C1337 dvdd.t23 avss 0.25357f
C1338 dvdd.t22 avss 0.38506f
C1339 dvdd.n12 avss 0.84491f
C1340 dvdd.t5 avss 3.40946f
C1341 dvdd.n13 avss 2.19728f
C1342 dvdd.t9 avss 1.54101f
C1343 dvdd.n14 avss 1.8387f
C1344 dvdd.t13 avss 4.86365f
C1345 dvdd.t7 avss 4.7999f
C1346 dvdd.n15 avss 4.26572f
C1347 dvdd.t3 avss 4.79986f
C1348 dvdd.n16 avss 2.18096f
C1349 dvdd.t1 avss 4.80315f
C1350 dvdd.n17 avss 2.16276f
C1351 dvdd.t10 avss 4.87332f
C1352 dvdd.t12 avss 4.80395f
C1353 dvdd.n18 avss 4.25676f
C1354 dvdd.t11 avss 4.79985f
C1355 dvdd.n19 avss 2.18669f
C1356 dvdd.t20 avss 4.80435f
C1357 dvdd.n20 avss 2.19266f
C1358 dvdd.t0 avss 4.79993f
C1359 dvdd.n21 avss 2.15519f
C1360 dvdd.n22 avss 1.29059f
C1361 dvdd.n24 avss 3.7121f
C1362 dvdd.n25 avss 1.64299f
C1363 dvdd.t16 avss 0.41732f
C1364 dvdd.n26 avss 0.88344f
C1365 dvdd.t17 avss 0.21654f
C1366 dvdd.t25 avss 0.23724f
C1367 dvdd.n30 avss 0.85597f
C1368 dvdd.t29 avss 0.25144f
C1369 dvdd.t28 avss 0.42176f
C1370 dvdd.n31 avss 0.83859f
C1371 dvdd.n32 avss 0.16109f
C1372 dvdd.n33 avss 0.10853f
C1373 dvdd.n34 avss 0.11294f
C1374 dvdd.n35 avss 0.16945f
C1375 dvdd.n36 avss 1.75583f
C1376 dvdd.n37 avss 1.73613f
C1377 dvdd.t8 avss 2.12374f
C1378 dvdd.n38 avss 1.72822f
C1379 dvdd.t4 avss 2.1222f
C1380 dvdd.n39 avss 1.68863f
C1381 dvdd.n40 avss 0.31089f
C1382 dvdd.n41 avss 2.48927f
C1383 avdd.n0 avss 0.85587f
C1384 avdd.n2 avss 3.23778f
C1385 avdd.n3 avss 0.46514f
C1386 avdd.n4 avss 1.14357f
C1387 avdd.n5 avss 1.67209f
C1388 avdd.n6 avss 0.33006f
C1389 avdd.n7 avss 0.13066f
C1390 avdd.n8 avss 0.15389f
C1391 avdd.n9 avss 1.04196f
C1392 avdd.n10 avss 3.23346f
C1393 avdd.n11 avss 0.46514f
C1394 avdd.n12 avss 0.90344f
C1395 avdd.n13 avss 2.00235f
C1396 avdd.n14 avss 0.83188f
C1397 avdd.n15 avss 0.48303f
C1398 avdd.n16 avss 0.88555f
C1399 avdd.n17 avss 0.79614f
C1400 avdd.n18 avss 0.10929f
C1401 avdd.n19 avss 0.39358f
C1402 avdd.n20 avss 0.77821f
C1403 avdd.n21 avss 1.23501f
C1404 avdd.n22 avss 1.13058f
C1405 avdd.n23 avss 0.80024f
C1406 avdd.n24 avss 0.18843f
C1407 avdd.n25 avss 0.92032f
C1408 avdd.n26 avss 0.86766f
C1409 avdd.n27 avss 0.39358f
C1410 avdd.n28 avss 0.83188f
C1411 avdd.n29 avss 2.09551f
C1412 avdd.n31 avss 0.66443f
C1413 avdd.n32 avss 0.1231f
C1414 avdd.n33 avss 0.18532f
C1415 avdd.n35 avss 0.12558f
C1416 avdd.n36 avss 0.2415f
C1417 avdd.n37 avss 0.12544f
C1418 avdd.n38 avss 0.21419f
C1419 avdd.n39 avss 0.16886f
C1420 avdd.n40 avss 0.46514f
C1421 avdd.n41 avss 0.16955f
C1422 avdd.n42 avss 0.16905f
C1423 avdd.n43 avss 0.13784f
C1424 avdd.n45 avss 0.10291f
C1425 avdd.n46 avss 3.33097f
C1426 avdd.n47 avss 1.46285f
C1427 avdd.n48 avss 0.12237f
C1428 avdd.n49 avss 0.76073f
C1429 avdd.t154 avss 0.96337f
C1430 avdd.n50 avss 1.04237f
C1431 avdd.t153 avss 0.80949f
C1432 avdd.n51 avss 1.11966f
C1433 avdd.n52 avss 1.67017f
C1434 avdd.t97 avss 0.95435f
C1435 avdd.t96 avss 0.76948f
C1436 avdd.n53 avss 1.16645f
C1437 avdd.t36 avss 0.54155f
C1438 avdd.n56 avss 1.00412f
C1439 avdd.t252 avss 1.47338f
C1440 avdd.t12 avss 1.46278f
C1441 avdd.t66 avss 1.46654f
C1442 avdd.t65 avss 1.75816f
C1443 avdd.n57 avss 2.1331f
C1444 avdd.t68 avss 1.464f
C1445 avdd.t47 avss 1.62767f
C1446 avdd.n58 avss 2.03055f
C1447 avdd.n59 avss 0.33544f
C1448 avdd.t205 avss 1.46523f
C1449 avdd.t42 avss 1.72628f
C1450 avdd.t41 avss 1.62895f
C1451 avdd.n60 avss 2.02715f
C1452 avdd.n61 avss 0.37569f
C1453 avdd.t40 avss 1.72628f
C1454 avdd.t39 avss 1.72745f
C1455 avdd.t38 avss 1.72628f
C1456 avdd.n62 avss 2.01334f
C1457 avdd.t98 avss 1.23499f
C1458 avdd.n63 avss 1.51739f
C1459 avdd.t73 avss 1.33815f
C1460 avdd.t24 avss 1.33815f
C1461 avdd.n64 avss 1.42017f
C1462 avdd.t99 avss 1.50684f
C1463 avdd.n65 avss 0.10982f
C1464 avdd.t72 avss 1.50625f
C1465 avdd.t74 avss 1.50282f
C1466 avdd.t25 avss 1.50282f
C1467 avdd.t27 avss 1.50282f
C1468 avdd.t150 avss 1.50625f
C1469 avdd.n70 avss 0.55808f
C1470 avdd.n72 avss 0.12388f
C1471 avdd.t26 avss 1.23499f
C1472 avdd.t149 avss 1.2935f
C1473 avdd.t29 avss 1.50678f
C1474 avdd.t31 avss 1.50682f
C1475 avdd.t30 avss 1.23697f
C1476 avdd.n75 avss 1.50836f
C1477 avdd.t151 avss 1.23697f
C1478 avdd.t117 avss 1.43646f
C1479 avdd.t79 avss 1.5064f
C1480 avdd.t121 avss 1.50287f
C1481 avdd.t14 avss 1.52956f
C1482 avdd.t123 avss 1.50287f
C1483 avdd.t77 avss 1.49639f
C1484 avdd.n78 avss 0.10115f
C1485 avdd.n80 avss 0.62615f
C1486 avdd.t122 avss 1.33836f
C1487 avdd.n81 avss 1.44024f
C1488 avdd.t76 avss 1.33836f
C1489 avdd.t78 avss 1.33836f
C1490 avdd.n82 avss 1.41114f
C1491 avdd.t207 avss 4.26678f
C1492 avdd.t81 avss 4.32749f
C1493 avdd.n84 avss 0.7015f
C1494 avdd.t206 avss 2.95687f
C1495 avdd.t209 avss 4.26554f
C1496 avdd.t208 avss 2.95682f
C1497 avdd.n85 avss 0.99385f
C1498 avdd.t126 avss 2.95732f
C1499 avdd.t128 avss 2.97582f
C1500 avdd.n86 avss 3.64952f
C1501 avdd.n87 avss 3.28793f
C1502 avdd.t225 avss 2.95552f
C1503 avdd.n88 avss 3.28455f
C1504 avdd.t145 avss 2.95547f
C1505 avdd.t146 avss 4.31254f
C1506 avdd.t129 avss 4.30473f
C1507 avdd.t127 avss 4.31292f
C1508 avdd.n89 avss 0.19957f
C1509 avdd.t226 avss 4.31181f
C1510 avdd.n90 avss 0.13102f
C1511 avdd.n91 avss 0.14907f
C1512 avdd.n93 avss 3.24949f
C1513 avdd.n94 avss 0.5367f
C1514 avdd.n95 avss 0.48303f
C1515 avdd.t193 avss 2.96327f
C1516 avdd.t244 avss 2.92317f
C1517 avdd.t195 avss 2.72202f
C1518 avdd.t243 avss 2.94196f
C1519 avdd.n97 avss 3.31306f
C1520 avdd.t194 avss 2.94286f
C1521 avdd.n98 avss 0.55459f
C1522 avdd.t112 avss 2.94286f
C1523 avdd.n99 avss 0.55459f
C1524 avdd.t156 avss 2.91938f
C1525 avdd.t20 avss 2.9544f
C1526 avdd.t213 avss 2.95294f
C1527 avdd.n101 avss 0.13218f
C1528 avdd.t19 avss 2.94286f
C1529 avdd.t8 avss 2.99459f
C1530 avdd.t139 avss 3.80677f
C1531 avdd.n102 avss 3.4981f
C1532 avdd.t130 avss 3.8094f
C1533 avdd.t214 avss 3.80691f
C1534 avdd.n103 avss 3.62716f
C1535 avdd.t217 avss 3.80855f
C1536 avdd.n104 avss 1.1846f
C1537 avdd.t132 avss 1.8027f
C1538 avdd.n105 avss 2.21827f
C1539 avdd.t176 avss 1.80155f
C1540 avdd.n106 avss 2.17927f
C1541 avdd.n107 avss 1.18956f
C1542 avdd.t4 avss 2.02699f
C1543 avdd.n108 avss 0.25198f
C1544 avdd.t23 avss 3.47667f
C1545 avdd.n109 avss 3.57599f
C1546 avdd.n110 avss 0.97832f
C1547 avdd.t95 avss 3.47779f
C1548 avdd.t93 avss 3.6982f
C1549 avdd.t94 avss 3.33054f
C1550 avdd.n111 avss 7.18056f
C1551 avdd.n112 avss 0.46372f
C1552 avdd.n113 avss 3.68937f
C1553 avdd.t21 avss 3.47667f
C1554 avdd.n114 avss 3.69228f
C1555 avdd.t22 avss 3.47779f
C1556 avdd.t166 avss 3.47729f
C1557 avdd.n115 avss 3.66842f
C1558 avdd.t167 avss 3.47527f
C1559 avdd.t84 avss 2.95695f
C1560 avdd.n116 avss 0.15342f
C1561 avdd.t86 avss 2.9452f
C1562 avdd.t85 avss 2.97225f
C1563 avdd.n117 avss 3.30115f
C1564 avdd.t182 avss 2.97767f
C1565 avdd.n118 avss 1.31308f
C1566 avdd.t161 avss 2.8557f
C1567 avdd.n119 avss 3.38854f
C1568 avdd.t233 avss 2.97335f
C1569 avdd.t185 avss 2.3471f
C1570 avdd.t6 avss 2.34781f
C1571 avdd.t184 avss 7.25271f
C1572 avdd.t75 avss 20.034f
C1573 avdd.n120 avss 1.37214f
C1574 avdd.n121 avss 1.42543f
C1575 avdd.t115 avss 3.00952f
C1576 avdd.t114 avss 3.04936f
C1577 avdd.t91 avss 2.97853f
C1578 avdd.n122 avss 6.49487f
C1579 avdd.t59 avss 3.02243f
C1580 avdd.n123 avss 3.26979f
C1581 avdd.t92 avss 2.95173f
C1582 avdd.n125 avss 0.18319f
C1583 avdd.t60 avss 2.9557f
C1584 avdd.t200 avss 3.24929f
C1585 avdd.n126 avss 3.09645f
C1586 avdd.t201 avss 2.95513f
C1587 avdd.t87 avss 3.24513f
C1588 avdd.n127 avss 3.09546f
C1589 avdd.t88 avss 2.95502f
C1590 avdd.n129 avss 0.61624f
C1591 avdd.t56 avss 2.95353f
C1592 avdd.t1 avss 0.52128f
C1593 avdd.t261 avss 12.93171f
C1594 avdd.t33 avss 0.68855f
C1595 avdd.t32 avss 0.221f
C1596 avdd.t224 avss 2.85119f
C1597 avdd.t246 avss 2.9694f
C1598 avdd.n131 avss 3.32065f
C1599 avdd.n132 avss 0.3578f
C1600 avdd.t103 avss 2.97244f
C1601 avdd.n133 avss 3.29876f
C1602 avdd.t141 avss 2.97335f
C1603 avdd.t142 avss 2.98953f
C1604 avdd.n135 avss 0.12762f
C1605 avdd.t143 avss 2.97244f
C1606 avdd.n136 avss 3.30805f
C1607 avdd.t144 avss 2.98808f
C1608 avdd.n137 avss 0.12384f
C1609 avdd.t159 avss 2.97335f
C1610 avdd.n138 avss 3.31258f
C1611 avdd.t160 avss 2.94807f
C1612 avdd.t162 avss 2.95036f
C1613 avdd.n139 avss 0.1156f
C1614 avdd.n142 avss 0.92147f
C1615 avdd.n143 avss 0.92147f
C1616 avdd.n144 avss 0.92147f
C1617 avdd.n145 avss 0.8857f
C1618 avdd.n146 avss 3.31258f
C1619 avdd.t104 avss 2.95024f
C1620 avdd.n149 avss 1.26568f
C1621 avdd.n150 avss 0.63887f
C1622 avdd.n151 avss 3.39236f
C1623 avdd.t125 avss 2.9694f
C1624 avdd.n152 avss 3.31061f
C1625 avdd.t188 avss 2.96777f
C1626 avdd.n153 avss 3.31085f
C1627 avdd.t189 avss 2.9694f
C1628 avdd.n154 avss 3.31101f
C1629 avdd.t256 avss 2.96777f
C1630 avdd.n155 avss 3.32728f
C1631 avdd.n156 avss 0.40073f
C1632 avdd.t260 avss 0.45938f
C1633 avdd.n157 avss 0.67142f
C1634 avdd.t17 avss 0.52876f
C1635 avdd.n158 avss 0.96611f
C1636 avdd.t248 avss 3.48715f
C1637 avdd.t259 avss 0.29241f
C1638 avdd.n159 avss 0.65899f
C1639 avdd.t247 avss 0.45945f
C1640 avdd.n160 avss 0.92315f
C1641 avdd.n162 avss 0.10121f
C1642 avdd.n163 avss 0.93445f
C1643 avdd.t2 avss 0.38852f
C1644 avdd.n166 avss 1.02832f
C1645 avdd.n167 avss 0.12105f
C1646 avdd.t89 avss 2.85978f
C1647 avdd.n168 avss 3.40189f
C1648 avdd.t105 avss 2.86142f
C1649 avdd.n169 avss 3.399f
C1650 avdd.n170 avss 0.13555f
C1651 avdd.t107 avss 2.97688f
C1652 avdd.n171 avss 3.31878f
C1653 avdd.t90 avss 3.02073f
C1654 avdd.t106 avss 2.95331f
C1655 avdd.n173 avss 0.19589f
C1656 avdd.t108 avss 2.95371f
C1657 avdd.n175 avss 0.12386f
C1658 avdd.t55 avss 2.97848f
C1659 avdd.n176 avss 3.25308f
C1660 avdd.t202 avss 3.14545f
C1661 avdd.t203 avss 2.9557f
C1662 avdd.n178 avss 3.24329f
C1663 avdd.t57 avss 2.97688f
C1664 avdd.n179 avss 0.81261f
C1665 avdd.n180 avss 3.35431f
C1666 avdd.n182 avss 0.18776f
C1667 avdd.t58 avss 2.95371f
C1668 avdd.n183 avss 0.11638f
C1669 avdd.t101 avss 3.04711f
C1670 avdd.n185 avss 3.26792f
C1671 avdd.t102 avss 2.95687f
C1672 avdd.n187 avss 0.83543f
C1673 avdd.n188 avss 0.87417f
C1674 avdd.n189 avss 0.6159f
C1675 avdd.n190 avss 0.62553f
C1676 avdd.n191 avss 2.77976f
C1677 avdd.n192 avss 4.9993f
C1678 avdd.n193 avss 3.37457f
C1679 avdd.t82 avss 6.68341f
C1680 avdd.t100 avss 6.67963f
C1681 avdd.n194 avss 3.76748f
C1682 avdd.n195 avss 0.37569f
C1683 avdd.t255 avss 6.68341f
C1684 avdd.t124 avss 6.67963f
C1685 avdd.t0 avss 6.68341f
C1686 avdd.t15 avss 6.68341f
C1687 avdd.n196 avss 3.80486f
C1688 avdd.n197 avss 0.51881f
C1689 avdd.t216 avss 6.67963f
C1690 avdd.t54 avss 6.68341f
C1691 avdd.t109 avss 6.68341f
C1692 avdd.n198 avss 3.84966f
C1693 avdd.n199 avss 1.21264f
C1694 avdd.t16 avss 6.67963f
C1695 avdd.n201 avss 3.73569f
C1696 avdd.n202 avss 3.76712f
C1697 avdd.n203 avss 3.76748f
C1698 avdd.n204 avss 0.37569f
C1699 avdd.n205 avss 0.57248f
C1700 avdd.n206 avss 0.55459f
C1701 avdd.n207 avss 3.80128f
C1702 avdd.n208 avss 3.76748f
C1703 avdd.n209 avss 3.7655f
C1704 avdd.n210 avss 0.37569f
C1705 avdd.n211 avss 0.37569f
C1706 avdd.n212 avss 0.37072f
C1707 avdd.n213 avss 3.7655f
C1708 avdd.t5 avss 7.18153f
C1709 avdd.n214 avss 3.95188f
C1710 avdd.n215 avss 0.43984f
C1711 avdd.n217 avss 3.33031f
C1712 avdd.n218 avss 0.55797f
C1713 avdd.n219 avss 0.13118f
C1714 avdd.t234 avss 2.95171f
C1715 avdd.n221 avss 0.53331f
C1716 avdd.n222 avss 0.66443f
C1717 avdd.n223 avss 0.55459f
C1718 avdd.t236 avss 3.02159f
C1719 avdd.n224 avss 0.119f
C1720 avdd.t168 avss 2.97317f
C1721 avdd.t134 avss 2.85291f
C1722 avdd.n225 avss 3.38754f
C1723 avdd.t53 avss 1.68263f
C1724 avdd.t175 avss 2.96843f
C1725 avdd.n226 avss 3.31712f
C1726 avdd.t223 avss 2.85291f
C1727 avdd.n227 avss 3.41617f
C1728 avdd.t245 avss 2.96843f
C1729 avdd.n228 avss 4.95791f
C1730 avdd.n229 avss 0.55459f
C1731 avdd.t147 avss 2.97245f
C1732 avdd.t219 avss 2.97136f
C1733 avdd.t221 avss 2.97245f
C1734 avdd.n230 avss 0.15461f
C1735 avdd.t198 avss 2.97921f
C1736 avdd.n231 avss 3.25422f
C1737 avdd.t222 avss 2.98798f
C1738 avdd.t197 avss 2.93834f
C1739 avdd.t196 avss 2.85461f
C1740 avdd.n232 avss 3.33556f
C1741 avdd.n235 avss 0.18367f
C1742 avdd.t199 avss 2.95022f
C1743 avdd.n236 avss 0.17062f
C1744 avdd.n237 avss 1.17892f
C1745 avdd.n238 avss 0.51881f
C1746 avdd.n239 avss 0.55459f
C1747 avdd.n240 avss 3.31949f
C1748 avdd.t220 avss 2.93834f
C1749 avdd.t148 avss 3.0457f
C1750 avdd.n241 avss 0.17902f
C1751 avdd.n243 avss 3.3007f
C1752 avdd.n244 avss 3.28748f
C1753 avdd.n245 avss 1.00385f
C1754 avdd.n246 avss 4.00598f
C1755 avdd.n247 avss 2.0428f
C1756 avdd.n248 avss 0.18214f
C1757 avdd.t235 avss 2.85551f
C1758 avdd.n249 avss 3.3892f
C1759 avdd.n250 avss 0.10116f
C1760 avdd.n251 avss 0.81261f
C1761 avdd.n252 avss 3.32012f
C1762 avdd.t170 avss 2.97225f
C1763 avdd.n253 avss 3.30115f
C1764 avdd.t169 avss 2.98781f
C1765 avdd.t171 avss 2.9452f
C1766 avdd.n254 avss 0.18117f
C1767 avdd.t83 avss 2.97317f
C1768 avdd.n256 avss 3.32012f
C1769 avdd.n257 avss 0.55459f
C1770 avdd.n258 avss 0.51881f
C1771 avdd.n259 avss 0.51881f
C1772 avdd.t183 avss 2.95013f
C1773 avdd.n263 avss 1.01895f
C1774 avdd.t174 avss 3.33122f
C1775 avdd.t165 avss 3.47527f
C1776 avdd.n264 avss 3.70632f
C1777 avdd.n265 avss 3.77538f
C1778 avdd.t173 avss 3.47527f
C1779 avdd.n266 avss 3.69146f
C1780 avdd.t172 avss 3.49325f
C1781 avdd.n267 avss 3.89162f
C1782 avdd.n268 avss 4.06113f
C1783 avdd.n269 avss 0.5367f
C1784 avdd.t251 avss 1.86719f
C1785 avdd.t11 avss 1.75726f
C1786 avdd.n270 avss 2.13269f
C1787 avdd.t9 avss 1.86719f
C1788 avdd.n272 avss 2.05489f
C1789 avdd.t253 avss 1.86628f
C1790 avdd.n273 avss 2.08742f
C1791 avdd.n274 avss 2.05628f
C1792 avdd.n275 avss 2.35567f
C1793 avdd.n276 avss 5.17454f
C1794 avdd.n277 avss 3.81664f
C1795 avdd.n278 avss 0.1744f
C1796 avdd.n279 avss 3.68745f
C1797 avdd.n280 avss 0.63487f
C1798 avdd.n281 avss 1.22544f
C1799 avdd.n282 avss 0.19743f
C1800 avdd.t177 avss 2.01937f
C1801 avdd.n283 avss 0.20674f
C1802 avdd.t133 avss 2.00021f
C1803 avdd.n285 avss 0.13014f
C1804 avdd.t3 avss 1.80203f
C1805 avdd.n287 avss 2.16522f
C1806 avdd.n288 avss 0.75937f
C1807 avdd.n289 avss 0.54286f
C1808 avdd.n290 avss 0.75896f
C1809 avdd.t258 avss 0.24851f
C1810 avdd.t257 avss 0.29648f
C1811 avdd.n293 avss 0.62808f
C1812 avdd.t215 avss 3.79305f
C1813 avdd.t140 avss 3.88778f
C1814 avdd.n294 avss 0.11065f
C1815 avdd.t138 avss 3.89096f
C1816 avdd.t218 avss 3.89362f
C1817 avdd.t136 avss 3.89382f
C1818 avdd.n295 avss 1.21798f
C1819 avdd.n296 avss 3.494f
C1820 avdd.t135 avss 3.80812f
C1821 avdd.n297 avss 3.49406f
C1822 avdd.t137 avss 3.807f
C1823 avdd.n298 avss 3.49679f
C1824 avdd.n299 avss 0.46514f
C1825 avdd.n300 avss 0.46514f
C1826 avdd.t186 avss 2.19445f
C1827 avdd.n301 avss 2.25464f
C1828 avdd.n302 avss 0.60825f
C1829 avdd.t210 avss 2.1925f
C1830 avdd.t69 avss 2.05861f
C1831 avdd.t163 avss 2.06067f
C1832 avdd.t158 avss 2.93555f
C1833 avdd.n303 avss 0.1938f
C1834 avdd.t178 avss 2.1925f
C1835 avdd.n304 avss 2.37357f
C1836 avdd.t164 avss 2.7053f
C1837 avdd.t250 avss 2.70142f
C1838 avdd.t211 avss 2.7007f
C1839 avdd.t187 avss 2.72028f
C1840 avdd.n305 avss 0.12287f
C1841 avdd.t180 avss 2.25071f
C1842 avdd.t237 avss 2.19449f
C1843 avdd.n307 avss 4.44045f
C1844 avdd.t239 avss 2.19557f
C1845 avdd.n308 avss 2.26514f
C1846 avdd.t241 avss 2.06066f
C1847 avdd.t230 avss 2.70249f
C1848 avdd.t240 avss 2.70249f
C1849 avdd.t181 avss 2.7099f
C1850 avdd.t238 avss 2.69804f
C1851 avdd.n309 avss 0.16349f
C1852 avdd.t242 avss 2.63093f
C1853 avdd.t52 avss 1.62758f
C1854 avdd.t51 avss 1.72741f
C1855 avdd.n312 avss 1.98275f
C1856 avdd.n313 avss 0.37569f
C1857 avdd.t50 avss 1.7261f
C1858 avdd.t49 avss 1.72741f
C1859 avdd.t48 avss 1.7261f
C1860 avdd.t120 avss 1.33836f
C1861 avdd.n314 avss 1.46791f
C1862 avdd.t13 avss 1.33836f
C1863 avdd.n315 avss 1.45091f
C1864 avdd.n316 avss 0.51881f
C1865 avdd.n317 avss 1.99463f
C1866 avdd.n318 avss 1.99349f
C1867 avdd.n319 avss 1.99301f
C1868 avdd.n320 avss 0.37569f
C1869 avdd.n321 avss 0.32202f
C1870 avdd.n323 avss 2.0142f
C1871 avdd.t34 avss 0.28396f
C1872 avdd.n325 avss 0.57771f
C1873 avdd.n326 avss 0.10765f
C1874 avdd.t232 avss 2.72903f
C1875 avdd.n327 avss 0.1464f
C1876 avdd.n328 avss 0.15394f
C1877 avdd.t231 avss 2.23467f
C1878 avdd.n329 avss 2.26719f
C1879 avdd.t229 avss 2.19557f
C1880 avdd.n330 avss 2.25333f
C1881 avdd.n331 avss 2.34388f
C1882 avdd.n333 avss 0.15296f
C1883 avdd.t70 avss 2.63344f
C1884 avdd.n335 avss 0.1432f
C1885 avdd.t179 avss 2.73212f
C1886 avdd.n336 avss 0.14094f
C1887 avdd.n337 avss 0.73479f
C1888 avdd.n338 avss 0.63288f
C1889 avdd.n341 avss 2.35755f
C1890 avdd.n342 avss 2.35663f
C1891 avdd.t249 avss 2.19445f
C1892 avdd.n344 avss 2.2568f
C1893 avdd.n345 avss 2.2868f
C1894 avdd.n346 avss 0.55459f
C1895 avdd.n347 avss 0.80475f
C1896 avdd.t131 avss 3.66004f
C1897 avdd.n348 avss 0.93057f
C1898 avdd.n349 avss 3.46651f
C1899 avdd.n350 avss 0.1208f
C1900 avdd.t7 avss 2.94286f
C1901 avdd.n351 avss 3.26694f
C1902 avdd.n352 avss 0.13594f
C1903 avdd.t212 avss 2.94196f
C1904 avdd.n353 avss 3.2588f
C1905 avdd.n354 avss 0.55459f
C1906 avdd.n355 avss 0.55459f
C1907 avdd.n356 avss 3.26334f
C1908 avdd.n357 avss 0.13594f
C1909 avdd.t155 avss 2.94196f
C1910 avdd.n358 avss 3.2588f
C1911 avdd.t157 avss 2.94286f
C1912 avdd.n360 avss 3.24578f
C1913 avdd.n361 avss 0.82293f
C1914 avdd.n362 avss 0.84082f
C1915 avdd.n363 avss 3.26564f
C1916 avdd.t110 avss 2.94196f
C1917 avdd.n364 avss 3.27867f
C1918 avdd.t111 avss 2.91961f
C1919 avdd.t113 avss 2.94244f
C1920 avdd.n365 avss 0.20684f
C1921 avdd.t192 avss 2.94286f
C1922 avdd.n367 avss 3.29766f
C1923 avdd.n368 avss 0.55459f
C1924 avdd.n369 avss 0.55459f
C1925 avdd.n370 avss 0.68293f
C1926 avdd.n371 avss 0.5367f
C1927 avdd.n372 avss 3.30858f
C1928 avdd.n373 avss 0.10342f
C1929 avdd.n374 avss 0.25635f
C1930 avdd.t190 avss 2.95781f
C1931 avdd.n376 avss 3.26651f
C1932 avdd.t191 avss 4.28815f
C1933 avdd.n379 avss 0.68361f
C1934 avdd.t227 avss 2.95592f
C1935 avdd.t228 avss 4.34762f
C1936 avdd.n380 avss 0.12493f
C1937 avdd.n381 avss 3.2565f
C1938 avdd.n382 avss 0.44725f
C1939 avdd.t80 avss 2.84209f
C1940 avdd.n384 avss 3.318f
C1941 avdd.n386 avss 0.10246f
C1942 avdd.n388 avss 1.44954f
C1943 avdd.t116 avss 1.33836f
C1944 avdd.n389 avss 1.43586f
C1945 avdd.n390 avss 0.44725f
C1946 avdd.t118 avss 1.23697f
C1947 avdd.t43 avss 1.62767f
C1948 avdd.n391 avss 2.01556f
C1949 avdd.n392 avss 0.37569f
C1950 avdd.t46 avss 1.62894f
C1951 avdd.n394 avss 2.02698f
C1952 avdd.n395 avss 0.37569f
C1953 avdd.t45 avss 1.62767f
C1954 avdd.n397 avss 2.05066f
C1955 avdd.t44 avss 1.72743f
C1956 avdd.n399 avss 2.01115f
C1957 avdd.n400 avss 0.63305f
C1958 avdd.n401 avss 0.12296f
C1959 avdd.n402 avss 1.52221f
C1960 avdd.t61 avss 1.3401f
C1961 avdd.t119 avss 1.5178f
C1962 avdd.t62 avss 1.50285f
C1963 avdd.t64 avss 1.50285f
C1964 avdd.n406 avss 0.78839f
C1965 avdd.n407 avss 1.53464f
C1966 avdd.t63 avss 1.3401f
C1967 avdd.n408 avss 1.44127f
C1968 avdd.t28 avss 1.3401f
C1969 avdd.n409 avss 1.5082f
C1970 avdd.n410 avss 1.54912f
C1971 avdd.t152 avss 1.50678f
C1972 avdd.n415 avss 0.10671f
C1973 avdd.n416 avss 3.08941f
C1974 avdd.n418 avss 0.42936f
C1975 avdd.n419 avss 1.46776f
C1976 avdd.t71 avss 1.33815f
C1977 avdd.n420 avss 1.43654f
C1978 avdd.n422 avss 0.38836f
C1979 avdd.n423 avss 0.37569f
C1980 avdd.n424 avss 1.99381f
C1981 avdd.n425 avss 2.00568f
C1982 avdd.n427 avss 0.37058f
C1983 avdd.n428 avss 0.40349f
C1984 avdd.n429 avss 1.99999f
C1985 avdd.t204 avss 1.86579f
C1986 avdd.n430 avss 2.07579f
C1987 avdd.n431 avss 0.62659f
C1988 avdd.t67 avss 1.86731f
C1989 avdd.n435 avss 0.30413f
C1990 avdd.n436 avss 0.10163f
C1991 avdd.t10 avss 1.46654f
C1992 avdd.n438 avss 0.10672f
C1993 avdd.t254 avss 1.46638f
C1994 avdd.n439 avss 0.28959f
C1995 avdd.n440 avss 0.11069f
C1996 avdd.n441 avss 0.67981f
C1997 avdd.n442 avss 5.31404f
C1998 b3.n0 avss 7.68693f
C1999 b3.n1 avss 4.20532f
C2000 b4.n0 avss 4.82903f
C2001 b4.n1 avss 4.13979f
C2002 b0.n0 avss 1.57629f
C2003 b0.n1 avss 0.70924f
C2004 b0.n2 avss 3.75417f
C2005 b5.n0 avss 2.40627f
C2006 b5.n1 avss 4.40653f
C2007 b6.n0 avss 2.15412f
C2008 b6.n1 avss 4.05144f
C2009 b2.n0 avss 3.20411f
C2010 b2.n1 avss 4.21334f
C2011 b1.n0 avss 2.14386f
C2012 b1.n1 avss 4.47046f
C2013 vref.t4 avss 11.03333f
C2014 net4 avss 11.05823f
C2015 net3 avss 22.63894f
C2016 vq2 avss 6.78808f
C2017 v1 avss 14.62458f
C2018 vq3 avss 25.1543f
.ends
