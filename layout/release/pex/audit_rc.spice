* Independent topology audit of the extraction output.
.subckt Bandgap_Core_Res avdd avss vref b0 b1 b2 b3 b4 b5 b6 dvss dvdd
QXpnp_05p00x05p00_0 avss avss vq3 pnp_05p00x05p00
QXpnp_05p00x05p00_1 avss avss vq2 pnp_05p00x05p00
QXpnp_05p00x05p00_2 avss avss vq2 pnp_05p00x05p00
QXpnp_05p00x05p00_4 avss avss vq2 pnp_05p00x05p00
QXpnp_05p00x05p00_3 avss avss vq2 pnp_05p00x05p00
QXpnp_05p00x05p00_5 avss avss v1 pnp_05p00x05p00
QXpnp_05p00x05p00_6 avss avss vq2 pnp_05p00x05p00
QXpnp_05p00x05p00_7 avss avss vq2 pnp_05p00x05p00
QXpnp_05p00x05p00_8 avss avss vq2 pnp_05p00x05p00
QXpnp_05p00x05p00_9 avss avss vq2 pnp_05p00x05p00
RXnwell_0 net3 net4 avss nwell W=2u L=20.19u
MX0 rbit0top b0 rbit1top dvss nfet_03v3 W=40u L=0.28u
MX1 avdd avdd avdd avdd pfet_05v0 W=54.89u L=4u
MX2 avss avss avss avss nfet_05v0 W=7.55u L=4u m=10
MX3 avss avss avss avss nfet_05v0 W=16.34u L=8u m=20
MX4 avdd avdd avdd avdd pfet_05v0 W=16.42u L=4u
MX5 vbn_sink vbp_i avdd avdd pfet_05v0 W=18.95u L=8u
MX6 vbn_sink vbp_i avdd avdd pfet_05v0 W=18.95u L=8u
MX7 avdd avdd avdd avdd pfet_05v0 W=16.75u L=2u
MX8 avdd avdd avdd avdd pfet_05v0 W=16.75u L=2u
MX9 vbn_sink vbp_i avdd avdd pfet_05v0 W=18.95u L=8u
MX10 avdd avdd avdd avdd pfet_05v0 W=18.99u L=8u
MX11 vbn_fold vbp_i avdd avdd pfet_05v0 W=18.99u L=8u
MX12 b3_b b3 dvdd dvdd pfet_03v3 W=3u L=0.5u
MX13 vx1 psrg_m3_feed avdd avdd pfet_05v0 W=16.75u L=2u
MX14 rbit3top b2_b rbit2top dvdd pfet_03v3 W=20u L=0.28u
MX15 pm1 y1 avdd avdd pfet_05v0 W=20.76u L=4u
MX16 vbn vbn avss avss nfet_05v0 W=7.55u L=4u
MX17 avdd avdd avdd avdd pfet_05v0 W=18.75u L=8u
MX18 avdd avdd avdd avdd pfet_05v0 W=18.95u L=8u
MX19 vgn2 vbn_fold xf2 avss nfet_05v0 W=18.49u L=6u
MX20 vbp_cas vbn_i avss avss nfet_05v0 W=0.65u L=8u
MX21 vbn_i vbp_i avdd avdd pfet_05v0 W=18.75u L=8u
MX22 avdd avdd avdd avdd pfet_05v0 W=16.42u L=4u
MX23 vgn2 vbp_cas pm2 avdd pfet_05v0 W=22.21u L=8u
MX24 avdd avdd avdd avdd pfet_05v0 W=16.42u L=4u
MX25 avdd avdd avdd avdd pfet_05v0 W=20.76u L=4u
MX26 avdd avdd avdd avdd pfet_05v0 W=16.75u L=2u
MX27 avdd avdd avdd avdd pfet_05v0 W=18.75u L=8u
MX28 avdd avdd avdd avdd pfet_05v0 W=18.95u L=8u
MX29 avdd avdd avdd avdd pfet_05v0 W=54.89u L=4u
MX30 vbn_fold vbn_fold vnx_bias avss nfet_05v0 W=4.62u L=6u
MX31 xf1 vbn_sink avss avss nfet_05v0 W=16.34u L=8u
MX32 vgn1 aux_gate psrg_m3_feed avdd pfet_05v0 W=2u L=2u
MX33 rbit6top b5_b rbit5top dvdd pfet_03v3 W=7.5u L=0.28u
MX34 avdd avdd avdd avdd pfet_05v0 W=22.21u L=8u
MX35 avdd avdd avdd avdd pfet_05v0 W=18.75u L=8u
RX36 rbit4top rbit3top avss ppolyf_u_1k W=6.6u L=16u
MX37 avss avss avss avss nfet_05v0 W=14.6u L=4u m=14
MX38 vx3 psrg_m3_feed avdd avdd pfet_05v0 W=16.75u L=2u
MX39 avdd avdd avdd avdd pfet_05v0 W=22.21u L=8u
MX40 avdd avdd avdd avdd pfet_05v0 W=16.75u L=2u
MX41 avdd avdd avdd avdd pfet_05v0 W=18.75u L=8u
MX42 avdd avdd avdd avdd pfet_05v0 W=16.75u L=2u
MX43 vaux psrg_m3_feed avdd avdd pfet_05v0 W=10u L=2u
MX44 vbn aux_gate avdd avdd pfet_05v0 W=0.5u L=8u
MX45 avdd avdd avdd avdd pfet_05v0 W=54.89u L=4u
MX46 avdd avdd avdd avdd pfet_05v0 W=54.89u L=4u
RX47 rfix2 rfix1 avss ppolyf_u_1k W=6.6u L=0.128m
MX48 avdd avdd avdd avdd pfet_05v0 W=18.75u L=8u
MX49 avdd avdd avdd avdd pfet_05v0 W=20.76u L=4u
MX50 vref vcasp vx3 avdd pfet_05v0 W=16.42u L=4u
MX51 avdd avdd avdd avdd pfet_05v0 W=16.42u L=4u
RX52 rbit6top rbit5top avss ppolyf_u_1k W=6.6u L=64u
MX53 psrg_vnc psrg_vnc rb_mid avss nfet_05v0 W=0.71u L=20u
MX54 avdd avdd avdd avdd pfet_05v0 W=54.89u L=4u
MX55 vx2 psrg_m3_feed avdd avdd pfet_05v0 W=16.75u L=2u
MX56 avdd avdd avdd avdd pfet_05v0 W=18.75u L=8u
MX57 avdd avdd avdd avdd pfet_05v0 W=22.21u L=8u
MX58 pm1 y1 avdd avdd pfet_05v0 W=20.76u L=4u
MX59 avdd avdd avdd avdd pfet_05v0 W=16.75u L=2u
MX60 avdd avdd avdd avdd pfet_05v0 W=18.99u L=8u
MX61 avdd avdd avdd avdd pfet_05v0 W=18.95u L=8u
MX62 avdd avdd avdd avdd pfet_05v0 W=18.95u L=8u
MX63 avdd avdd avdd avdd pfet_05v0 W=16.42u L=4u
MX64 psrg_m3_feed vcasp vx2 avdd pfet_05v0 W=16.42u L=4u
MX65 pm1 y1 avdd avdd pfet_05v0 W=20.76u L=4u
MX66 vx2 psrg_m3_feed avdd avdd pfet_05v0 W=16.75u L=2u
MX67 avdd avdd avdd avdd pfet_05v0 W=16.42u L=4u
MX68 avdd avdd avdd avdd pfet_05v0 W=18.99u L=8u
MX69 avdd avdd avdd avdd pfet_05v0 W=18.95u L=8u
MX70 avdd avdd avdd avdd pfet_05v0 W=18.95u L=8u
MX71 b2_b b2 dvdd dvdd pfet_03v3 W=3u L=0.5u
MX72 avdd avdd avdd avdd pfet_05v0 W=16.75u L=2u
MX73 avdd avdd avdd avdd pfet_05v0 W=54.89u L=4u
MX74 y1 vbp_cas pm1 avdd pfet_05v0 W=22.21u L=8u
MX75 avdd avdd avdd avdd pfet_05v0 W=22.21u L=8u
MX76 avss avss avss avss nfet_05v0 W=12.31u L=8u m=10
MX77 b5_b b5 dvdd dvdd pfet_03v3 W=3u L=0.5u
MX78 avss avss avss avss nfet_05v0 W=18.49u L=6u m=10
MX79 avdd avdd avdd avdd pfet_05v0 W=54.89u L=4u
MX80 vbp_i vbp_i avdd avdd pfet_05v0 W=18.75u L=8u
MX81 vbp_bias vbp_bias avdd avdd pfet_03v3 W=19.06u L=8u
MX82 avdd avdd avdd avdd pfet_05v0 W=18.75u L=8u
MX83 avdd avdd avdd avdd pfet_05v0 W=20.76u L=4u
MX84 vbp_bias vbp_bias avdd avdd pfet_03v3 W=19.06u L=8u
MX85 xf2 vbn_sink avss avss nfet_05v0 W=16.34u L=8u
CX86 vref avss cap_mim_2f0fF W=70.7u L=70.7u
MX87 vbn_sink vbp_i avdd avdd pfet_05v0 W=18.95u L=8u
MX88 vbn_fold vbp_i avdd avdd pfet_05v0 W=18.99u L=8u
MX89 rbit1top b0_b rbit0top dvdd pfet_03v3 W=40u L=0.28u
MX90 avdd avdd avdd avdd pfet_05v0 W=20.76u L=4u
MX91 vbn_i iref_gate avdd avdd pfet_05v0 W=0.5u L=8u
CX92 vref avss cap_mim_2f0fF W=70.7u L=70.7u
MX93 avdd avdd avdd avdd pfet_05v0 W=18.95u L=8u
MX94 avdd avdd avdd avdd pfet_05v0 W=18.95u L=8u
MX95 avdd avdd avdd avdd pfet_05v0 W=18.75u L=8u
MX96 iref_gate vbp_i vsu1 avss nfet_05v0 W=0.5u L=50u
MX97 vgn2 vbp_cas pm2 avdd pfet_05v0 W=22.21u L=8u
MX98 vbn_fold vbp_i avdd avdd pfet_05v0 W=18.99u L=8u
RX99 rbit0top rfix2 avss ppolyf_u_1k W=6.6u L=0.128m
MX100 vsp vbp_tail avdd avdd pfet_03v3 W=28.91u L=6u
MX101 avdd avdd avdd avdd pfet_05v0 W=16.42u L=4u
MX102 rbit4top b3_b rbit3top dvdd pfet_03v3 W=30u L=0.28u
MX103 avdd avdd avdd avdd pfet_05v0 W=16.42u L=4u
MX104 su_state vsu avdd avdd pfet_05v0 W=1u L=8u
MX105 xf1 vbn_sink avss avss nfet_05v0 W=16.34u L=8u
MX106 avdd avdd avdd avdd pfet_05v0 W=18.99u L=8u
MX107 rbit5top b4_b rbit4top dvdd pfet_03v3 W=15u L=0.28u
MX108 avdd avdd avdd avdd pfet_05v0 W=18.95u L=8u
MX109 vbn_i vbp_i avdd avdd pfet_05v0 W=18.75u L=8u
MX110 xf2 vbn_sink avss avss nfet_05v0 W=16.34u L=8u
MX111 avdd avdd avdd avdd pfet_05v0 W=20.76u L=4u
MX112 avdd avdd avdd avdd pfet_05v0 W=16.42u L=4u
MX113 xf1 v1 vsp avdd pfet_05v0 W=54.89u L=4u
MX114 rbit2top b1_b rbit1top dvdd pfet_03v3 W=40u L=0.28u
MX115 psrg_m3_feed psrg_vnc psrg_m3_protected avss nfet_05v0 W=14.6u L=4u
MX116 avdd avdd avdd avdd pfet_05v0 W=18.95u L=8u
MX117 rbit4top b4 rbit5top dvss nfet_03v3 W=5u L=0.28u
MX118 avdd avdd avdd avdd pfet_05v0 W=18.99u L=8u
MX119 vbn_sink vbn_sink avss avss nfet_05v0 W=12.31u L=8u
MX120 avdd avdd avdd avdd pfet_05v0 W=54.89u L=4u
MX121 avdd avdd avdd avdd pfet_05v0 W=16.42u L=4u
MX122 vbp_tail vbp_tail avdd avdd pfet_03v3 W=13.75u L=6u
MX123 avdd avdd avdd avdd pfet_05v0 W=16.42u L=4u
MX124 avdd avdd avdd avdd pfet_05v0 W=54.89u L=4u
MX125 vbp_cas vbp_cas vbp_bias avdd pfet_05v0 W=18.93u L=8u
MX126 pm2 y1 avdd avdd pfet_05v0 W=20.76u L=4u
MX127 avdd avdd avdd avdd pfet_05v0 W=16.75u L=2u
MX128 xf2 v2 vsp avdd pfet_05v0 W=54.89u L=4u
MX129 vaux psrg_m3_feed avdd avdd pfet_05v0 W=10u L=2u
MX130 avdd avdd avdd avdd pfet_05v0 W=22.21u L=8u
MX131 su_state vbp_tail avdd avdd pfet_05v0 W=1u L=8u
MX132 avdd avdd avdd avdd pfet_05v0 W=54.89u L=4u
MX133 avdd avdd avdd avdd pfet_05v0 W=16.42u L=4u
MX134 avdd avdd avdd avdd pfet_05v0 W=20.76u L=4u
MX135 avdd avdd avdd avdd pfet_05v0 W=18.95u L=8u
MX136 pm2 y1 avdd avdd pfet_05v0 W=20.76u L=4u
MX137 avdd avdd avdd avdd pfet_05v0 W=16.42u L=4u
MX138 avdd avdd avdd avdd pfet_05v0 W=16.42u L=4u
MX139 psrg_vnc vbp_i avdd avdd pfet_05v0 W=17.74u L=4u
MX140 avdd avdd avdd avdd pfet_05v0 W=18.75u L=8u
MX141 avdd avdd avdd avdd pfet_05v0 W=18.95u L=8u
MX142 xf1 vbn_sink avss avss nfet_05v0 W=16.34u L=8u
MX143 vbn_sink vbp_i avdd avdd pfet_05v0 W=18.95u L=8u
MX144 vcasp vcasp avdd avdd pfet_05v0 W=0.9u L=2u
MX145 avdd avdd avdd avdd pfet_05v0 W=18.99u L=8u
MX146 vx2 psrg_m3_feed avdd avdd pfet_05v0 W=16.75u L=2u
MX147 vbp_bias vbp_bias avdd avdd pfet_03v3 W=19.06u L=8u
MX148 avdd avdd avdd avdd pfet_05v0 W=16.42u L=4u
RX149 rfix0 vref avss ppolyf_u_1k W=6.6u L=0.128m
MX150 avdd avdd avdd avdd pfet_05v0 W=16.42u L=4u
MX151 avdd avdd avdd avdd pfet_05v0 W=16.42u L=4u
MX152 vbn_fold vbp_i avdd avdd pfet_05v0 W=18.99u L=8u
MX153 pm2 y1 avdd avdd pfet_05v0 W=20.76u L=4u
MX154 vref vcasp vx3 avdd pfet_05v0 W=16.42u L=4u
MX155 avdd avdd avdd avdd pfet_05v0 W=18.75u L=8u
MX156 y1 vbp_cas pm1 avdd pfet_05v0 W=22.21u L=8u
MX157 avdd avdd avdd avdd pfet_05v0 W=18.95u L=8u
MX158 vsu2 vbp_i avss avss nfet_05v0 W=0.5u L=50u
MX159 vbn_sink vbp_i avdd avdd pfet_05v0 W=18.95u L=8u
MX160 avdd avdd avdd avdd pfet_05v0 W=22.21u L=8u
MX161 avdd avdd avdd avdd pfet_05v0 W=20.76u L=4u
MX162 vx1 psrg_m3_feed avdd avdd pfet_05v0 W=16.75u L=2u
MX163 avdd avdd avdd avdd pfet_05v0 W=54.89u L=4u
MX164 avdd avdd avdd avdd pfet_05v0 W=18.95u L=8u
MX165 vsp vbp_tail avdd avdd pfet_03v3 W=28.91u L=6u
RX166 rbit3top rbit2top avss ppolyf_u_1k W=6.6u L=8u
MX167 avdd avdd avdd avdd pfet_05v0 W=20.76u L=4u
MX168 vbn_sink vbp_i avdd avdd pfet_05v0 W=18.95u L=8u
MX169 xf1 v1 vsp avdd pfet_05v0 W=54.89u L=4u
MX170 avdd avdd avdd avdd pfet_05v0 W=22.21u L=8u
CX171 vref avss cap_mim_2f0fF W=70.7u L=70.7u
MX172 avdd avdd avdd avdd pfet_05v0 W=18.75u L=8u
CX173 vref avss cap_mim_2f0fF W=70.7u L=70.7u
MX174 avdd avdd avdd avdd pfet_05v0 W=54.89u L=4u
MX175 vbn_fold vbp_i avdd avdd pfet_05v0 W=18.99u L=8u
MX176 vbp_cas vbp_cas vbp_bias avdd pfet_05v0 W=18.93u L=8u
MX177 vbp_i vbp_i avdd avdd pfet_05v0 W=18.75u L=8u
MX178 vbn_sink vbn_sink avss avss nfet_05v0 W=12.31u L=8u
MX179 vbn_fold vbp_i avdd avdd pfet_05v0 W=18.99u L=8u
MX180 psrg_m3_feed vcasp vx2 avdd pfet_05v0 W=16.42u L=4u
MX181 psrg_m3_feed vcasp vx2 avdd pfet_05v0 W=16.42u L=4u
MX182 psrg_vnc vbp_i avdd avdd pfet_05v0 W=17.74u L=4u
MX183 vsp vbp_tail avdd avdd pfet_03v3 W=28.91u L=6u
MX184 avdd avdd avdd avdd pfet_05v0 W=18.99u L=8u
MX185 avdd avdd avdd avdd pfet_05v0 W=16.75u L=2u
MX186 vbp_tail vbp_tail avdd avdd pfet_03v3 W=13.75u L=6u
MX187 vbp_bias vbp_bias avdd avdd pfet_03v3 W=19.06u L=8u
MX188 avdd avdd avdd avdd pfet_05v0 W=54.89u L=4u
MX189 vbp_cas vbp_cas vbp_bias avdd pfet_05v0 W=18.93u L=8u
MX190 psrg_m3_feed vcasp vx2 avdd pfet_05v0 W=16.42u L=4u
MX191 avdd avdd avdd avdd pfet_05v0 W=16.75u L=2u
RX192 rfix1 rfix0 avss ppolyf_u_1k W=6.6u L=0.128m
MX193 vbp_cas vbp_cas vbp_bias avdd pfet_05v0 W=18.93u L=8u
MX194 vbp_cas vbp_cas vbp_bias avdd pfet_05v0 W=18.93u L=8u
MX195 avdd avdd avdd avdd pfet_05v0 W=18.75u L=8u
MX196 avdd avdd avdd avdd pfet_05v0 W=18.95u L=8u
MX197 xf2 vbn_sink avss avss nfet_05v0 W=16.34u L=8u
MX198 avdd avdd avdd avdd pfet_05v0 W=54.89u L=4u
MX199 avdd avdd avdd avdd pfet_05v0 W=16.42u L=4u
MX200 avdd avdd avdd avdd pfet_05v0 W=20.76u L=4u
RX201 avss net3 avdd pplus_u W=1u L=0.23253m
MX202 vbn_i vbn_i avss avss nfet_05v0 W=7.78u L=8u
MX203 psrg_m3_feed vcasp vx2 avdd pfet_05v0 W=16.42u L=4u
MX204 y1 psrg_vnc psrg_mf1_protected avss nfet_05v0 W=18.49u L=6u
MX205 avdd avdd avdd avdd pfet_05v0 W=16.42u L=4u
MX206 avdd avdd avdd avdd pfet_05v0 W=20.76u L=4u
MX207 pm2 y1 avdd avdd pfet_05v0 W=20.76u L=4u
MX208 avdd avdd avdd avdd pfet_05v0 W=20.76u L=4u
RX209 vq2 v2 avss ppolyf_u_1k W=4u L=42.1u
MX210 avdd avdd avdd avdd pfet_05v0 W=18.95u L=8u
MX211 xf2 v2 vsp avdd pfet_05v0 W=54.89u L=4u
MX212 vbp_i vbn_i net4 avss nfet_05v0 W=9.13u L=8u
MX213 psrg_vnc vbp_i avdd avdd pfet_05v0 W=17.74u L=4u
MX214 avdd avdd avdd avdd pfet_05v0 W=18.99u L=8u
MX215 avdd avdd avdd avdd pfet_05v0 W=18.75u L=8u
MX216 rbit3top b3 rbit4top dvss nfet_03v3 W=10u L=0.28u
MX217 avdd avdd avdd avdd pfet_05v0 W=54.89u L=4u
MX218 avdd avdd avdd avdd pfet_05v0 W=54.89u L=4u
MX219 avdd avdd avdd avdd pfet_05v0 W=18.75u L=8u
MX220 avdd avdd avdd avdd pfet_05v0 W=18.99u L=8u
MX221 avdd avdd avdd avdd pfet_05v0 W=16.75u L=2u
MX222 avdd avdd avdd avdd pfet_05v0 W=16.42u L=4u
MX223 vbp_tail vbn_i avss avss nfet_05v0 W=13.95u L=8u
MX224 vbp_bias vbp_bias avdd avdd pfet_03v3 W=19.06u L=8u
MX225 avdd avdd avdd avdd pfet_05v0 W=54.89u L=4u
MX226 avdd avdd avdd avdd pfet_05v0 W=20.76u L=4u
MX227 vsua vsua auxsu1 avss nfet_05v0 W=1u L=2u
MX228 avdd avdd avdd avdd pfet_05v0 W=20.76u L=4u
CX229 vgn2 avss cap_mim_2f0fF W=59u L=59u
MX230 vbn_sink vbp_i avdd avdd pfet_05v0 W=18.95u L=8u
MX231 avdd avdd avdd avdd pfet_05v0 W=18.99u L=8u
MX232 rbit1top b0_b rbit0top dvdd pfet_03v3 W=40u L=0.28u
MX233 rbit1top b0_b rbit0top dvdd pfet_03v3 W=40u L=0.28u
MX234 b3_b b3 dvss dvss nfet_03v3 W=1u L=0.5u
MX235 avdd avdd avdd avdd pfet_05v0 W=18.75u L=8u
MX236 vbn_sink vbp_i avdd avdd pfet_05v0 W=18.95u L=8u
MX237 vbn_fold vbp_i avdd avdd pfet_05v0 W=18.99u L=8u
MX238 vbn_fold vbp_i avdd avdd pfet_05v0 W=18.99u L=8u
MX239 vx1 psrg_m3_feed avdd avdd pfet_05v0 W=16.75u L=2u
MX240 b5_b b5 dvss dvss nfet_03v3 W=1u L=0.5u
MX241 vbn_fold vbp_i avdd avdd pfet_05v0 W=18.99u L=8u
MX242 avdd avdd avdd avdd pfet_05v0 W=18.75u L=8u
MX243 vbn_sink vbp_i avdd avdd pfet_05v0 W=18.95u L=8u
MX244 avdd avdd avdd avdd pfet_05v0 W=22.21u L=8u
MX245 vbp_i vbp_i avdd avdd pfet_05v0 W=18.75u L=8u
MX246 vbn_sink vbp_i avdd avdd pfet_05v0 W=18.95u L=8u
MX247 avdd avdd avdd avdd pfet_05v0 W=20.76u L=4u
MX248 xf2 v2 vsp avdd pfet_05v0 W=54.89u L=4u
MX249 avdd avdd avdd avdd pfet_05v0 W=16.75u L=2u
MX250 b6_b b6 dvdd dvdd pfet_03v3 W=3u L=0.5u
MX251 psrg_mf1_protected vbn_fold xf1 avss nfet_05v0 W=18.49u L=6u
MX252 pm1 y1 avdd avdd pfet_05v0 W=20.76u L=4u
MX253 bgsu1 bgsu1 bgsu2 avss nfet_03v3 W=1u L=2u
MX254 psrg_m3_feed psrg_vnc psrg_m3_protected avss nfet_05v0 W=14.6u L=4u
MX255 vx1 psrg_m3_feed avdd avdd pfet_05v0 W=16.75u L=2u
MX256 vgn1 vcasp vx1 avdd pfet_05v0 W=16.42u L=4u
MX257 avdd avdd avdd avdd pfet_05v0 W=22.21u L=8u
MX258 vbp_bias vbp_bias avdd avdd pfet_03v3 W=19.06u L=8u
MX259 avdd avdd avdd avdd pfet_05v0 W=16.42u L=4u
MX260 avdd avdd avdd avdd pfet_05v0 W=18.95u L=8u
MX261 psrg_vnc vbp_i avdd avdd pfet_05v0 W=17.74u L=4u
MX262 avdd avdd avdd avdd pfet_05v0 W=18.99u L=8u
MX263 vbn_fold vbp_i avdd avdd pfet_05v0 W=18.99u L=8u
MX264 avdd avdd avdd avdd pfet_05v0 W=16.42u L=4u
MX265 b1_b b1 dvdd dvdd pfet_03v3 W=3u L=0.5u
MX266 iref_gate vbp_i avdd avdd pfet_05v0 W=80u L=1u
MX267 vbp_cas vbp_cas vbp_bias avdd pfet_05v0 W=18.93u L=8u
RX268 vq3 rbit6top avss ppolyf_u_1k W=6.6u L=0.128m
MX269 vgn1 vgn1 v1 avss nfet_05v0 W=14.6u L=4u
MX270 avdd avdd avdd avdd pfet_05v0 W=18.99u L=8u
MX271 avdd avdd avdd avdd pfet_05v0 W=54.89u L=4u
MX272 vq3 b6_b rbit6top dvdd pfet_03v3 W=3.75u L=0.28u
MX273 avdd avdd avdd avdd pfet_05v0 W=16.42u L=4u
MX274 vbp_cas vbp_cas vbp_bias avdd pfet_05v0 W=18.93u L=8u
MX275 avdd avdd avdd avdd pfet_05v0 W=16.42u L=4u
MX276 rbit3top b2_b rbit2top dvdd pfet_03v3 W=20u L=0.28u
MX277 avdd avdd avdd avdd pfet_05v0 W=16.42u L=4u
MX278 vref vcasp vx3 avdd pfet_05v0 W=16.42u L=4u
MX279 vbp_cas vbp_cas vbp_bias avdd pfet_05v0 W=18.93u L=8u
MX280 psrg_vnc vbp_i avdd avdd pfet_05v0 W=17.74u L=4u
MX281 psrg_m3_protected vgn2 v2 avss nfet_05v0 W=14.6u L=4u
MX282 vx3 psrg_m3_feed avdd avdd pfet_05v0 W=16.75u L=2u
MX283 xf2 vbn_sink avss avss nfet_05v0 W=16.34u L=8u
MX284 vx3 psrg_m3_feed avdd avdd pfet_05v0 W=16.75u L=2u
MX285 avdd avdd avdd avdd pfet_05v0 W=54.89u L=4u
MX286 avdd avdd avdd avdd pfet_05v0 W=54.89u L=4u
MX287 psrg_m3_protected vgn2 v2 avss nfet_05v0 W=14.6u L=4u
MX288 vgn1 vcasp vx1 avdd pfet_05v0 W=16.42u L=4u
MX289 avdd avdd avdd avdd pfet_05v0 W=18.99u L=8u
MX290 avdd avdd avdd avdd pfet_05v0 W=16.75u L=2u
MX291 vgn1 vcasp vx1 avdd pfet_05v0 W=16.42u L=4u
MX292 avdd avdd avdd avdd pfet_05v0 W=16.42u L=4u
MX293 avdd avdd avdd avdd pfet_05v0 W=54.89u L=4u
MX294 rbit2top b2 rbit3top dvss nfet_03v3 W=20u L=0.28u
MX295 xf1 v1 vsp avdd pfet_05v0 W=54.89u L=4u
MX296 avdd avdd avdd avdd pfet_05v0 W=18.75u L=8u
MX297 avdd avdd avdd avdd pfet_05v0 W=18.95u L=8u
MX298 vx2 psrg_m3_feed avdd avdd pfet_05v0 W=16.75u L=2u
MX299 vsu psrg_m3_feed avdd avdd pfet_05v0 W=2u L=2u
MX300 avdd avdd avdd avdd pfet_05v0 W=18.75u L=8u
CX301 vref avss cap_mim_2f0fF W=70.7u L=70.7u
MX302 avdd avdd avdd avdd pfet_05v0 W=18.95u L=8u
MX303 rbit5top b5 rbit6top dvss nfet_03v3 W=2.5u L=0.28u
MX304 avdd avdd avdd avdd pfet_05v0 W=22.21u L=8u
MX305 xf2 v2 vsp avdd pfet_05v0 W=54.89u L=4u
MX306 avdd avdd avdd avdd pfet_05v0 W=18.75u L=8u
CX307 vref avss cap_mim_2f0fF W=70.7u L=70.7u
MX308 avdd avdd avdd avdd pfet_05v0 W=16.75u L=2u
MX309 vbp_bias vbp_bias avdd avdd pfet_03v3 W=19.06u L=8u
RX310 rbit1top rbit0top avss ppolyf_u_1k W=6.6u L=2u
MX311 vgn1 vcasp vx1 avdd pfet_05v0 W=16.42u L=4u
CX312 vref avss cap_mim_2f0fF W=70.7u L=70.7u
MX313 vbn_i vbp_i avdd avdd pfet_05v0 W=18.75u L=8u
MX314 avdd avdd avdd avdd pfet_05v0 W=18.75u L=8u
MX315 avdd avdd avdd avdd pfet_05v0 W=54.89u L=4u
MX316 vbn_i vbp_i avdd avdd pfet_05v0 W=18.75u L=8u
MX317 avdd avdd avdd avdd pfet_05v0 W=18.99u L=8u
CX318 vref avss cap_mim_2f0fF W=70.7u L=70.7u
MX319 avdd avdd avdd avdd pfet_05v0 W=16.75u L=2u
MX320 b4_b b4 dvdd dvdd pfet_03v3 W=3u L=0.5u
MX321 vnx_bias vnx_bias avss avss nfet_03v3 W=1.62u L=8u
MX322 vbn vcasp vaux avdd pfet_05v0 W=16u L=4u
MX323 vx1 psrg_m3_feed avdd avdd pfet_05v0 W=16.75u L=2u
MX324 rbit2top b1_b rbit1top dvdd pfet_03v3 W=40u L=0.28u
MX325 vbn_fold vbp_i avdd avdd pfet_05v0 W=18.99u L=8u
MX326 pm2 y1 avdd avdd pfet_05v0 W=20.76u L=4u
MX327 avdd avdd avdd avdd pfet_05v0 W=16.42u L=4u
MX328 vbn_sink vbp_i avdd avdd pfet_05v0 W=18.95u L=8u
MX329 vbn_fold vbp_i avdd avdd pfet_05v0 W=18.99u L=8u
MX330 b1_b b1 dvss dvss nfet_03v3 W=1u L=0.5u
MX331 vbp_bias vbp_bias avdd avdd pfet_03v3 W=19.06u L=8u
MX332 xf2 vbn_sink avss avss nfet_05v0 W=16.34u L=8u
MX333 rbit1top b1 rbit2top dvss nfet_03v3 W=40u L=0.28u
MX334 pm1 y1 avdd avdd pfet_05v0 W=20.76u L=4u
MX335 vsu vsu bgsu1 avss nfet_05v0 W=1u L=2u
MX336 vgn2 vbp_cas pm2 avdd pfet_05v0 W=22.21u L=8u
MX337 avdd avdd avdd avdd pfet_05v0 W=22.21u L=8u
MX338 xf1 vbn_sink avss avss nfet_05v0 W=16.34u L=8u
MX339 b4_b b4 dvss dvss nfet_03v3 W=1u L=0.5u
MX340 vbn_sink vbp_i avdd avdd pfet_05v0 W=18.95u L=8u
MX341 vbp_cas vbp_cas vbp_bias avdd pfet_05v0 W=18.93u L=8u
MX342 avdd avdd avdd avdd pfet_05v0 W=18.75u L=8u
MX343 xf1 vbn_sink avss avss nfet_05v0 W=16.34u L=8u
MX344 avdd avdd avdd avdd pfet_05v0 W=22.21u L=8u
MX345 vsp vbp_tail avdd avdd pfet_03v3 W=28.91u L=6u
MX346 avdd avdd avdd avdd pfet_05v0 W=18.95u L=8u
MX347 vbp_cas vbp_cas vbp_bias avdd pfet_05v0 W=18.93u L=8u
MX348 aux_gate vbn_i avss avss nfet_05v0 W=1u L=8u
MX349 avdd avdd avdd avdd pfet_05v0 W=18.99u L=8u
MX350 avdd avdd avdd avdd pfet_05v0 W=18.75u L=8u
MX351 avdd avdd avdd avdd pfet_05v0 W=16.42u L=4u
MX352 avdd avdd avdd avdd pfet_05v0 W=16.75u L=2u
MX353 avdd avdd avdd avdd pfet_05v0 W=54.89u L=4u
MX354 avdd avdd avdd avdd pfet_05v0 W=18.99u L=8u
MX355 vgn1 vgn1 v1 avss nfet_05v0 W=14.6u L=4u
MX356 rb_mid rb_mid avss avss nfet_05v0 W=0.54u L=20u
MX357 avdd avdd avdd avdd pfet_05v0 W=20.76u L=4u
MX358 avdd avdd avdd avdd pfet_05v0 W=54.89u L=4u
MX359 avdd avdd avdd avdd pfet_05v0 W=22.21u L=8u
MX360 rbit1top b0_b rbit0top dvdd pfet_03v3 W=40u L=0.28u
MX361 vref vcasp vx3 avdd pfet_05v0 W=16.42u L=4u
MX362 xf2 vbn_sink avss avss nfet_05v0 W=16.34u L=8u
MX363 avdd avdd avdd avdd pfet_05v0 W=54.89u L=4u
MX364 avdd avdd avdd avdd pfet_05v0 W=18.75u L=8u
MX365 avdd avdd avdd avdd pfet_05v0 W=22.21u L=8u
MX366 b0_b b0 dvss dvss nfet_03v3 W=1u L=0.5u
MX367 y1 vbp_cas pm1 avdd pfet_05v0 W=22.21u L=8u
MX368 vbp_tail vbp_tail avdd avdd pfet_03v3 W=13.75u L=6u
MX369 rbit6top b6 vq3 dvss nfet_03v3 W=1.25u L=0.28u
MX370 xf2 v2 vsp avdd pfet_05v0 W=54.89u L=4u
MX371 vbp_i vbp_i avdd avdd pfet_05v0 W=18.75u L=8u
MX372 avdd avdd avdd avdd pfet_05v0 W=54.89u L=4u
MX373 vbp_bias vbp_bias avdd avdd pfet_03v3 W=19.06u L=8u
MX374 vbn_i vbp_i avdd avdd pfet_05v0 W=18.75u L=8u
CX375 vref avss cap_mim_2f0fF W=70.7u L=70.7u
MX376 avdd avdd avdd avdd pfet_05v0 W=18.75u L=8u
MX377 avdd avdd avdd avdd pfet_05v0 W=18.95u L=8u
MX378 vbn_sink vbp_i avdd avdd pfet_05v0 W=18.95u L=8u
MX379 vx3 psrg_m3_feed avdd avdd pfet_05v0 W=16.75u L=2u
MX380 vx2 psrg_m3_feed avdd avdd pfet_05v0 W=16.75u L=2u
MX381 avdd avdd avdd avdd pfet_05v0 W=16.75u L=2u
MX382 avdd avdd avdd avdd pfet_05v0 W=20.76u L=4u
CX383 vref avss cap_mim_2f0fF W=70.7u L=70.7u
MX384 iref_gate vbp_i avdd avdd pfet_05v0 W=80u L=1u
MX385 avdd avdd avdd avdd pfet_05v0 W=16.75u L=2u
MX386 vsua vcasp avdd avdd pfet_05v0 W=2u L=2u
MX387 avdd avdd avdd avdd pfet_05v0 W=16.42u L=4u
MX388 vbn_sink vbp_i avdd avdd pfet_05v0 W=18.95u L=8u
MX389 vbn_sink vbp_i avdd avdd pfet_05v0 W=18.95u L=8u
MX390 psrg_vnc vbp_i avdd avdd pfet_05v0 W=17.74u L=4u
MX391 b6_b b6 dvss dvss nfet_03v3 W=1u L=0.5u
MX392 avdd avdd avdd avdd pfet_05v0 W=22.21u L=8u
MX393 vsu1 vbp_i vsu2 avss nfet_05v0 W=0.5u L=50u
MX394 avdd avdd avdd avdd pfet_05v0 W=16.75u L=2u
MX395 vbp_i vbp_i avdd avdd pfet_05v0 W=18.75u L=8u
MX396 avdd avdd avdd avdd pfet_05v0 W=22.21u L=8u
MX397 bgsu2 bgsu2 avss avss nfet_03v3 W=1u L=2u
MX398 y1 vbp_cas pm1 avdd pfet_05v0 W=22.21u L=8u
MX399 xf1 v1 vsp avdd pfet_05v0 W=54.89u L=4u
MX400 vcasp vbn avss avss nfet_05v0 W=7.55u L=4u
MX401 b2_b b2 dvss dvss nfet_03v3 W=1u L=0.5u
MX402 avdd avdd avdd avdd pfet_05v0 W=18.95u L=8u
MX403 avdd avdd avdd avdd pfet_05v0 W=18.99u L=8u
MX404 vx1 psrg_m3_feed avdd avdd pfet_05v0 W=16.75u L=2u
MX405 su_state vgn2 avss avss nfet_05v0 W=4u L=1u
MX406 vgn2 vbp_cas pm2 avdd pfet_05v0 W=22.21u L=8u
MX407 avdd avdd avdd avdd pfet_05v0 W=16.75u L=2u
MX408 vref vcasp vx3 avdd pfet_05v0 W=16.42u L=4u
MX409 rbit3top b2_b rbit2top dvdd pfet_03v3 W=20u L=0.28u
RX410 rbit5top rbit4top avss ppolyf_u_1k W=6.6u L=32u
MX411 avdd avdd avdd avdd pfet_05v0 W=20.76u L=4u
MX412 auxsu1 auxsu1 auxsu2 avss nfet_03v3 W=1u L=2u
MX413 vgn1 vcasp vx1 avdd pfet_05v0 W=16.42u L=4u
MX414 vsp vbp_tail avdd avdd pfet_03v3 W=28.91u L=6u
MX415 avdd avdd avdd avdd pfet_05v0 W=18.99u L=8u
MX416 vbn_sink vbp_i avdd avdd pfet_05v0 W=18.95u L=8u
MX417 b0_b b0 dvdd dvdd pfet_03v3 W=3u L=0.5u
MX418 avdd avdd avdd avdd pfet_05v0 W=16.42u L=4u
RX419 rbit2top rbit1top avss ppolyf_u_1k W=6.6u L=4u
MX420 avdd avdd avdd avdd pfet_05v0 W=16.75u L=2u
MX421 aux_gate vcasp avdd avdd pfet_05v0 W=0.5u L=10u
MX422 vx3 psrg_m3_feed avdd avdd pfet_05v0 W=16.75u L=2u
MX423 avdd avdd avdd avdd pfet_05v0 W=16.42u L=4u
MX424 avdd avdd avdd avdd pfet_05v0 W=20.76u L=4u
MX425 avdd avdd avdd avdd pfet_05v0 W=16.42u L=4u
MX426 xf1 vbn_sink avss avss nfet_05v0 W=16.34u L=8u
MX427 vgn2 vbp_cas pm2 avdd pfet_05v0 W=22.21u L=8u
MX428 avdd avdd avdd avdd pfet_05v0 W=22.21u L=8u
MX429 avdd avdd avdd avdd pfet_05v0 W=18.75u L=8u
MX430 avdd avdd avdd avdd pfet_05v0 W=20.76u L=4u
MX431 rbit1top b0_b rbit0top dvdd pfet_03v3 W=40u L=0.28u
MX432 y1 vbp_cas pm1 avdd pfet_05v0 W=22.21u L=8u
MX433 vsp vbp_tail avdd avdd pfet_03v3 W=28.91u L=6u
MX434 avdd avdd avdd avdd pfet_05v0 W=18.75u L=8u
MX435 vx2 psrg_m3_feed avdd avdd pfet_05v0 W=16.75u L=2u
MX436 y1 vbp_cas pm1 avdd pfet_05v0 W=22.21u L=8u
MX437 avdd avdd avdd avdd pfet_05v0 W=18.75u L=8u
MX438 avdd avdd avdd avdd pfet_05v0 W=20.76u L=4u
MX439 xf1 v1 vsp avdd pfet_05v0 W=54.89u L=4u
MX440 vx3 psrg_m3_feed avdd avdd pfet_05v0 W=16.75u L=2u
MX441 avdd avdd avdd avdd pfet_05v0 W=18.75u L=8u
MX442 avdd avdd avdd avdd pfet_05v0 W=16.42u L=4u
MX443 avdd avdd avdd avdd pfet_05v0 W=16.75u L=2u
MX444 avdd avdd avdd avdd pfet_05v0 W=16.42u L=4u
MX445 auxsu2 auxsu2 avss avss nfet_03v3 W=1u L=2u
MX446 avdd avdd avdd avdd pfet_05v0 W=18.75u L=8u
MX447 rbit1top b0_b rbit0top dvdd pfet_03v3 W=40u L=0.28u
MX448 avdd avdd avdd avdd pfet_05v0 W=54.89u L=4u
MX449 avdd avdd avdd avdd pfet_05v0 W=18.99u L=8u
MX450 pm2 y1 avdd avdd pfet_05v0 W=20.76u L=4u
MX451 avdd avdd avdd avdd pfet_05v0 W=18.95u L=8u
MX452 avdd avdd avdd avdd pfet_05v0 W=22.21u L=8u
MX453 rbit2top b1_b rbit1top dvdd pfet_03v3 W=40u L=0.28u
MX454 avdd avdd avdd avdd pfet_05v0 W=54.89u L=4u
MX455 avdd avdd avdd avdd pfet_05v0 W=18.99u L=8u
MX456 avdd avdd avdd avdd pfet_05v0 W=22.21u L=8u
MX457 avdd avdd avdd avdd pfet_05v0 W=54.89u L=4u
MX458 vgn2 vbp_cas pm2 avdd pfet_05v0 W=22.21u L=8u
MX459 pm1 y1 avdd avdd pfet_05v0 W=20.76u L=4u
MX460 avdd avdd avdd avdd pfet_05v0 W=22.21u L=8u
MX461 psrg_vnc vbp_i avdd avdd pfet_05v0 W=17.74u L=4u
MX462 rbit0top b0 rbit1top dvss nfet_03v3 W=40u L=0.28u
.ends Bandgap_Core_Res
