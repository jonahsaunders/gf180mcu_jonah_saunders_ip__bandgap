* Independent topology audit of the extraction output.
.subckt Bandgap_Core_Res avdd avss vref b0 b1 b2 b3 b4 b5 b6 dvss dvdd
QXpnp_05p00x05p00_0 avss avss vq3 pnp_05p00x05p00
QXpnp_05p00x05p00_1 avss avss vq2 pnp_05p00x05p00
QXpnp_05p00x05p00_2 avss avss vq2 pnp_05p00x05p00
QXpnp_05p00x05p00_4 avss avss vq2 pnp_05p00x05p00
QXpnp_05p00x05p00_3 avss avss vq2 pnp_05p00x05p00
QXpnp_05p00x05p00_5 avss avss v1 pnp_05p00x05p00
QXpnp_05p00x05p00_6 avss avss vq2 pnp_05p00x05p00
QXpnp_05p00x05p00_7 avss avss vq2 pnp_05p00x05p00
QXpnp_05p00x05p00_8 avss avss vq2 pnp_05p00x05p00
QXpnp_05p00x05p00_9 avss avss vq2 pnp_05p00x05p00
RXnwell_0 net3 net4 avss nwell W=2u L=20.19u
MX0 rbit0top b0 rbit1top dvss nfet_03v3 W=40u L=0.28u
MX1 vref vcasp vx3 avdd pfet_05v0 W=16.42u L=4u
MX2 vx2 psrg_m3_feed avdd avdd pfet_05v0 W=16.75u L=2u
MX3 vbn_sink vbn_sink avss avss nfet_05v0 W=12.31u L=8u
MX4 vbn_fold vbp_i avdd avdd pfet_05v0 W=18.99u L=8u
MX5 vx3 psrg_m3_feed avdd avdd pfet_05v0 W=16.75u L=2u
MX6 vbp_bias vbp_bias avdd avdd pfet_03v3 W=19.06u L=8u
CX7 vgn2 avss cap_mim_2f0fF W=59u L=59u
MX8 vbn_sink vbp_i avdd avdd pfet_05v0 W=18.95u L=8u
MX9 b3_b b3 dvdd dvdd pfet_03v3 W=3u L=0.5u
MX10 vref vcasp vx3 avdd pfet_05v0 W=16.42u L=4u
MX11 vbn_sink vbp_i avdd avdd pfet_05v0 W=18.95u L=8u
CX12 vref avss cap_mim_2f0fF W=70.7u L=70.7u
MX13 su_state vbp_tail avdd avdd pfet_05v0 W=1u L=8u
MX14 vbn_i vbp_i avdd avdd pfet_05v0 W=18.75u L=8u
MX15 rbit3top b2_b rbit2top dvdd pfet_03v3 W=20u L=0.28u
MX16 xf2 vbn_sink avss avss nfet_05v0 W=16.34u L=8u
MX17 rbit6top b5_b rbit5top dvdd pfet_03v3 W=7.5u L=0.28u
RX18 rbit4top rbit3top avss ppolyf_u_1k W=6.6u L=16u
MX19 vbp_bias vbp_bias avdd avdd pfet_03v3 W=19.06u L=8u
MX20 rb_mid rb_mid avss avss nfet_05v0 W=0.54u L=20u
MX21 vgn1 vcasp vx1 avdd pfet_05v0 W=16.42u L=4u
MX22 xf1 v1 vsp avdd pfet_05v0 W=54.89u L=4u
RX23 rfix2 rfix1 avss ppolyf_u_1k W=6.6u L=0.128m
MX24 vx3 psrg_m3_feed avdd avdd pfet_05v0 W=16.75u L=2u
MX25 vgn2 vbp_cas pm2 avdd pfet_05v0 W=22.21u L=8u
MX26 vbp_bias vbp_bias avdd avdd pfet_03v3 W=19.06u L=8u
MX27 aux_gate vcasp avdd avdd pfet_05v0 W=0.5u L=10u
MX28 xf2 v2 vsp avdd pfet_05v0 W=54.89u L=4u
MX29 vsu vsu bgsu1 avss nfet_05v0 W=1u L=2u
MX30 vbp_cas vbp_cas vbp_bias avdd pfet_05v0 W=18.93u L=8u
RX31 rbit6top rbit5top avss ppolyf_u_1k W=6.6u L=64u
MX32 vx1 psrg_m3_feed avdd avdd pfet_05v0 W=16.75u L=2u
MX33 psrg_m3_feed vcasp vx2 avdd pfet_05v0 W=16.42u L=4u
MX34 vbp_bias vbp_bias avdd avdd pfet_03v3 W=19.06u L=8u
MX35 xf1 vbn_sink avss avss nfet_05v0 W=16.34u L=8u
MX36 xf1 vbn_sink avss avss nfet_05v0 W=16.34u L=8u
MX37 vbp_cas vbp_cas vbp_bias avdd pfet_05v0 W=18.93u L=8u
MX38 su_state vsu avdd avdd pfet_05v0 W=1u L=8u
MX39 vx2 psrg_m3_feed avdd avdd pfet_05v0 W=16.75u L=2u
MX40 psrg_vnc vbp_i avdd avdd pfet_05v0 W=17.74u L=4u
MX41 pm1 y1 avdd avdd pfet_05v0 W=20.76u L=4u
MX42 vsu psrg_m3_feed avdd avdd pfet_05v0 W=2u L=2u
MX43 vbp_cas vbp_cas vbp_bias avdd pfet_05v0 W=18.93u L=8u
MX44 vbn_sink vbp_i avdd avdd pfet_05v0 W=18.95u L=8u
MX45 b2_b b2 dvdd dvdd pfet_03v3 W=3u L=0.5u
MX46 vbn_sink vbp_i avdd avdd pfet_05v0 W=18.95u L=8u
MX47 b5_b b5 dvdd dvdd pfet_03v3 W=3u L=0.5u
MX48 psrg_m3_feed vcasp vx2 avdd pfet_05v0 W=16.42u L=4u
MX49 vgn2 vbp_cas pm2 avdd pfet_05v0 W=22.21u L=8u
MX50 xf2 vbn_sink avss avss nfet_05v0 W=16.34u L=8u
MX51 vbp_cas vbp_cas vbp_bias avdd pfet_05v0 W=18.93u L=8u
MX52 vx1 psrg_m3_feed avdd avdd pfet_05v0 W=16.75u L=2u
CX53 vref avss cap_mim_2f0fF W=70.7u L=70.7u
MX54 vref vcasp vx3 avdd pfet_05v0 W=16.42u L=4u
MX55 rbit1top b0_b rbit0top dvdd pfet_03v3 W=40u L=0.28u
MX56 vbp_i vbp_i avdd avdd pfet_05v0 W=18.75u L=8u
MX57 y1 psrg_vnc psrg_mf1_protected avss nfet_05v0 W=18.49u L=6u
RX58 rbit0top rfix2 avss ppolyf_u_1k W=6.6u L=0.128m
MX59 vbn_fold vbp_i avdd avdd pfet_05v0 W=18.99u L=8u
MX60 rbit4top b3_b rbit3top dvdd pfet_03v3 W=30u L=0.28u
MX61 rbit5top b4_b rbit4top dvdd pfet_03v3 W=15u L=0.28u
MX62 xf2 vbn_sink avss avss nfet_05v0 W=16.34u L=8u
MX63 vbp_i vbp_i avdd avdd pfet_05v0 W=18.75u L=8u
MX64 rbit2top b1_b rbit1top dvdd pfet_03v3 W=40u L=0.28u
MX65 xf2 v2 vsp avdd pfet_05v0 W=54.89u L=4u
MX66 rbit4top b4 rbit5top dvss nfet_03v3 W=5u L=0.28u
MX67 vbp_bias vbp_bias avdd avdd pfet_03v3 W=19.06u L=8u
MX68 vbn vbn avss avss nfet_05v0 W=7.55u L=4u
MX69 vbn_fold vbp_i avdd avdd pfet_05v0 W=18.99u L=8u
MX70 vsp vbp_tail avdd avdd pfet_03v3 W=28.91u L=6u
MX71 vx1 psrg_m3_feed avdd avdd pfet_05v0 W=16.75u L=2u
CX72 vref avss cap_mim_2f0fF W=70.7u L=70.7u
MX73 vbp_cas vbp_cas vbp_bias avdd pfet_05v0 W=18.93u L=8u
MX74 xf1 v1 vsp avdd pfet_05v0 W=54.89u L=4u
MX75 vaux psrg_m3_feed avdd avdd pfet_05v0 W=10u L=2u
MX76 vbp_tail vbn_i avss avss nfet_05v0 W=13.95u L=8u
MX77 xf1 vbn_sink avss avss nfet_05v0 W=16.34u L=8u
MX78 y1 vbp_cas pm1 avdd pfet_05v0 W=22.21u L=8u
MX79 pm1 y1 avdd avdd pfet_05v0 W=20.76u L=4u
MX80 vbn_i vbp_i avdd avdd pfet_05v0 W=18.75u L=8u
MX81 vbp_cas vbp_cas vbp_bias avdd pfet_05v0 W=18.93u L=8u
MX82 psrg_vnc psrg_vnc rb_mid avss nfet_05v0 W=0.71u L=20u
MX83 psrg_vnc vbp_i avdd avdd pfet_05v0 W=17.74u L=4u
RX84 rfix0 vref avss ppolyf_u_1k W=6.6u L=0.128m
MX85 vsp vbp_tail avdd avdd pfet_03v3 W=28.91u L=6u
MX86 vbp_cas vbp_cas vbp_bias avdd pfet_05v0 W=18.93u L=8u
MX87 pm2 y1 avdd avdd pfet_05v0 W=20.76u L=4u
MX88 vbp_cas vbp_cas vbp_bias avdd pfet_05v0 W=18.93u L=8u
CX89 vref avss cap_mim_2f0fF W=70.7u L=70.7u
MX90 vbn_fold vbp_i avdd avdd pfet_05v0 W=18.99u L=8u
RX91 rbit3top rbit2top avss ppolyf_u_1k W=6.6u L=8u
MX92 psrg_m3_feed psrg_vnc psrg_m3_protected avss nfet_05v0 W=14.6u L=4u
MX93 vbn_fold vbn_fold vnx_bias avss nfet_05v0 W=4.62u L=6u
MX94 vx3 psrg_m3_feed avdd avdd pfet_05v0 W=16.75u L=2u
MX95 vbn_sink vbp_i avdd avdd pfet_05v0 W=18.95u L=8u
MX96 vbn_sink vbp_i avdd avdd pfet_05v0 W=18.95u L=8u
MX97 pm1 y1 avdd avdd pfet_05v0 W=20.76u L=4u
MX98 iref_gate vbp_i vsu1 avss nfet_05v0 W=0.5u L=50u
MX99 vbp_tail vbp_tail avdd avdd pfet_03v3 W=13.75u L=6u
MX100 vbp_i vbp_i avdd avdd pfet_05v0 W=18.75u L=8u
MX101 vbn_fold vbp_i avdd avdd pfet_05v0 W=18.99u L=8u
RX102 rfix1 rfix0 avss ppolyf_u_1k W=6.6u L=0.128m
MX103 vbn_fold vbp_i avdd avdd pfet_05v0 W=18.99u L=8u
MX104 xf2 vbn_sink avss avss nfet_05v0 W=16.34u L=8u
MX105 y1 vbp_cas pm1 avdd pfet_05v0 W=22.21u L=8u
MX106 vbp_bias vbp_bias avdd avdd pfet_03v3 W=19.06u L=8u
CX107 vref avss cap_mim_2f0fF W=70.7u L=70.7u
MX108 rbit3top b3 rbit4top dvss nfet_03v3 W=10u L=0.28u
MX109 vx2 psrg_m3_feed avdd avdd pfet_05v0 W=16.75u L=2u
MX110 vx3 psrg_m3_feed avdd avdd pfet_05v0 W=16.75u L=2u
MX111 y1 vbp_cas pm1 avdd pfet_05v0 W=22.21u L=8u
MX112 bgsu1 bgsu1 bgsu2 avss nfet_03v3 W=1u L=2u
MX113 vbp_cas vbp_cas vbp_bias avdd pfet_05v0 W=18.93u L=8u
MX114 rbit1top b0_b rbit0top dvdd pfet_03v3 W=40u L=0.28u
MX115 rbit1top b0_b rbit0top dvdd pfet_03v3 W=40u L=0.28u
CX116 vref avss cap_mim_2f0fF W=70.7u L=70.7u
MX117 xf2 v2 vsp avdd pfet_05v0 W=54.89u L=4u
MX118 b3_b b3 dvss dvss nfet_03v3 W=1u L=0.5u
MX119 y1 vbp_cas pm1 avdd pfet_05v0 W=22.21u L=8u
MX120 xf1 vbn_sink avss avss nfet_05v0 W=16.34u L=8u
MX121 xf1 vbn_sink avss avss nfet_05v0 W=16.34u L=8u
MX122 vbn_sink vbp_i avdd avdd pfet_05v0 W=18.95u L=8u
MX123 vx2 psrg_m3_feed avdd avdd pfet_05v0 W=16.75u L=2u
MX124 vgn1 vgn1 v1 avss nfet_05v0 W=14.6u L=4u
MX125 vbp_i vbp_i avdd avdd pfet_05v0 W=18.75u L=8u
MX126 iref_gate vbp_i avdd avdd pfet_05v0 W=80u L=1u
MX127 vsp vbp_tail avdd avdd pfet_03v3 W=28.91u L=6u
MX128 su_state vgn2 avss avss nfet_05v0 W=4u L=1u
MX129 b5_b b5 dvss dvss nfet_03v3 W=1u L=0.5u
MX130 b6_b b6 dvdd dvdd pfet_03v3 W=3u L=0.5u
MX131 psrg_m3_feed vcasp vx2 avdd pfet_05v0 W=16.42u L=4u
MX132 vbn_sink vbp_i avdd avdd pfet_05v0 W=18.95u L=8u
MX133 psrg_m3_feed psrg_vnc psrg_m3_protected avss nfet_05v0 W=14.6u L=4u
MX134 pm1 y1 avdd avdd pfet_05v0 W=20.76u L=4u
MX135 vbn_sink vbp_i avdd avdd pfet_05v0 W=18.95u L=8u
MX136 vbp_tail vbp_tail avdd avdd pfet_03v3 W=13.75u L=6u
MX137 vbn_fold vbp_i avdd avdd pfet_05v0 W=18.99u L=8u
MX138 vbn_sink vbp_i avdd avdd pfet_05v0 W=18.95u L=8u
MX139 xf2 vbn_sink avss avss nfet_05v0 W=16.34u L=8u
MX140 vbn_sink vbp_i avdd avdd pfet_05v0 W=18.95u L=8u
MX141 b1_b b1 dvdd dvdd pfet_03v3 W=3u L=0.5u
MX142 vq3 b6_b rbit6top dvdd pfet_03v3 W=3.75u L=0.28u
RX143 vq3 rbit6top avss ppolyf_u_1k W=6.6u L=0.128m
MX144 psrg_vnc vbp_i avdd avdd pfet_05v0 W=17.74u L=4u
MX145 y1 vbp_cas pm1 avdd pfet_05v0 W=22.21u L=8u
MX146 rbit3top b2_b rbit2top dvdd pfet_03v3 W=20u L=0.28u
MX147 vgn2 vbn_fold xf2 avss nfet_05v0 W=18.49u L=6u
MX148 vgn2 vbp_cas pm2 avdd pfet_05v0 W=22.21u L=8u
MX149 vbn_i vbp_i avdd avdd pfet_05v0 W=18.75u L=8u
MX150 vbp_tail vbp_tail avdd avdd pfet_03v3 W=13.75u L=6u
MX151 vbp_i vbp_i avdd avdd pfet_05v0 W=18.75u L=8u
MX152 vbn vcasp vaux avdd pfet_05v0 W=16u L=4u
MX153 vsua vcasp avdd avdd pfet_05v0 W=2u L=2u
MX154 rbit2top b2 rbit3top dvss nfet_03v3 W=20u L=0.28u
MX155 pm2 y1 avdd avdd pfet_05v0 W=20.76u L=4u
MX156 vx2 psrg_m3_feed avdd avdd pfet_05v0 W=16.75u L=2u
MX157 vsp vbp_tail avdd avdd pfet_03v3 W=28.91u L=6u
MX158 rbit5top b5 rbit6top dvss nfet_03v3 W=2.5u L=0.28u
RX159 rbit1top rbit0top avss ppolyf_u_1k W=6.6u L=2u
MX160 vx1 psrg_m3_feed avdd avdd pfet_05v0 W=16.75u L=2u
MX161 vx1 psrg_m3_feed avdd avdd pfet_05v0 W=16.75u L=2u
MX162 vaux psrg_m3_feed avdd avdd pfet_05v0 W=10u L=2u
MX163 vsp vbp_tail avdd avdd pfet_03v3 W=28.91u L=6u
MX164 b4_b b4 dvdd dvdd pfet_03v3 W=3u L=0.5u
MX165 vbn_sink vbp_i avdd avdd pfet_05v0 W=18.95u L=8u
MX166 vbn_sink vbp_i avdd avdd pfet_05v0 W=18.95u L=8u
MX167 rbit2top b1_b rbit1top dvdd pfet_03v3 W=40u L=0.28u
MX168 pm1 y1 avdd avdd pfet_05v0 W=20.76u L=4u
MX169 pm2 y1 avdd avdd pfet_05v0 W=20.76u L=4u
MX170 vbn_sink vbp_i avdd avdd pfet_05v0 W=18.95u L=8u
MX171 vbp_bias vbp_bias avdd avdd pfet_03v3 W=19.06u L=8u
MX172 vbn_fold vbp_i avdd avdd pfet_05v0 W=18.99u L=8u
MX173 vbn_sink vbp_i avdd avdd pfet_05v0 W=18.95u L=8u
MX174 b1_b b1 dvss dvss nfet_03v3 W=1u L=0.5u
MX175 vgn2 vbp_cas pm2 avdd pfet_05v0 W=22.21u L=8u
MX176 xf1 vbn_sink avss avss nfet_05v0 W=16.34u L=8u
MX177 rbit1top b1 rbit2top dvss nfet_03v3 W=40u L=0.28u
RX178 vq2 v2 avss ppolyf_u_1k W=4u L=42.1u
MX179 psrg_m3_feed vcasp vx2 avdd pfet_05v0 W=16.42u L=4u
MX180 b4_b b4 dvss dvss nfet_03v3 W=1u L=0.5u
MX181 xf2 v2 vsp avdd pfet_05v0 W=54.89u L=4u
MX182 pm2 y1 avdd avdd pfet_05v0 W=20.76u L=4u
MX183 vref vcasp vx3 avdd pfet_05v0 W=16.42u L=4u
CX184 vref avss cap_mim_2f0fF W=70.7u L=70.7u
CX185 vref avss cap_mim_2f0fF W=70.7u L=70.7u
MX186 vgn1 vcasp vx1 avdd pfet_05v0 W=16.42u L=4u
MX187 vbn_i iref_gate avdd avdd pfet_05v0 W=0.5u L=8u
MX188 vnx_bias vnx_bias avss avss nfet_03v3 W=1.62u L=8u
MX189 xf2 vbn_sink avss avss nfet_05v0 W=16.34u L=8u
MX190 xf1 v1 vsp avdd pfet_05v0 W=54.89u L=4u
MX191 vbp_i vbn_i net4 avss nfet_05v0 W=9.13u L=8u
MX192 pm1 y1 avdd avdd pfet_05v0 W=20.76u L=4u
MX193 iref_gate vbp_i avdd avdd pfet_05v0 W=80u L=1u
MX194 xf2 v2 vsp avdd pfet_05v0 W=54.89u L=4u
MX195 rbit1top b0_b rbit0top dvdd pfet_03v3 W=40u L=0.28u
MX196 bgsu2 bgsu2 avss avss nfet_03v3 W=1u L=2u
MX197 vbn_i vbp_i avdd avdd pfet_05v0 W=18.75u L=8u
MX198 b0_b b0 dvss dvss nfet_03v3 W=1u L=0.5u
MX199 rbit6top b6 vq3 dvss nfet_03v3 W=1.25u L=0.28u
MX200 psrg_vnc vbp_i avdd avdd pfet_05v0 W=17.74u L=4u
MX201 vbn_fold vbp_i avdd avdd pfet_05v0 W=18.99u L=8u
MX202 auxsu1 auxsu1 auxsu2 avss nfet_03v3 W=1u L=2u
MX203 psrg_m3_protected vgn2 v2 avss nfet_05v0 W=14.6u L=4u
MX204 vbn_fold vbp_i avdd avdd pfet_05v0 W=18.99u L=8u
MX205 aux_gate vbn_i avss avss nfet_05v0 W=1u L=8u
MX206 vsu1 vbp_i vsu2 avss nfet_05v0 W=0.5u L=50u
MX207 vgn1 vcasp vx1 avdd pfet_05v0 W=16.42u L=4u
MX208 vbp_cas vbn_i avss avss nfet_05v0 W=0.65u L=8u
MX209 pm2 y1 avdd avdd pfet_05v0 W=20.76u L=4u
MX210 vx1 psrg_m3_feed avdd avdd pfet_05v0 W=16.75u L=2u
MX211 b6_b b6 dvss dvss nfet_03v3 W=1u L=0.5u
MX212 psrg_mf1_protected vbn_fold xf1 avss nfet_05v0 W=18.49u L=6u
MX213 vbn aux_gate avdd avdd pfet_05v0 W=0.5u L=8u
MX214 vsu2 vbp_i avss avss nfet_05v0 W=0.5u L=50u
MX215 vx3 psrg_m3_feed avdd avdd pfet_05v0 W=16.75u L=2u
MX216 vgn2 vbp_cas pm2 avdd pfet_05v0 W=22.21u L=8u
MX217 vbp_bias vbp_bias avdd avdd pfet_03v3 W=19.06u L=8u
MX218 vcasp vbn avss avss nfet_05v0 W=7.55u L=4u
RX219 avss net3 avdd pplus_u W=1u L=0.23253m
MX220 vgn1 aux_gate psrg_m3_feed avdd pfet_05v0 W=2u L=2u
MX221 vcasp vcasp avdd avdd pfet_05v0 W=0.9u L=2u
MX222 psrg_vnc vbp_i avdd avdd pfet_05v0 W=17.74u L=4u
MX223 vsp vbp_tail avdd avdd pfet_03v3 W=28.91u L=6u
MX224 b2_b b2 dvss dvss nfet_03v3 W=1u L=0.5u
MX225 vgn2 vbp_cas pm2 avdd pfet_05v0 W=22.21u L=8u
MX226 vbn_i vbn_i avss avss nfet_05v0 W=7.78u L=8u
MX227 vbp_bias vbp_bias avdd avdd pfet_03v3 W=19.06u L=8u
MX228 rbit3top b2_b rbit2top dvdd pfet_03v3 W=20u L=0.28u
RX229 rbit5top rbit4top avss ppolyf_u_1k W=6.6u L=32u
MX230 vbn_i vbp_i avdd avdd pfet_05v0 W=18.75u L=8u
MX231 auxsu2 auxsu2 avss avss nfet_03v3 W=1u L=2u
MX232 vbn_sink vbp_i avdd avdd pfet_05v0 W=18.95u L=8u
MX233 vbn_sink vbn_sink avss avss nfet_05v0 W=12.31u L=8u
MX234 vgn1 vgn1 v1 avss nfet_05v0 W=14.6u L=4u
MX235 b0_b b0 dvdd dvdd pfet_03v3 W=3u L=0.5u
RX236 rbit2top rbit1top avss ppolyf_u_1k W=6.6u L=4u
CX237 vref avss cap_mim_2f0fF W=70.7u L=70.7u
MX238 vbn_fold vbp_i avdd avdd pfet_05v0 W=18.99u L=8u
CX239 vref avss cap_mim_2f0fF W=70.7u L=70.7u
MX240 xf1 v1 vsp avdd pfet_05v0 W=54.89u L=4u
MX241 psrg_m3_feed vcasp vx2 avdd pfet_05v0 W=16.42u L=4u
MX242 rbit1top b0_b rbit0top dvdd pfet_03v3 W=40u L=0.28u
MX243 vgn1 vcasp vx1 avdd pfet_05v0 W=16.42u L=4u
MX244 vsua vsua auxsu1 avss nfet_05v0 W=1u L=2u
MX245 xf1 v1 vsp avdd pfet_05v0 W=54.89u L=4u
MX246 vx3 psrg_m3_feed avdd avdd pfet_05v0 W=16.75u L=2u
MX247 psrg_vnc vbp_i avdd avdd pfet_05v0 W=17.74u L=4u
MX248 rbit1top b0_b rbit0top dvdd pfet_03v3 W=40u L=0.28u
MX249 vref vcasp vx3 avdd pfet_05v0 W=16.42u L=4u
MX250 psrg_m3_protected vgn2 v2 avss nfet_05v0 W=14.6u L=4u
MX251 rbit2top b1_b rbit1top dvdd pfet_03v3 W=40u L=0.28u
MX252 psrg_vnc vbp_i avdd avdd pfet_05v0 W=17.74u L=4u
MX253 vbn_fold vbp_i avdd avdd pfet_05v0 W=18.99u L=8u
MX254 vx2 psrg_m3_feed avdd avdd pfet_05v0 W=16.75u L=2u
MX255 pm2 y1 avdd avdd pfet_05v0 W=20.76u L=4u
MX256 vbp_cas vbp_cas vbp_bias avdd pfet_05v0 W=18.93u L=8u
MX257 vbn_sink vbp_i avdd avdd pfet_05v0 W=18.95u L=8u
MX258 y1 vbp_cas pm1 avdd pfet_05v0 W=22.21u L=8u
MX259 rbit0top b0 rbit1top dvss nfet_03v3 W=40u L=0.28u
MX260 vgn1 vcasp vx1 avdd pfet_05v0 W=16.42u L=4u
.ends Bandgap_Core_Res
