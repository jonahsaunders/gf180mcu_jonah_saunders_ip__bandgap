* Independent topology audit of the extraction output.
.subckt Bandgap_Core_Res avdd avss vref b0 b1 b2 b3 b4 b5 b6 dvss dvdd
QXpnp_05p00x05p00_0 avss avss vq3 pnp_05p00x05p00
QXpnp_05p00x05p00_1 avss avss vq2 pnp_05p00x05p00
QXpnp_05p00x05p00_2 avss avss vq2 pnp_05p00x05p00
QXpnp_05p00x05p00_4 avss avss vq2 pnp_05p00x05p00
QXpnp_05p00x05p00_3 avss avss vq2 pnp_05p00x05p00
QXpnp_05p00x05p00_5 avss avss v1 pnp_05p00x05p00
QXpnp_05p00x05p00_6 avss avss vq2 pnp_05p00x05p00
QXpnp_05p00x05p00_7 avss avss vq2 pnp_05p00x05p00
QXpnp_05p00x05p00_8 avss avss vq2 pnp_05p00x05p00
QXpnp_05p00x05p00_9 avss avss vq2 pnp_05p00x05p00
RXnwell_0 net3 net4 avss nwell W=2u L=20.19u
MX0 rbit0top b0 rbit1top dvss nfet_03v3 W=40u L=0.28u
MX1 avdd avdd avdd avdd pfet_05v0 W=54.89u L=4u
MX2 avss avss avss avss nfet_05v0 W=7.55u L=4u
MX3 avss avss avss avss nfet_05v0 W=16.34u L=8u
MX4 avdd avdd avdd avdd pfet_05v0 W=16.42u L=4u
MX5 vbn_sink vbp_i avdd avdd pfet_05v0 W=18.95u L=8u
MX6 vbn_sink vbp_i avdd avdd pfet_05v0 W=18.95u L=8u
MX7 avdd avdd avdd avdd pfet_05v0 W=16.75u L=2u
MX8 avdd avdd avdd avdd pfet_05v0 W=16.75u L=2u
MX9 vbn_sink vbp_i avdd avdd pfet_05v0 W=18.95u L=8u
MX10 avdd avdd avdd avdd pfet_05v0 W=18.99u L=8u
MX11 vbn_fold vbp_i avdd avdd pfet_05v0 W=18.99u L=8u
MX12 b3_b b3 dvdd dvdd pfet_03v3 W=3u L=0.5u
MX13 vx1 psrg_m3_feed avdd avdd pfet_05v0 W=16.75u L=2u
MX14 rbit3top b2_b rbit2top dvdd pfet_03v3 W=20u L=0.28u
MX15 pm1 y1 avdd avdd pfet_05v0 W=20.76u L=4u
MX16 vbn vbn avss avss nfet_05v0 W=7.55u L=4u
MX17 avdd avdd avdd avdd pfet_05v0 W=18.75u L=8u
MX18 avdd avdd avdd avdd pfet_05v0 W=18.95u L=8u
MX19 vgn2 vbn_fold xf2 avss nfet_05v0 W=18.49u L=6u
MX20 vbp_cas vbn_i avss avss nfet_05v0 W=0.65u L=8u
MX21 vbn_i vbp_i avdd avdd pfet_05v0 W=18.75u L=8u
MX22 avdd avdd avdd avdd pfet_05v0 W=16.42u L=4u
MX23 avss avss avss avss nfet_05v0 W=16.34u L=8u
MX24 vgn2 vbp_cas pm2 avdd pfet_05v0 W=22.21u L=8u
MX25 avdd avdd avdd avdd pfet_05v0 W=16.42u L=4u
MX26 avdd avdd avdd avdd pfet_05v0 W=20.76u L=4u
MX27 avdd avdd avdd avdd pfet_05v0 W=16.75u L=2u
MX28 avdd avdd avdd avdd pfet_05v0 W=18.75u L=8u
MX29 avdd avdd avdd avdd pfet_05v0 W=18.95u L=8u
MX30 avdd avdd avdd avdd pfet_05v0 W=54.89u L=4u
MX31 vbn_fold vbn_fold vnx_bias avss nfet_05v0 W=4.62u L=6u
MX32 xf1 vbn_sink avss avss nfet_05v0 W=16.34u L=8u
MX33 vgn1 aux_gate psrg_m3_feed avdd pfet_05v0 W=2u L=2u
MX34 rbit6top b5_b rbit5top dvdd pfet_03v3 W=7.5u L=0.28u
MX35 avdd avdd avdd avdd pfet_05v0 W=22.21u L=8u
MX36 avdd avdd avdd avdd pfet_05v0 W=18.75u L=8u
RX37 rbit4top rbit3top avss ppolyf_u_1k W=6.6u L=16u
MX38 avss avss avss avss nfet_05v0 W=14.6u L=4u
MX39 vx3 psrg_m3_feed avdd avdd pfet_05v0 W=16.75u L=2u
MX40 avdd avdd avdd avdd pfet_05v0 W=22.21u L=8u
MX41 avss avss avss avss nfet_05v0 W=16.34u L=8u
MX42 avdd avdd avdd avdd pfet_05v0 W=16.75u L=2u
MX43 avdd avdd avdd avdd pfet_05v0 W=18.75u L=8u
MX44 avdd avdd avdd avdd pfet_05v0 W=16.75u L=2u
MX45 vaux psrg_m3_feed avdd avdd pfet_05v0 W=10u L=2u
MX46 vbn aux_gate avdd avdd pfet_05v0 W=0.5u L=8u
MX47 avdd avdd avdd avdd pfet_05v0 W=54.89u L=4u
MX48 avdd avdd avdd avdd pfet_05v0 W=54.89u L=4u
RX49 rfix2 rfix1 avss ppolyf_u_1k W=6.6u L=0.128m
MX50 avss avss avss avss nfet_05v0 W=16.34u L=8u
MX51 avdd avdd avdd avdd pfet_05v0 W=18.75u L=8u
MX52 avdd avdd avdd avdd pfet_05v0 W=20.76u L=4u
MX53 vref vcasp vx3 avdd pfet_05v0 W=16.42u L=4u
MX54 avdd avdd avdd avdd pfet_05v0 W=16.42u L=4u
RX55 rbit6top rbit5top avss ppolyf_u_1k W=6.6u L=64u
MX56 psrg_vnc psrg_vnc rb_mid avss nfet_05v0 W=0.71u L=20u
MX57 avss avss avss avss nfet_05v0 W=16.34u L=8u
MX58 avdd avdd avdd avdd pfet_05v0 W=54.89u L=4u
MX59 vx2 psrg_m3_feed avdd avdd pfet_05v0 W=16.75u L=2u
MX60 avdd avdd avdd avdd pfet_05v0 W=18.75u L=8u
MX61 avdd avdd avdd avdd pfet_05v0 W=22.21u L=8u
MX62 pm1 y1 avdd avdd pfet_05v0 W=20.76u L=4u
MX63 avss avss avss avss nfet_05v0 W=14.6u L=4u
MX64 avdd avdd avdd avdd pfet_05v0 W=16.75u L=2u
MX65 avss avss avss avss nfet_05v0 W=7.55u L=4u
MX66 avdd avdd avdd avdd pfet_05v0 W=18.99u L=8u
MX67 avdd avdd avdd avdd pfet_05v0 W=18.95u L=8u
MX68 avdd avdd avdd avdd pfet_05v0 W=18.95u L=8u
MX69 avdd avdd avdd avdd pfet_05v0 W=16.42u L=4u
MX70 psrg_m3_feed vcasp vx2 avdd pfet_05v0 W=16.42u L=4u
MX71 pm1 y1 avdd avdd pfet_05v0 W=20.76u L=4u
MX72 vx2 psrg_m3_feed avdd avdd pfet_05v0 W=16.75u L=2u
MX73 avdd avdd avdd avdd pfet_05v0 W=16.42u L=4u
MX74 avdd avdd avdd avdd pfet_05v0 W=18.99u L=8u
MX75 avdd avdd avdd avdd pfet_05v0 W=18.95u L=8u
MX76 avdd avdd avdd avdd pfet_05v0 W=18.95u L=8u
MX77 b2_b b2 dvdd dvdd pfet_03v3 W=3u L=0.5u
MX78 avdd avdd avdd avdd pfet_05v0 W=16.75u L=2u
MX79 avdd avdd avdd avdd pfet_05v0 W=54.89u L=4u
MX80 y1 vbp_cas pm1 avdd pfet_05v0 W=22.21u L=8u
MX81 avdd avdd avdd avdd pfet_05v0 W=22.21u L=8u
MX82 avss avss avss avss nfet_05v0 W=12.31u L=8u
MX83 b5_b b5 dvdd dvdd pfet_03v3 W=3u L=0.5u
MX84 avss avss avss avss nfet_05v0 W=18.49u L=6u
MX85 avdd avdd avdd avdd pfet_05v0 W=54.89u L=4u
MX86 vbp_i vbp_i avdd avdd pfet_05v0 W=18.75u L=8u
MX87 avss avss avss avss nfet_05v0 W=16.34u L=8u
MX88 avss avss avss avss nfet_05v0 W=12.31u L=8u
MX89 vbp_bias vbp_bias avdd avdd pfet_03v3 W=19.06u L=8u
MX90 avdd avdd avdd avdd pfet_05v0 W=18.75u L=8u
MX91 avdd avdd avdd avdd pfet_05v0 W=20.76u L=4u
MX92 vbp_bias vbp_bias avdd avdd pfet_03v3 W=19.06u L=8u
MX93 xf2 vbn_sink avss avss nfet_05v0 W=16.34u L=8u
CX94 vref avss cap_mim_2f0fF W=70.7u L=70.7u
MX95 vbn_sink vbp_i avdd avdd pfet_05v0 W=18.95u L=8u
MX96 vbn_fold vbp_i avdd avdd pfet_05v0 W=18.99u L=8u
MX97 rbit1top b0_b rbit0top dvdd pfet_03v3 W=40u L=0.28u
MX98 avdd avdd avdd avdd pfet_05v0 W=20.76u L=4u
MX99 vbn_i iref_gate avdd avdd pfet_05v0 W=0.5u L=8u
MX100 avss avss avss avss nfet_05v0 W=18.49u L=6u
CX101 vref avss cap_mim_2f0fF W=70.7u L=70.7u
MX102 avdd avdd avdd avdd pfet_05v0 W=18.95u L=8u
MX103 avdd avdd avdd avdd pfet_05v0 W=18.95u L=8u
MX104 avdd avdd avdd avdd pfet_05v0 W=18.75u L=8u
MX105 iref_gate vbp_i vsu1 avss nfet_05v0 W=0.5u L=50u
MX106 vgn2 vbp_cas pm2 avdd pfet_05v0 W=22.21u L=8u
MX107 vbn_fold vbp_i avdd avdd pfet_05v0 W=18.99u L=8u
RX108 rbit0top rfix2 avss ppolyf_u_1k W=6.6u L=0.128m
MX109 avss avss avss avss nfet_05v0 W=18.49u L=6u
MX110 vsp vbp_tail avdd avdd pfet_03v3 W=28.91u L=6u
MX111 avdd avdd avdd avdd pfet_05v0 W=16.42u L=4u
MX112 rbit4top b3_b rbit3top dvdd pfet_03v3 W=30u L=0.28u
MX113 avdd avdd avdd avdd pfet_05v0 W=16.42u L=4u
MX114 su_state vsu avdd avdd pfet_05v0 W=1u L=8u
MX115 xf1 vbn_sink avss avss nfet_05v0 W=16.34u L=8u
MX116 avdd avdd avdd avdd pfet_05v0 W=18.99u L=8u
MX117 rbit5top b4_b rbit4top dvdd pfet_03v3 W=15u L=0.28u
MX118 avss avss avss avss nfet_05v0 W=14.6u L=4u
MX119 avdd avdd avdd avdd pfet_05v0 W=18.95u L=8u
MX120 vbn_i vbp_i avdd avdd pfet_05v0 W=18.75u L=8u
MX121 xf2 vbn_sink avss avss nfet_05v0 W=16.34u L=8u
MX122 avss avss avss avss nfet_05v0 W=16.34u L=8u
MX123 avdd avdd avdd avdd pfet_05v0 W=20.76u L=4u
MX124 avss avss avss avss nfet_05v0 W=16.34u L=8u
MX125 avdd avdd avdd avdd pfet_05v0 W=16.42u L=4u
MX126 xf1 v1 vsp avdd pfet_05v0 W=54.89u L=4u
MX127 avss avss avss avss nfet_05v0 W=12.31u L=8u
MX128 rbit2top b1_b rbit1top dvdd pfet_03v3 W=40u L=0.28u
MX129 psrg_m3_feed psrg_vnc psrg_m3_protected avss nfet_05v0 W=14.6u L=4u
MX130 avdd avdd avdd avdd pfet_05v0 W=18.95u L=8u
MX131 rbit4top b4 rbit5top dvss nfet_03v3 W=5u L=0.28u
MX132 avdd avdd avdd avdd pfet_05v0 W=18.99u L=8u
MX133 vbn_sink vbn_sink avss avss nfet_05v0 W=12.31u L=8u
MX134 avdd avdd avdd avdd pfet_05v0 W=54.89u L=4u
MX135 avdd avdd avdd avdd pfet_05v0 W=16.42u L=4u
MX136 vbp_tail vbp_tail avdd avdd pfet_03v3 W=13.75u L=6u
MX137 avdd avdd avdd avdd pfet_05v0 W=16.42u L=4u
MX138 avdd avdd avdd avdd pfet_05v0 W=54.89u L=4u
MX139 avss avss avss avss nfet_05v0 W=14.6u L=4u
MX140 vbp_cas vbp_cas vbp_bias avdd pfet_05v0 W=18.93u L=8u
MX141 pm2 y1 avdd avdd pfet_05v0 W=20.76u L=4u
MX142 avdd avdd avdd avdd pfet_05v0 W=16.75u L=2u
MX143 xf2 v2 vsp avdd pfet_05v0 W=54.89u L=4u
MX144 vaux psrg_m3_feed avdd avdd pfet_05v0 W=10u L=2u
MX145 avdd avdd avdd avdd pfet_05v0 W=22.21u L=8u
MX146 su_state vbp_tail avdd avdd pfet_05v0 W=1u L=8u
MX147 avdd avdd avdd avdd pfet_05v0 W=54.89u L=4u
MX148 avss avss avss avss nfet_05v0 W=14.6u L=4u
MX149 avdd avdd avdd avdd pfet_05v0 W=16.42u L=4u
MX150 avdd avdd avdd avdd pfet_05v0 W=20.76u L=4u
MX151 avdd avdd avdd avdd pfet_05v0 W=18.95u L=8u
MX152 pm2 y1 avdd avdd pfet_05v0 W=20.76u L=4u
MX153 avdd avdd avdd avdd pfet_05v0 W=16.42u L=4u
MX154 avdd avdd avdd avdd pfet_05v0 W=16.42u L=4u
MX155 psrg_vnc vbp_i avdd avdd pfet_05v0 W=17.74u L=4u
MX156 avdd avdd avdd avdd pfet_05v0 W=18.75u L=8u
MX157 avdd avdd avdd avdd pfet_05v0 W=18.95u L=8u
MX158 xf1 vbn_sink avss avss nfet_05v0 W=16.34u L=8u
MX159 vbn_sink vbp_i avdd avdd pfet_05v0 W=18.95u L=8u
MX160 vcasp vcasp avdd avdd pfet_05v0 W=0.9u L=2u
MX161 avss avss avss avss nfet_05v0 W=12.31u L=8u
MX162 avdd avdd avdd avdd pfet_05v0 W=18.99u L=8u
MX163 vx2 psrg_m3_feed avdd avdd pfet_05v0 W=16.75u L=2u
MX164 vbp_bias vbp_bias avdd avdd pfet_03v3 W=19.06u L=8u
MX165 avdd avdd avdd avdd pfet_05v0 W=16.42u L=4u
RX166 rfix0 vref avss ppolyf_u_1k W=6.6u L=0.128m
MX167 avss avss avss avss nfet_05v0 W=12.31u L=8u
MX168 avdd avdd avdd avdd pfet_05v0 W=16.42u L=4u
MX169 avdd avdd avdd avdd pfet_05v0 W=16.42u L=4u
MX170 vbn_fold vbp_i avdd avdd pfet_05v0 W=18.99u L=8u
MX171 pm2 y1 avdd avdd pfet_05v0 W=20.76u L=4u
MX172 vref vcasp vx3 avdd pfet_05v0 W=16.42u L=4u
MX173 avdd avdd avdd avdd pfet_05v0 W=18.75u L=8u
MX174 y1 vbp_cas pm1 avdd pfet_05v0 W=22.21u L=8u
MX175 avdd avdd avdd avdd pfet_05v0 W=18.95u L=8u
MX176 vsu2 vbp_i avss avss nfet_05v0 W=0.5u L=50u
MX177 vbn_sink vbp_i avdd avdd pfet_05v0 W=18.95u L=8u
MX178 avdd avdd avdd avdd pfet_05v0 W=22.21u L=8u
MX179 avdd avdd avdd avdd pfet_05v0 W=20.76u L=4u
MX180 vx1 psrg_m3_feed avdd avdd pfet_05v0 W=16.75u L=2u
MX181 avdd avdd avdd avdd pfet_05v0 W=54.89u L=4u
MX182 avdd avdd avdd avdd pfet_05v0 W=18.95u L=8u
MX183 vsp vbp_tail avdd avdd pfet_03v3 W=28.91u L=6u
RX184 rbit3top rbit2top avss ppolyf_u_1k W=6.6u L=8u
MX185 avdd avdd avdd avdd pfet_05v0 W=20.76u L=4u
MX186 vbn_sink vbp_i avdd avdd pfet_05v0 W=18.95u L=8u
MX187 avss avss avss avss nfet_05v0 W=18.49u L=6u
MX188 xf1 v1 vsp avdd pfet_05v0 W=54.89u L=4u
MX189 avdd avdd avdd avdd pfet_05v0 W=22.21u L=8u
CX190 vref avss cap_mim_2f0fF W=70.7u L=70.7u
MX191 avdd avdd avdd avdd pfet_05v0 W=18.75u L=8u
MX192 avss avss avss avss nfet_05v0 W=16.34u L=8u
CX193 vref avss cap_mim_2f0fF W=70.7u L=70.7u
MX194 avdd avdd avdd avdd pfet_05v0 W=54.89u L=4u
MX195 vbn_fold vbp_i avdd avdd pfet_05v0 W=18.99u L=8u
MX196 avss avss avss avss nfet_05v0 W=18.49u L=6u
MX197 vbp_cas vbp_cas vbp_bias avdd pfet_05v0 W=18.93u L=8u
MX198 vbp_i vbp_i avdd avdd pfet_05v0 W=18.75u L=8u
MX199 vbn_sink vbn_sink avss avss nfet_05v0 W=12.31u L=8u
MX200 vbn_fold vbp_i avdd avdd pfet_05v0 W=18.99u L=8u
MX201 psrg_m3_feed vcasp vx2 avdd pfet_05v0 W=16.42u L=4u
MX202 psrg_m3_feed vcasp vx2 avdd pfet_05v0 W=16.42u L=4u
MX203 psrg_vnc vbp_i avdd avdd pfet_05v0 W=17.74u L=4u
MX204 avss avss avss avss nfet_05v0 W=12.31u L=8u
MX205 vsp vbp_tail avdd avdd pfet_03v3 W=28.91u L=6u
MX206 avdd avdd avdd avdd pfet_05v0 W=18.99u L=8u
MX207 avdd avdd avdd avdd pfet_05v0 W=16.75u L=2u
MX208 vbp_tail vbp_tail avdd avdd pfet_03v3 W=13.75u L=6u
MX209 vbp_bias vbp_bias avdd avdd pfet_03v3 W=19.06u L=8u
MX210 avdd avdd avdd avdd pfet_05v0 W=54.89u L=4u
MX211 vbp_cas vbp_cas vbp_bias avdd pfet_05v0 W=18.93u L=8u
MX212 psrg_m3_feed vcasp vx2 avdd pfet_05v0 W=16.42u L=4u
MX213 avdd avdd avdd avdd pfet_05v0 W=16.75u L=2u
RX214 rfix1 rfix0 avss ppolyf_u_1k W=6.6u L=0.128m
MX215 avss avss avss avss nfet_05v0 W=14.6u L=4u
MX216 vbp_cas vbp_cas vbp_bias avdd pfet_05v0 W=18.93u L=8u
MX217 vbp_cas vbp_cas vbp_bias avdd pfet_05v0 W=18.93u L=8u
MX218 avdd avdd avdd avdd pfet_05v0 W=18.75u L=8u
MX219 avdd avdd avdd avdd pfet_05v0 W=18.95u L=8u
MX220 xf2 vbn_sink avss avss nfet_05v0 W=16.34u L=8u
MX221 avdd avdd avdd avdd pfet_05v0 W=54.89u L=4u
MX222 avdd avdd avdd avdd pfet_05v0 W=16.42u L=4u
MX223 avdd avdd avdd avdd pfet_05v0 W=20.76u L=4u
RX224 avss net3 avdd pplus_u W=1u L=0.23253m
MX225 vbn_i vbn_i avss avss nfet_05v0 W=7.78u L=8u
MX226 psrg_m3_feed vcasp vx2 avdd pfet_05v0 W=16.42u L=4u
MX227 y1 psrg_vnc psrg_mf1_protected avss nfet_05v0 W=18.49u L=6u
MX228 avdd avdd avdd avdd pfet_05v0 W=16.42u L=4u
MX229 avdd avdd avdd avdd pfet_05v0 W=20.76u L=4u
MX230 pm2 y1 avdd avdd pfet_05v0 W=20.76u L=4u
MX231 avdd avdd avdd avdd pfet_05v0 W=20.76u L=4u
RX232 vq2 v2 avss ppolyf_u_1k W=4u L=42.1u
MX233 avdd avdd avdd avdd pfet_05v0 W=18.95u L=8u
MX234 xf2 v2 vsp avdd pfet_05v0 W=54.89u L=4u
MX235 vbp_i vbn_i net4 avss nfet_05v0 W=9.13u L=8u
MX236 avss avss avss avss nfet_05v0 W=16.34u L=8u
MX237 psrg_vnc vbp_i avdd avdd pfet_05v0 W=17.74u L=4u
MX238 avdd avdd avdd avdd pfet_05v0 W=18.99u L=8u
MX239 avdd avdd avdd avdd pfet_05v0 W=18.75u L=8u
MX240 rbit3top b3 rbit4top dvss nfet_03v3 W=10u L=0.28u
MX241 avdd avdd avdd avdd pfet_05v0 W=54.89u L=4u
MX242 avdd avdd avdd avdd pfet_05v0 W=54.89u L=4u
MX243 avdd avdd avdd avdd pfet_05v0 W=18.75u L=8u
MX244 avss avss avss avss nfet_05v0 W=14.6u L=4u
MX245 avdd avdd avdd avdd pfet_05v0 W=18.99u L=8u
MX246 avdd avdd avdd avdd pfet_05v0 W=16.75u L=2u
MX247 avdd avdd avdd avdd pfet_05v0 W=16.42u L=4u
MX248 vbp_tail vbn_i avss avss nfet_05v0 W=13.95u L=8u
MX249 vbp_bias vbp_bias avdd avdd pfet_03v3 W=19.06u L=8u
MX250 avdd avdd avdd avdd pfet_05v0 W=54.89u L=4u
MX251 avdd avdd avdd avdd pfet_05v0 W=20.76u L=4u
MX252 vsua vsua auxsu1 avss nfet_05v0 W=1u L=2u
MX253 avdd avdd avdd avdd pfet_05v0 W=20.76u L=4u
CX254 vgn2 avss cap_mim_2f0fF W=59u L=59u
MX255 vbn_sink vbp_i avdd avdd pfet_05v0 W=18.95u L=8u
MX256 avdd avdd avdd avdd pfet_05v0 W=18.99u L=8u
MX257 rbit1top b0_b rbit0top dvdd pfet_03v3 W=40u L=0.28u
MX258 rbit1top b0_b rbit0top dvdd pfet_03v3 W=40u L=0.28u
MX259 b3_b b3 dvss dvss nfet_03v3 W=1u L=0.5u
MX260 avdd avdd avdd avdd pfet_05v0 W=18.75u L=8u
MX261 vbn_sink vbp_i avdd avdd pfet_05v0 W=18.95u L=8u
MX262 vbn_fold vbp_i avdd avdd pfet_05v0 W=18.99u L=8u
MX263 vbn_fold vbp_i avdd avdd pfet_05v0 W=18.99u L=8u
MX264 vx1 psrg_m3_feed avdd avdd pfet_05v0 W=16.75u L=2u
MX265 b5_b b5 dvss dvss nfet_03v3 W=1u L=0.5u
MX266 avss avss avss avss nfet_05v0 W=7.55u L=4u
MX267 vbn_fold vbp_i avdd avdd pfet_05v0 W=18.99u L=8u
MX268 avss avss avss avss nfet_05v0 W=18.49u L=6u
MX269 avdd avdd avdd avdd pfet_05v0 W=18.75u L=8u
MX270 avss avss avss avss nfet_05v0 W=18.49u L=6u
MX271 vbn_sink vbp_i avdd avdd pfet_05v0 W=18.95u L=8u
MX272 avdd avdd avdd avdd pfet_05v0 W=22.21u L=8u
MX273 vbp_i vbp_i avdd avdd pfet_05v0 W=18.75u L=8u
MX274 vbn_sink vbp_i avdd avdd pfet_05v0 W=18.95u L=8u
MX275 avss avss avss avss nfet_05v0 W=16.34u L=8u
MX276 avdd avdd avdd avdd pfet_05v0 W=20.76u L=4u
MX277 xf2 v2 vsp avdd pfet_05v0 W=54.89u L=4u
MX278 avdd avdd avdd avdd pfet_05v0 W=16.75u L=2u
MX279 b6_b b6 dvdd dvdd pfet_03v3 W=3u L=0.5u
MX280 psrg_mf1_protected vbn_fold xf1 avss nfet_05v0 W=18.49u L=6u
MX281 pm1 y1 avdd avdd pfet_05v0 W=20.76u L=4u
MX282 bgsu1 bgsu1 bgsu2 avss nfet_03v3 W=1u L=2u
MX283 psrg_m3_feed psrg_vnc psrg_m3_protected avss nfet_05v0 W=14.6u L=4u
MX284 vx1 psrg_m3_feed avdd avdd pfet_05v0 W=16.75u L=2u
MX285 vgn1 vcasp vx1 avdd pfet_05v0 W=16.42u L=4u
MX286 avdd avdd avdd avdd pfet_05v0 W=22.21u L=8u
MX287 vbp_bias vbp_bias avdd avdd pfet_03v3 W=19.06u L=8u
MX288 avdd avdd avdd avdd pfet_05v0 W=16.42u L=4u
MX289 avdd avdd avdd avdd pfet_05v0 W=18.95u L=8u
MX290 avss avss avss avss nfet_05v0 W=7.55u L=4u
MX291 psrg_vnc vbp_i avdd avdd pfet_05v0 W=17.74u L=4u
MX292 avdd avdd avdd avdd pfet_05v0 W=18.99u L=8u
MX293 avss avss avss avss nfet_05v0 W=14.6u L=4u
MX294 vbn_fold vbp_i avdd avdd pfet_05v0 W=18.99u L=8u
MX295 avdd avdd avdd avdd pfet_05v0 W=16.42u L=4u
MX296 b1_b b1 dvdd dvdd pfet_03v3 W=3u L=0.5u
MX297 iref_gate vbp_i avdd avdd pfet_05v0 W=80u L=1u
MX298 vbp_cas vbp_cas vbp_bias avdd pfet_05v0 W=18.93u L=8u
RX299 vq3 rbit6top avss ppolyf_u_1k W=6.6u L=0.128m
MX300 avss avss avss avss nfet_05v0 W=7.55u L=4u
MX301 vgn1 vgn1 v1 avss nfet_05v0 W=14.6u L=4u
MX302 avdd avdd avdd avdd pfet_05v0 W=18.99u L=8u
MX303 avdd avdd avdd avdd pfet_05v0 W=54.89u L=4u
MX304 vq3 b6_b rbit6top dvdd pfet_03v3 W=3.75u L=0.28u
MX305 avdd avdd avdd avdd pfet_05v0 W=16.42u L=4u
MX306 vbp_cas vbp_cas vbp_bias avdd pfet_05v0 W=18.93u L=8u
MX307 avdd avdd avdd avdd pfet_05v0 W=16.42u L=4u
MX308 rbit3top b2_b rbit2top dvdd pfet_03v3 W=20u L=0.28u
MX309 avdd avdd avdd avdd pfet_05v0 W=16.42u L=4u
MX310 avss avss avss avss nfet_05v0 W=18.49u L=6u
MX311 vref vcasp vx3 avdd pfet_05v0 W=16.42u L=4u
MX312 vbp_cas vbp_cas vbp_bias avdd pfet_05v0 W=18.93u L=8u
MX313 psrg_vnc vbp_i avdd avdd pfet_05v0 W=17.74u L=4u
MX314 psrg_m3_protected vgn2 v2 avss nfet_05v0 W=14.6u L=4u
MX315 vx3 psrg_m3_feed avdd avdd pfet_05v0 W=16.75u L=2u
MX316 xf2 vbn_sink avss avss nfet_05v0 W=16.34u L=8u
MX317 vx3 psrg_m3_feed avdd avdd pfet_05v0 W=16.75u L=2u
MX318 avdd avdd avdd avdd pfet_05v0 W=54.89u L=4u
MX319 avdd avdd avdd avdd pfet_05v0 W=54.89u L=4u
MX320 psrg_m3_protected vgn2 v2 avss nfet_05v0 W=14.6u L=4u
MX321 vgn1 vcasp vx1 avdd pfet_05v0 W=16.42u L=4u
MX322 avdd avdd avdd avdd pfet_05v0 W=18.99u L=8u
MX323 avdd avdd avdd avdd pfet_05v0 W=16.75u L=2u
MX324 vgn1 vcasp vx1 avdd pfet_05v0 W=16.42u L=4u
MX325 avdd avdd avdd avdd pfet_05v0 W=16.42u L=4u
MX326 avdd avdd avdd avdd pfet_05v0 W=54.89u L=4u
MX327 rbit2top b2 rbit3top dvss nfet_03v3 W=20u L=0.28u
MX328 xf1 v1 vsp avdd pfet_05v0 W=54.89u L=4u
MX329 avdd avdd avdd avdd pfet_05v0 W=18.75u L=8u
MX330 avdd avdd avdd avdd pfet_05v0 W=18.95u L=8u
MX331 vx2 psrg_m3_feed avdd avdd pfet_05v0 W=16.75u L=2u
MX332 vsu psrg_m3_feed avdd avdd pfet_05v0 W=2u L=2u
MX333 avdd avdd avdd avdd pfet_05v0 W=18.75u L=8u
CX334 vref avss cap_mim_2f0fF W=70.7u L=70.7u
MX335 avdd avdd avdd avdd pfet_05v0 W=18.95u L=8u
MX336 rbit5top b5 rbit6top dvss nfet_03v3 W=2.5u L=0.28u
MX337 avdd avdd avdd avdd pfet_05v0 W=22.21u L=8u
MX338 xf2 v2 vsp avdd pfet_05v0 W=54.89u L=4u
MX339 avss avss avss avss nfet_05v0 W=14.6u L=4u
MX340 avdd avdd avdd avdd pfet_05v0 W=18.75u L=8u
CX341 vref avss cap_mim_2f0fF W=70.7u L=70.7u
MX342 avdd avdd avdd avdd pfet_05v0 W=16.75u L=2u
MX343 vbp_bias vbp_bias avdd avdd pfet_03v3 W=19.06u L=8u
RX344 rbit1top rbit0top avss ppolyf_u_1k W=6.6u L=2u
MX345 vgn1 vcasp vx1 avdd pfet_05v0 W=16.42u L=4u
CX346 vref avss cap_mim_2f0fF W=70.7u L=70.7u
MX347 vbn_i vbp_i avdd avdd pfet_05v0 W=18.75u L=8u
MX348 avdd avdd avdd avdd pfet_05v0 W=18.75u L=8u
MX349 avdd avdd avdd avdd pfet_05v0 W=54.89u L=4u
MX350 vbn_i vbp_i avdd avdd pfet_05v0 W=18.75u L=8u
MX351 avdd avdd avdd avdd pfet_05v0 W=18.99u L=8u
CX352 vref avss cap_mim_2f0fF W=70.7u L=70.7u
MX353 avss avss avss avss nfet_05v0 W=14.6u L=4u
MX354 avdd avdd avdd avdd pfet_05v0 W=16.75u L=2u
MX355 b4_b b4 dvdd dvdd pfet_03v3 W=3u L=0.5u
MX356 vnx_bias vnx_bias avss avss nfet_03v3 W=1.62u L=8u
MX357 vbn vcasp vaux avdd pfet_05v0 W=16u L=4u
MX358 vx1 psrg_m3_feed avdd avdd pfet_05v0 W=16.75u L=2u
MX359 rbit2top b1_b rbit1top dvdd pfet_03v3 W=40u L=0.28u
MX360 vbn_fold vbp_i avdd avdd pfet_05v0 W=18.99u L=8u
MX361 pm2 y1 avdd avdd pfet_05v0 W=20.76u L=4u
MX362 avss avss avss avss nfet_05v0 W=14.6u L=4u
MX363 avdd avdd avdd avdd pfet_05v0 W=16.42u L=4u
MX364 vbn_sink vbp_i avdd avdd pfet_05v0 W=18.95u L=8u
MX365 vbn_fold vbp_i avdd avdd pfet_05v0 W=18.99u L=8u
MX366 avss avss avss avss nfet_05v0 W=18.49u L=6u
MX367 b1_b b1 dvss dvss nfet_03v3 W=1u L=0.5u
MX368 avss avss avss avss nfet_05v0 W=14.6u L=4u
MX369 vbp_bias vbp_bias avdd avdd pfet_03v3 W=19.06u L=8u
MX370 xf2 vbn_sink avss avss nfet_05v0 W=16.34u L=8u
MX371 rbit1top b1 rbit2top dvss nfet_03v3 W=40u L=0.28u
MX372 pm1 y1 avdd avdd pfet_05v0 W=20.76u L=4u
MX373 vsu vsu bgsu1 avss nfet_05v0 W=1u L=2u
MX374 vgn2 vbp_cas pm2 avdd pfet_05v0 W=22.21u L=8u
MX375 avss avss avss avss nfet_05v0 W=7.55u L=4u
MX376 avdd avdd avdd avdd pfet_05v0 W=22.21u L=8u
MX377 xf1 vbn_sink avss avss nfet_05v0 W=16.34u L=8u
MX378 b4_b b4 dvss dvss nfet_03v3 W=1u L=0.5u
MX379 vbn_sink vbp_i avdd avdd pfet_05v0 W=18.95u L=8u
MX380 vbp_cas vbp_cas vbp_bias avdd pfet_05v0 W=18.93u L=8u
MX381 avdd avdd avdd avdd pfet_05v0 W=18.75u L=8u
MX382 xf1 vbn_sink avss avss nfet_05v0 W=16.34u L=8u
MX383 avdd avdd avdd avdd pfet_05v0 W=22.21u L=8u
MX384 vsp vbp_tail avdd avdd pfet_03v3 W=28.91u L=6u
MX385 avdd avdd avdd avdd pfet_05v0 W=18.95u L=8u
MX386 vbp_cas vbp_cas vbp_bias avdd pfet_05v0 W=18.93u L=8u
MX387 aux_gate vbn_i avss avss nfet_05v0 W=1u L=8u
MX388 avdd avdd avdd avdd pfet_05v0 W=18.99u L=8u
MX389 avdd avdd avdd avdd pfet_05v0 W=18.75u L=8u
MX390 avdd avdd avdd avdd pfet_05v0 W=16.42u L=4u
MX391 avdd avdd avdd avdd pfet_05v0 W=16.75u L=2u
MX392 avdd avdd avdd avdd pfet_05v0 W=54.89u L=4u
MX393 avss avss avss avss nfet_05v0 W=16.34u L=8u
MX394 avdd avdd avdd avdd pfet_05v0 W=18.99u L=8u
MX395 vgn1 vgn1 v1 avss nfet_05v0 W=14.6u L=4u
MX396 rb_mid rb_mid avss avss nfet_05v0 W=0.54u L=20u
MX397 avdd avdd avdd avdd pfet_05v0 W=20.76u L=4u
MX398 avdd avdd avdd avdd pfet_05v0 W=54.89u L=4u
MX399 avss avss avss avss nfet_05v0 W=16.34u L=8u
MX400 avdd avdd avdd avdd pfet_05v0 W=22.21u L=8u
MX401 rbit1top b0_b rbit0top dvdd pfet_03v3 W=40u L=0.28u
MX402 vref vcasp vx3 avdd pfet_05v0 W=16.42u L=4u
MX403 xf2 vbn_sink avss avss nfet_05v0 W=16.34u L=8u
MX404 avdd avdd avdd avdd pfet_05v0 W=54.89u L=4u
MX405 avdd avdd avdd avdd pfet_05v0 W=18.75u L=8u
MX406 avdd avdd avdd avdd pfet_05v0 W=22.21u L=8u
MX407 b0_b b0 dvss dvss nfet_03v3 W=1u L=0.5u
MX408 y1 vbp_cas pm1 avdd pfet_05v0 W=22.21u L=8u
MX409 vbp_tail vbp_tail avdd avdd pfet_03v3 W=13.75u L=6u
MX410 rbit6top b6 vq3 dvss nfet_03v3 W=1.25u L=0.28u
MX411 xf2 v2 vsp avdd pfet_05v0 W=54.89u L=4u
MX412 vbp_i vbp_i avdd avdd pfet_05v0 W=18.75u L=8u
MX413 avdd avdd avdd avdd pfet_05v0 W=54.89u L=4u
MX414 vbp_bias vbp_bias avdd avdd pfet_03v3 W=19.06u L=8u
MX415 vbn_i vbp_i avdd avdd pfet_05v0 W=18.75u L=8u
CX416 vref avss cap_mim_2f0fF W=70.7u L=70.7u
MX417 avdd avdd avdd avdd pfet_05v0 W=18.75u L=8u
MX418 avss avss avss avss nfet_05v0 W=12.31u L=8u
MX419 avdd avdd avdd avdd pfet_05v0 W=18.95u L=8u
MX420 vbn_sink vbp_i avdd avdd pfet_05v0 W=18.95u L=8u
MX421 vx3 psrg_m3_feed avdd avdd pfet_05v0 W=16.75u L=2u
MX422 vx2 psrg_m3_feed avdd avdd pfet_05v0 W=16.75u L=2u
MX423 avdd avdd avdd avdd pfet_05v0 W=16.75u L=2u
MX424 avdd avdd avdd avdd pfet_05v0 W=20.76u L=4u
CX425 vref avss cap_mim_2f0fF W=70.7u L=70.7u
MX426 iref_gate vbp_i avdd avdd pfet_05v0 W=80u L=1u
MX427 avss avss avss avss nfet_05v0 W=12.31u L=8u
MX428 avdd avdd avdd avdd pfet_05v0 W=16.75u L=2u
MX429 vsua vcasp avdd avdd pfet_05v0 W=2u L=2u
MX430 avdd avdd avdd avdd pfet_05v0 W=16.42u L=4u
MX431 vbn_sink vbp_i avdd avdd pfet_05v0 W=18.95u L=8u
MX432 vbn_sink vbp_i avdd avdd pfet_05v0 W=18.95u L=8u
MX433 avss avss avss avss nfet_05v0 W=16.34u L=8u
MX434 psrg_vnc vbp_i avdd avdd pfet_05v0 W=17.74u L=4u
MX435 b6_b b6 dvss dvss nfet_03v3 W=1u L=0.5u
MX436 avdd avdd avdd avdd pfet_05v0 W=22.21u L=8u
MX437 vsu1 vbp_i vsu2 avss nfet_05v0 W=0.5u L=50u
MX438 avdd avdd avdd avdd pfet_05v0 W=16.75u L=2u
MX439 avss avss avss avss nfet_05v0 W=14.6u L=4u
MX440 vbp_i vbp_i avdd avdd pfet_05v0 W=18.75u L=8u
MX441 avdd avdd avdd avdd pfet_05v0 W=22.21u L=8u
MX442 bgsu2 bgsu2 avss avss nfet_03v3 W=1u L=2u
MX443 y1 vbp_cas pm1 avdd pfet_05v0 W=22.21u L=8u
MX444 xf1 v1 vsp avdd pfet_05v0 W=54.89u L=4u
MX445 vcasp vbn avss avss nfet_05v0 W=7.55u L=4u
MX446 b2_b b2 dvss dvss nfet_03v3 W=1u L=0.5u
MX447 avdd avdd avdd avdd pfet_05v0 W=18.95u L=8u
MX448 avdd avdd avdd avdd pfet_05v0 W=18.99u L=8u
MX449 vx1 psrg_m3_feed avdd avdd pfet_05v0 W=16.75u L=2u
MX450 su_state vgn2 avss avss nfet_05v0 W=4u L=1u
MX451 vgn2 vbp_cas pm2 avdd pfet_05v0 W=22.21u L=8u
MX452 avdd avdd avdd avdd pfet_05v0 W=16.75u L=2u
MX453 vref vcasp vx3 avdd pfet_05v0 W=16.42u L=4u
MX454 rbit3top b2_b rbit2top dvdd pfet_03v3 W=20u L=0.28u
RX455 rbit5top rbit4top avss ppolyf_u_1k W=6.6u L=32u
MX456 avdd avdd avdd avdd pfet_05v0 W=20.76u L=4u
MX457 auxsu1 auxsu1 auxsu2 avss nfet_03v3 W=1u L=2u
MX458 vgn1 vcasp vx1 avdd pfet_05v0 W=16.42u L=4u
MX459 vsp vbp_tail avdd avdd pfet_03v3 W=28.91u L=6u
MX460 avdd avdd avdd avdd pfet_05v0 W=18.99u L=8u
MX461 vbn_sink vbp_i avdd avdd pfet_05v0 W=18.95u L=8u
MX462 avss avss avss avss nfet_05v0 W=16.34u L=8u
MX463 b0_b b0 dvdd dvdd pfet_03v3 W=3u L=0.5u
MX464 avdd avdd avdd avdd pfet_05v0 W=16.42u L=4u
MX465 avss avss avss avss nfet_05v0 W=7.55u L=4u
RX466 rbit2top rbit1top avss ppolyf_u_1k W=6.6u L=4u
MX467 avdd avdd avdd avdd pfet_05v0 W=16.75u L=2u
MX468 aux_gate vcasp avdd avdd pfet_05v0 W=0.5u L=10u
MX469 avss avss avss avss nfet_05v0 W=16.34u L=8u
MX470 vx3 psrg_m3_feed avdd avdd pfet_05v0 W=16.75u L=2u
MX471 avdd avdd avdd avdd pfet_05v0 W=16.42u L=4u
MX472 avdd avdd avdd avdd pfet_05v0 W=20.76u L=4u
MX473 avss avss avss avss nfet_05v0 W=7.55u L=4u
MX474 avdd avdd avdd avdd pfet_05v0 W=16.42u L=4u
MX475 xf1 vbn_sink avss avss nfet_05v0 W=16.34u L=8u
MX476 vgn2 vbp_cas pm2 avdd pfet_05v0 W=22.21u L=8u
MX477 avdd avdd avdd avdd pfet_05v0 W=22.21u L=8u
MX478 avdd avdd avdd avdd pfet_05v0 W=18.75u L=8u
MX479 avdd avdd avdd avdd pfet_05v0 W=20.76u L=4u
MX480 rbit1top b0_b rbit0top dvdd pfet_03v3 W=40u L=0.28u
MX481 y1 vbp_cas pm1 avdd pfet_05v0 W=22.21u L=8u
MX482 avss avss avss avss nfet_05v0 W=16.34u L=8u
MX483 vsp vbp_tail avdd avdd pfet_03v3 W=28.91u L=6u
MX484 avdd avdd avdd avdd pfet_05v0 W=18.75u L=8u
MX485 vx2 psrg_m3_feed avdd avdd pfet_05v0 W=16.75u L=2u
MX486 y1 vbp_cas pm1 avdd pfet_05v0 W=22.21u L=8u
MX487 avdd avdd avdd avdd pfet_05v0 W=18.75u L=8u
MX488 avdd avdd avdd avdd pfet_05v0 W=20.76u L=4u
MX489 xf1 v1 vsp avdd pfet_05v0 W=54.89u L=4u
MX490 avss avss avss avss nfet_05v0 W=18.49u L=6u
MX491 vx3 psrg_m3_feed avdd avdd pfet_05v0 W=16.75u L=2u
MX492 avdd avdd avdd avdd pfet_05v0 W=18.75u L=8u
MX493 avdd avdd avdd avdd pfet_05v0 W=16.42u L=4u
MX494 avdd avdd avdd avdd pfet_05v0 W=16.75u L=2u
MX495 avdd avdd avdd avdd pfet_05v0 W=16.42u L=4u
MX496 auxsu2 auxsu2 avss avss nfet_03v3 W=1u L=2u
MX497 avdd avdd avdd avdd pfet_05v0 W=18.75u L=8u
MX498 rbit1top b0_b rbit0top dvdd pfet_03v3 W=40u L=0.28u
MX499 avss avss avss avss nfet_05v0 W=7.55u L=4u
MX500 avdd avdd avdd avdd pfet_05v0 W=54.89u L=4u
MX501 avss avss avss avss nfet_05v0 W=12.31u L=8u
MX502 avdd avdd avdd avdd pfet_05v0 W=18.99u L=8u
MX503 pm2 y1 avdd avdd pfet_05v0 W=20.76u L=4u
MX504 avdd avdd avdd avdd pfet_05v0 W=18.95u L=8u
MX505 avss avss avss avss nfet_05v0 W=16.34u L=8u
MX506 avss avss avss avss nfet_05v0 W=16.34u L=8u
MX507 avdd avdd avdd avdd pfet_05v0 W=22.21u L=8u
MX508 rbit2top b1_b rbit1top dvdd pfet_03v3 W=40u L=0.28u
MX509 avdd avdd avdd avdd pfet_05v0 W=54.89u L=4u
MX510 avss avss avss avss nfet_05v0 W=12.31u L=8u
MX511 avdd avdd avdd avdd pfet_05v0 W=18.99u L=8u
MX512 avss avss avss avss nfet_05v0 W=16.34u L=8u
MX513 avdd avdd avdd avdd pfet_05v0 W=22.21u L=8u
MX514 avdd avdd avdd avdd pfet_05v0 W=54.89u L=4u
MX515 avss avss avss avss nfet_05v0 W=7.55u L=4u
MX516 vgn2 vbp_cas pm2 avdd pfet_05v0 W=22.21u L=8u
MX517 pm1 y1 avdd avdd pfet_05v0 W=20.76u L=4u
MX518 avdd avdd avdd avdd pfet_05v0 W=22.21u L=8u
MX519 psrg_vnc vbp_i avdd avdd pfet_05v0 W=17.74u L=4u
MX520 avss avss avss avss nfet_05v0 W=14.6u L=4u
MX521 rbit0top b0 rbit1top dvss nfet_03v3 W=40u L=0.28u
.ends Bandgap_Core_Res
