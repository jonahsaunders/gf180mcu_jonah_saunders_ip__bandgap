* Capacitance-conserving approximation; see conserve_pex_capacitance.py.
* Raw Magic exports remain available for independent review.
* NGSPICE file created from Bandgap_Core_Res.ext - technology: gf180mcuD
.subckt Bandgap_Core_Res avdd avss vref b0 b1 b2 b3 b4 b5 b6 dvss dvdd
Xpnp_05p00x05p00_0 avss avss vq3 pnp_05p00x05p00
Xpnp_05p00x05p00_1 avss avss vq2 pnp_05p00x05p00
Xpnp_05p00x05p00_2 avss avss vq2 pnp_05p00x05p00
Xpnp_05p00x05p00_4 avss avss vq2 pnp_05p00x05p00
Xpnp_05p00x05p00_3 avss avss vq2 pnp_05p00x05p00
Xpnp_05p00x05p00_5 avss avss v1 pnp_05p00x05p00
Xpnp_05p00x05p00_6 avss avss vq2 pnp_05p00x05p00
Xpnp_05p00x05p00_7 avss avss vq2 pnp_05p00x05p00
Xpnp_05p00x05p00_8 avss avss vq2 pnp_05p00x05p00
Xpnp_05p00x05p00_9 avss avss vq2 pnp_05p00x05p00
Xnwell_0 net3 net4 avss nwell r_length=20.19u r_width=2u
X0 rbit0top.t9 b0.t2 rbit1top.t13 dvss nfet_03v3 ad=17.6p pd=80.88u as=17.6p ps=80.88u w=40u l=0.28u
X1 vref.t4 vcasp vx3.t2 avdd.t39 pfet_05v0 ad=7.2248p pd=33.72u as=7.2248p ps=33.72u w=16.42u l=4u
X2 vx2.t7 psrg_m3_feed.t14 avdd.t117 avdd.t116 pfet_05v0 ad=7.37p pd=34.38u as=7.37p ps=34.38u w=16.75u l=2u
X3 vbn_sink.t4 vbn_sink.t3 avss avss nfet_05v0 ad=5.4164p pd=25.5u as=5.4164p ps=25.5u w=12.31u l=8u
X4 vbn_fold.t12 vbp_i.t14 avdd.t201 avdd.t200 pfet_05v0 ad=8.3556p pd=38.86u as=8.3556p ps=38.86u w=18.99u l=8u
X5 vx3.t0 psrg_m3_feed.t26 avdd.t25 avdd.t24 pfet_05v0 ad=7.37p pd=34.38u as=7.37p ps=34.38u w=16.75u l=2u
X6 vbp_bias.t8 vbp_bias.t7 avdd.t191 avdd.t190 pfet_03v3 ad=8.3864p pd=39u as=8.3864p ps=39u w=19.06u l=8u
X7 vgn2.t7 avss cap_mim_2f0fF c_width=59u c_length=59u
X8 vbn_sink.t7 vbp_i.t24 avdd.t142 avdd.t141 pfet_05v0 ad=8.338p pd=38.78u as=8.338p ps=38.78u w=18.95u l=8u
X9 b3_b.t1 b3.t0 dvdd.t19 dvdd.t18 pfet_03v3 ad=1.32p pd=6.88u as=1.32p ps=6.88u w=3u l=0.5u
X10 vref.t1 vcasp vx3.t4 avdd.t44 pfet_05v0 ad=7.2248p pd=33.72u as=7.2248p ps=33.72u w=16.42u l=4u
X11 vbn_sink.t8 vbp_i.t25 avdd.t144 avdd.t143 pfet_05v0 ad=8.338p pd=38.78u as=8.338p ps=38.78u w=18.95u l=8u
X12 vref.t7 avss cap_mim_2f0fF c_width=70.7u c_length=70.7u
X13 su_state.t0 vbp_tail.t7 avdd.t2 avdd.t1 pfet_05v0 ad=0.44p pd=2.88u as=0.44p ps=2.88u w=1u l=8u
X14 vbn_i.t5 vbp_i.t40 avdd.t193 avdd.t192 pfet_05v0 ad=8.25p pd=38.38u as=8.25p ps=38.38u w=18.75u l=8u
X15 rbit3top.t3 b2_b.t3 rbit2top.t1 dvdd.t4 pfet_03v3 ad=8.8p pd=40.88u as=8.8p ps=40.88u w=20u l=0.28u
X16 xf2.t8 vbn_sink.t32 avss avss nfet_05v0 ad=7.1896p pd=33.56u as=7.1896p ps=33.56u w=16.34u l=8u
X17 rbit6top.t0 b5_b.t2 rbit5top.t0 dvdd.t6 pfet_03v3 ad=3.3p pd=15.88u as=3.3p ps=15.88u w=7.5u l=0.28u
X18 rbit4top.t4 rbit3top.t6 avss ppolyf_u_1k r_width=6.6u r_length=16u
X19 vbp_bias.t4 vbp_bias.t3 avdd.t207 avdd.t206 pfet_03v3 ad=8.3864p pd=39u as=8.3864p ps=39u w=19.06u l=8u
X20 rb_mid rb_mid avss avss nfet_05v0 ad=0.2376p pd=1.96u as=0.2376p ps=1.96u w=0.54u l=20u
X21 vgn1.t2 vcasp vx1.t2 avdd.t41 pfet_05v0 ad=7.2248p pd=33.72u as=7.2248p ps=33.72u w=16.42u l=4u
X22 xf1.t2 v1.t2 vsp.t5 avdd.t100 pfet_05v0 ad=24.1516p pd=0.11066m as=24.1516p ps=0.11066m w=54.89u l=4u
X23 rfix2 rfix1 avss ppolyf_u_1k r_width=6.6u r_length=0.128m
X24 vx3.t8 psrg_m3_feed.t25 avdd.t74 avdd.t73 pfet_05v0 ad=7.37p pd=34.38u as=7.37p ps=34.38u w=16.75u l=2u
X25 vgn2.t3 vbp_cas.t21 pm2.t2 avdd.t93 pfet_05v0 ad=9.7724p pd=45.3u as=9.7724p ps=45.3u w=22.21u l=8u
X26 vbp_bias.t16 vbp_bias.t15 avdd.t127 avdd.t126 pfet_03v3 ad=8.3864p pd=39u as=8.3864p ps=39u w=19.06u l=8u
X27 aux_gate vcasp avdd.t37 avdd.t36 pfet_05v0 ad=0.22p pd=1.88u as=0.22p ps=1.88u w=0.5u l=10u
X28 xf2.t0 v2.t5 vsp.t0 avdd.t0 pfet_05v0 ad=24.1516p pd=0.11066m as=24.1516p ps=0.11066m w=54.89u l=4u
X29 vsu vsu bgsu1 avss nfet_05v0 ad=0.44p pd=2.88u as=0.44p ps=2.88u w=1u l=2u
X30 vbp_cas.t18 vbp_cas.t17 vbp_bias.t22 avdd.t189 pfet_05v0 ad=8.3292p pd=38.74u as=8.3292p ps=38.74u w=18.93u l=8u
X31 rbit6top.t1 rbit5top.t2 avss ppolyf_u_1k r_width=6.6u r_length=64u
X32 vx1.t7 psrg_m3_feed.t16 avdd.t62 avdd.t61 pfet_05v0 ad=7.37p pd=34.38u as=7.37p ps=34.38u w=16.75u l=2u
X33 psrg_m3_feed.t2 vcasp vx2.t2 avdd.t46 pfet_05v0 ad=7.2248p pd=33.72u as=7.2248p ps=33.72u w=16.42u l=4u
X34 vbp_bias.t6 vbp_bias.t5 avdd.t228 avdd.t227 pfet_03v3 ad=8.3864p pd=39u as=8.3864p ps=39u w=19.06u l=8u
X35 xf1.t6 vbn_sink.t26 avss avss nfet_05v0 ad=7.1896p pd=33.56u as=7.1896p ps=33.56u w=16.34u l=8u
X36 xf1.t7 vbn_sink.t27 avss avss nfet_05v0 ad=7.1896p pd=33.56u as=7.1896p ps=33.56u w=16.34u l=8u
X37 vbp_cas.t16 vbp_cas.t15 vbp_bias.t21 avdd.t188 pfet_05v0 ad=8.3292p pd=38.74u as=8.3292p ps=38.74u w=18.93u l=8u
X38 su_state.t1 vsu avdd.t18 avdd.t17 pfet_05v0 ad=0.44p pd=2.88u as=0.44p ps=2.88u w=1u l=8u
X39 vx2.t6 psrg_m3_feed.t23 avdd.t99 avdd.t98 pfet_05v0 ad=7.37p pd=34.38u as=7.37p ps=34.38u w=16.75u l=2u
X40 psrg_vnc.t0 vbp_i.t50 avdd.t10 avdd.t9 pfet_05v0 ad=7.8056p pd=36.36u as=7.8056p ps=36.36u w=17.74u l=4u
X41 pm1.t7 y1.t16 avdd.t242 avdd.t241 pfet_05v0 ad=9.1344p pd=42.4u as=9.1344p ps=42.4u w=20.76u l=4u
X42 vsu psrg_m3_feed.t8 avdd.t258 avdd.t257 pfet_05v0 ad=0.88p pd=4.88u as=0.88p ps=4.88u w=2u l=2u
X43 vbp_cas.t14 vbp_cas.t13 vbp_bias.t0 avdd.t125 pfet_05v0 ad=8.3292p pd=38.74u as=8.3292p ps=38.74u w=18.93u l=8u
X44 vbn_sink.t10 vbp_i.t26 avdd.t160 avdd.t159 pfet_05v0 ad=8.338p pd=38.78u as=8.338p ps=38.78u w=18.95u l=8u
X45 b2_b.t1 b2.t0 dvdd.t25 dvdd.t24 pfet_03v3 ad=1.32p pd=6.88u as=1.32p ps=6.88u w=3u l=0.5u
X46 vbn_sink.t11 vbp_i.t27 avdd.t162 avdd.t161 pfet_05v0 ad=8.338p pd=38.78u as=8.338p ps=38.78u w=18.95u l=8u
X47 b5_b.t1 b5.t0 dvdd.t23 dvdd.t22 pfet_03v3 ad=1.32p pd=6.88u as=1.32p ps=6.88u w=3u l=0.5u
X48 psrg_m3_feed.t0 vcasp vx2.t4 avdd.t38 pfet_05v0 ad=7.2248p pd=33.72u as=7.2248p ps=33.72u w=16.42u l=4u
X49 vgn2.t2 vbp_cas.t25 pm2.t1 avdd.t22 pfet_05v0 ad=9.7724p pd=45.3u as=9.7724p ps=45.3u w=22.21u l=8u
X50 xf2.t4 vbn_sink.t21 avss avss nfet_05v0 ad=7.1896p pd=33.56u as=7.1896p ps=33.56u w=16.34u l=8u
X51 vbp_cas.t12 vbp_cas.t11 vbp_bias.t24 avdd.t224 pfet_05v0 ad=8.3292p pd=38.74u as=8.3292p ps=38.74u w=18.93u l=8u
X52 vx1.t9 psrg_m3_feed.t13 avdd.t79 avdd.t78 pfet_05v0 ad=7.37p pd=34.38u as=7.37p ps=34.38u w=16.75u l=2u
X53 vref.t15 avss cap_mim_2f0fF c_width=70.7u c_length=70.7u
X54 vref.t2 vcasp vx3.t3 avdd.t43 pfet_05v0 ad=7.2248p pd=33.72u as=7.2248p ps=33.72u w=16.42u l=4u
X55 rbit1top.t8 b0_b.t3 rbit0top.t6 dvdd.t0 pfet_03v3 ad=17.6p pd=80.88u as=17.6p ps=80.88u w=40u l=0.28u
X56 vbp_i.t8 vbp_i.t7 avdd.t20 avdd.t19 pfet_05v0 ad=8.25p pd=38.38u as=8.25p ps=38.38u w=18.75u l=8u
X57 y1.t6 psrg_vnc.t9 psrg_mf1_protected.t0 avss nfet_05v0 ad=8.1356p pd=37.86u as=8.1356p ps=37.86u w=18.49u l=6u
X58 rbit0top.t7 rfix2 avss ppolyf_u_1k r_width=6.6u r_length=0.128m
X59 vbn_fold.t10 vbp_i.t19 avdd.t108 avdd.t107 pfet_05v0 ad=8.3556p pd=38.86u as=8.3556p ps=38.86u w=18.99u l=8u
X60 rbit4top.t1 b3_b.t2 rbit3top.t0 dvdd.t5 pfet_03v3 ad=13.2p pd=60.88u as=13.2p ps=60.88u w=30u l=0.28u
X61 rbit5top.t5 b4_b.t2 rbit4top.t5 dvdd.t9 pfet_03v3 ad=6.6p pd=30.88u as=6.6p ps=30.88u w=15u l=0.28u
X62 xf2.t6 vbn_sink.t29 avss avss nfet_05v0 ad=7.1896p pd=33.56u as=7.1896p ps=33.56u w=16.34u l=8u
X63 vbp_i.t4 vbp_i.t3 avdd.t111 avdd.t110 pfet_05v0 ad=8.25p pd=38.38u as=8.25p ps=38.38u w=18.75u l=8u
X64 rbit2top.t3 b1_b.t4 rbit1top.t1 dvdd.t11 pfet_03v3 ad=17.6p pd=80.88u as=17.6p ps=80.88u w=40u l=0.28u
X65 xf2.t5 v2.t4 vsp.t7 avdd.t124 pfet_05v0 ad=24.1516p pd=0.11066m as=24.1516p ps=0.11066m w=54.89u l=4u
X66 rbit4top.t2 b4.t2 rbit5top.t3 dvss nfet_03v3 ad=2.2p pd=10.88u as=2.2p ps=10.88u w=5u l=0.28u
X67 vbp_bias.t2 vbp_bias.t1 avdd.t81 avdd.t80 pfet_03v3 ad=8.3864p pd=39u as=8.3864p ps=39u w=19.06u l=8u
X68 vbn.t2 vbn.t1 avss avss nfet_05v0 ad=3.322p pd=15.98u as=3.322p ps=15.98u w=7.55u l=4u
X69 vbn_fold.t5 vbp_i.t16 avdd.t88 avdd.t87 pfet_05v0 ad=8.3556p pd=38.86u as=8.3556p ps=38.86u w=18.99u l=8u
X70 vsp.t14 vbp_tail.t9 avdd.t218 avdd.t217 pfet_03v3 ad=12.7204p pd=58.7u as=12.7204p ps=58.7u w=28.91u l=6u
X71 vx1.t8 psrg_m3_feed.t24 avdd.t72 avdd.t71 pfet_05v0 ad=7.37p pd=34.38u as=7.37p ps=34.38u w=16.75u l=2u
X72 vref.t6 avss cap_mim_2f0fF c_width=70.7u c_length=70.7u
X73 vbp_cas.t8 vbp_cas.t7 vbp_bias.t25 avdd.t245 pfet_05v0 ad=8.3292p pd=38.74u as=8.3292p ps=38.74u w=18.93u l=8u
X74 xf1.t10 v1.t3 vsp.t15 avdd.t255 pfet_05v0 ad=24.1516p pd=0.11066m as=24.1516p ps=0.11066m w=54.89u l=4u
X75 vaux.t2 psrg_m3_feed.t21 avdd.t154 avdd.t153 pfet_05v0 ad=4.4p pd=20.88u as=4.4p ps=20.88u w=10u l=2u
X76 vbp_tail.t6 vbn_i.t10 avss avss nfet_05v0 ad=6.138p pd=28.78u as=6.138p ps=28.78u w=13.95u l=8u
X77 xf1.t11 vbn_sink.t23 avss avss nfet_05v0 ad=7.1896p pd=33.56u as=7.1896p ps=33.56u w=16.34u l=8u
X78 y1.t0 vbp_cas.t26 pm1.t0 avdd.t23 pfet_05v0 ad=9.7724p pd=45.3u as=9.7724p ps=45.3u w=22.21u l=8u
X79 pm1.t9 y1.t12 avdd.t179 avdd.t178 pfet_05v0 ad=9.1344p pd=42.4u as=9.1344p ps=42.4u w=20.76u l=4u
X80 vbn_i.t6 vbp_i.t41 avdd.t195 avdd.t194 pfet_05v0 ad=8.25p pd=38.38u as=8.25p ps=38.38u w=18.75u l=8u
X81 vbp_cas.t10 vbp_cas.t9 vbp_bias.t26 avdd.t246 pfet_05v0 ad=8.3292p pd=38.74u as=8.3292p ps=38.74u w=18.93u l=8u
X82 psrg_vnc.t5 psrg_vnc.t4 rb_mid avss nfet_05v0 ad=0.3124p pd=2.3u as=0.3124p ps=2.3u w=0.71u l=20u
X83 psrg_vnc.t1 vbp_i.t51 avdd.t12 avdd.t11 pfet_05v0 ad=7.8056p pd=36.36u as=7.8056p ps=36.36u w=17.74u l=4u
X84 rfix0 vref.t5 avss ppolyf_u_1k r_width=6.6u r_length=0.128m
X85 vsp.t8 vbp_tail.t13 avdd.t131 avdd.t130 pfet_03v3 ad=12.7204p pd=58.7u as=12.7204p ps=58.7u w=28.91u l=6u
X86 vbp_cas.t6 vbp_cas.t5 vbp_bias.t23 avdd.t223 pfet_05v0 ad=8.3292p pd=38.74u as=8.3292p ps=38.74u w=18.93u l=8u
X87 pm2.t9 y1.t11 avdd.t164 avdd.t163 pfet_05v0 ad=9.1344p pd=42.4u as=9.1344p ps=42.4u w=20.76u l=4u
X88 vbp_cas.t4 vbp_cas.t3 vbp_bias.t20 avdd.t175 pfet_05v0 ad=8.3292p pd=38.74u as=8.3292p ps=38.74u w=18.93u l=8u
X89 vref.t14 avss cap_mim_2f0fF c_width=70.7u c_length=70.7u
X90 vbn_fold.t3 vbp_i.t21 avdd.t58 avdd.t57 pfet_05v0 ad=8.3556p pd=38.86u as=8.3556p ps=38.86u w=18.99u l=8u
X91 rbit3top.t1 rbit2top.t6 avss ppolyf_u_1k r_width=6.6u r_length=8u
X92 psrg_m3_feed.t6 psrg_vnc.t10 psrg_m3_protected.t1 avss nfet_05v0 ad=6.424p pd=30.08u as=6.424p ps=30.08u w=14.6u l=4u
X93 vbn_fold.t1 vbn_fold.t0 vnx_bias avss nfet_05v0 ad=2.0328p pd=10.12u as=2.0328p ps=10.12u w=4.62u l=6u
X94 vx3.t9 psrg_m3_feed.t12 avdd.t77 avdd.t76 pfet_05v0 ad=7.37p pd=34.38u as=7.37p ps=34.38u w=16.75u l=2u
X95 vbn_sink.t14 vbp_i.t34 avdd.t183 avdd.t182 pfet_05v0 ad=8.338p pd=38.78u as=8.338p ps=38.78u w=18.95u l=8u
X96 vbn_sink.t16 vbp_i.t47 avdd.t199 avdd.t198 pfet_05v0 ad=8.338p pd=38.78u as=8.338p ps=38.78u w=18.95u l=8u
X97 pm1.t8 y1.t13 avdd.t181 avdd.t180 pfet_05v0 ad=9.1344p pd=42.4u as=9.1344p ps=42.4u w=20.76u l=4u
X98 iref_gate.t1 vbp_i.t42 vsu1 avss nfet_05v0 ad=0.22p pd=1.88u as=0.22p ps=1.88u w=0.5u l=50u
X99 vbp_tail.t1 vbp_tail.t0 avdd.t4 avdd.t3 pfet_03v3 ad=6.05p pd=28.38u as=6.05p ps=28.38u w=13.75u l=6u
X100 vbp_i.t10 vbp_i.t9 avdd.t213 avdd.t212 pfet_05v0 ad=8.25p pd=38.38u as=8.25p ps=38.38u w=18.75u l=8u
X101 vbn_fold.t9 vbp_i.t18 avdd.t106 avdd.t105 pfet_05v0 ad=8.3556p pd=38.86u as=8.3556p ps=38.86u w=18.99u l=8u
X102 rfix1 rfix0 avss ppolyf_u_1k r_width=6.6u r_length=0.128m
X103 vbn_fold.t11 vbp_i.t11 avdd.t115 avdd.t114 pfet_05v0 ad=8.3556p pd=38.86u as=8.3556p ps=38.86u w=18.99u l=8u
X104 xf2.t7 vbn_sink.t28 avss avss nfet_05v0 ad=7.1896p pd=33.56u as=7.1896p ps=33.56u w=16.34u l=8u
X105 y1.t1 vbp_cas.t22 pm1.t1 avdd.t94 pfet_05v0 ad=9.7724p pd=45.3u as=9.7724p ps=45.3u w=22.21u l=8u
X106 vbp_bias.t12 vbp_bias.t11 avdd.t146 avdd.t145 pfet_03v3 ad=8.3864p pd=39u as=8.3864p ps=39u w=19.06u l=8u
X107 vref.t8 avss cap_mim_2f0fF c_width=70.7u c_length=70.7u
X108 rbit3top.t5 b3.t2 rbit4top.t3 dvss nfet_03v3 ad=4.4p pd=20.88u as=4.4p ps=20.88u w=10u l=0.28u
X109 vx2.t10 psrg_m3_feed.t20 avdd.t152 avdd.t151 pfet_05v0 ad=7.37p pd=34.38u as=7.37p ps=34.38u w=16.75u l=2u
X110 vx3.t10 psrg_m3_feed.t11 avdd.t123 avdd.t122 pfet_05v0 ad=7.37p pd=34.38u as=7.37p ps=34.38u w=16.75u l=2u
X111 y1.t2 vbp_cas.t23 pm1.t2 avdd.t95 pfet_05v0 ad=9.7724p pd=45.3u as=9.7724p ps=45.3u w=22.21u l=8u
X112 bgsu1 bgsu1 bgsu2 avss nfet_03v3 ad=0.44p pd=2.88u as=0.44p ps=2.88u w=1u l=2u
X113 vbp_cas.t2 vbp_cas.t1 vbp_bias.t19 avdd.t134 pfet_05v0 ad=8.3292p pd=38.74u as=8.3292p ps=38.74u w=18.93u l=8u
X114 rbit1top.t4 b0_b.t7 rbit0top.t2 dvdd.t13 pfet_03v3 ad=17.6p pd=80.88u as=17.6p ps=80.88u w=40u l=0.28u
X115 rbit1top.t7 b0_b.t4 rbit0top.t3 dvdd.t1 pfet_03v3 ad=17.6p pd=80.88u as=17.6p ps=80.88u w=40u l=0.28u
X116 vref.t12 avss cap_mim_2f0fF c_width=70.7u c_length=70.7u
X117 xf2.t2 v2.t3 vsp.t4 avdd.t82 pfet_05v0 ad=24.1516p pd=0.11066m as=24.1516p ps=0.11066m w=54.89u l=4u
X118 b3_b.t0 b3.t1 dvss dvss nfet_03v3 ad=0.44p pd=2.88u as=0.44p ps=2.88u w=1u l=0.5u
X119 y1.t5 vbp_cas.t27 pm1.t5 avdd.t172 pfet_05v0 ad=9.7724p pd=45.3u as=9.7724p ps=45.3u w=22.21u l=8u
X120 xf1.t3 vbn_sink.t22 avss avss nfet_05v0 ad=7.1896p pd=33.56u as=7.1896p ps=33.56u w=16.34u l=8u
X121 xf1.t5 vbn_sink.t31 avss avss nfet_05v0 ad=7.1896p pd=33.56u as=7.1896p ps=33.56u w=16.34u l=8u
X122 vbn_sink.t20 vbp_i.t29 avdd.t236 avdd.t235 pfet_05v0 ad=8.338p pd=38.78u as=8.338p ps=38.78u w=18.95u l=8u
X123 vx2.t0 psrg_m3_feed.t9 avdd.t14 avdd.t13 pfet_05v0 ad=7.37p pd=34.38u as=7.37p ps=34.38u w=16.75u l=2u
X124 vgn1.t6 vgn1.t5 v1.t0 avss nfet_05v0 ad=6.424p pd=30.08u as=6.424p ps=30.08u w=14.6u l=4u
X125 vbp_i.t2 vbp_i.t1 avdd.t244 avdd.t243 pfet_05v0 ad=8.25p pd=38.38u as=8.25p ps=38.38u w=18.75u l=8u
X126 iref_gate.t0 vbp_i.t36 avdd.t6 avdd.t5 pfet_05v0 ad=35.2p pd=0.16088m as=35.2p ps=0.16088m w=80u l=1u
X127 vsp.t10 vbp_tail.t11 avdd.t138 avdd.t137 pfet_03v3 ad=12.7204p pd=58.7u as=12.7204p ps=58.7u w=28.91u l=6u
X128 su_state.t2 vgn2.t8 avss avss nfet_05v0 ad=1.76p pd=8.88u as=1.76p ps=8.88u w=4u l=1u
X129 b5_b.t0 b5.t2 dvss dvss nfet_03v3 ad=0.44p pd=2.88u as=0.44p ps=2.88u w=1u l=0.5u
X130 b6_b.t1 b6.t0 dvdd.t29 dvdd.t28 pfet_03v3 ad=1.32p pd=6.88u as=1.32p ps=6.88u w=3u l=0.5u
X131 psrg_m3_feed.t3 vcasp vx2.t5 avdd.t50 pfet_05v0 ad=7.2248p pd=33.72u as=7.2248p ps=33.72u w=16.42u l=4u
X132 vbn_sink.t9 vbp_i.t43 avdd.t148 avdd.t147 pfet_05v0 ad=8.338p pd=38.78u as=8.338p ps=38.78u w=18.95u l=8u
X133 psrg_m3_feed.t5 psrg_vnc.t11 psrg_m3_protected.t3 avss nfet_05v0 ad=6.424p pd=30.08u as=6.424p ps=30.08u w=14.6u l=4u
X134 pm1.t10 y1.t9 avdd.t250 avdd.t249 pfet_05v0 ad=9.1344p pd=42.4u as=9.1344p ps=42.4u w=20.76u l=4u
X135 vbn_sink.t12 vbp_i.t30 avdd.t169 avdd.t168 pfet_05v0 ad=8.338p pd=38.78u as=8.338p ps=38.78u w=18.95u l=8u
X136 vbp_tail.t5 vbp_tail.t4 avdd.t177 avdd.t176 pfet_03v3 ad=6.05p pd=28.38u as=6.05p ps=28.38u w=13.75u l=6u
X137 vbn_fold.t2 vbp_i.t20 avdd.t56 avdd.t55 pfet_05v0 ad=8.3556p pd=38.86u as=8.3556p ps=38.86u w=18.99u l=8u
X138 vbn_sink.t17 vbp_i.t44 avdd.t220 avdd.t219 pfet_05v0 ad=8.338p pd=38.78u as=8.338p ps=38.78u w=18.95u l=8u
X139 xf2.t11 vbn_sink.t25 avss avss nfet_05v0 ad=7.1896p pd=33.56u as=7.1896p ps=33.56u w=16.34u l=8u
X140 vbn_sink.t13 vbp_i.t31 avdd.t171 avdd.t170 pfet_05v0 ad=8.338p pd=38.78u as=8.338p ps=38.78u w=18.95u l=8u
X141 b1_b.t1 b1.t2 dvdd.t15 dvdd.t14 pfet_03v3 ad=1.32p pd=6.88u as=1.32p ps=6.88u w=3u l=0.5u
X142 vq3.t1 b6_b.t2 rbit6top.t3 dvdd.t21 pfet_03v3 ad=1.65p pd=8.38u as=1.65p ps=8.38u w=3.75u l=0.28u
X143 vq3.t0 rbit6top.t2 avss ppolyf_u_1k r_width=6.6u r_length=0.128m
X144 psrg_vnc.t7 vbp_i.t48 avdd.t252 avdd.t251 pfet_05v0 ad=7.8056p pd=36.36u as=7.8056p ps=36.36u w=17.74u l=4u
X145 y1.t4 vbp_cas.t31 pm1.t4 avdd.t166 pfet_05v0 ad=9.7724p pd=45.3u as=9.7724p ps=45.3u w=22.21u l=8u
X146 rbit3top.t2 b2_b.t4 rbit2top.t2 dvdd.t8 pfet_03v3 ad=8.8p pd=40.88u as=8.8p ps=40.88u w=20u l=0.28u
X147 vgn2.t0 vbn_fold.t15 xf2.t9 avss nfet_05v0 ad=8.1356p pd=37.86u as=8.1356p ps=37.86u w=18.49u l=6u
X148 vgn2.t1 vbp_cas.t24 pm2.t0 avdd.t21 pfet_05v0 ad=9.7724p pd=45.3u as=9.7724p ps=45.3u w=22.21u l=8u
X149 vbn_i.t4 vbp_i.t39 avdd.t158 avdd.t157 pfet_05v0 ad=8.25p pd=38.38u as=8.25p ps=38.38u w=18.75u l=8u
X150 vbp_tail.t3 vbp_tail.t2 avdd.t133 avdd.t132 pfet_03v3 ad=6.05p pd=28.38u as=6.05p ps=28.38u w=13.75u l=6u
X151 vbp_i.t6 vbp_i.t5 avdd.t113 avdd.t112 pfet_05v0 ad=8.25p pd=38.38u as=8.25p ps=38.38u w=18.75u l=8u
X152 vbn.t0 vcasp vaux.t0 avdd.t53 pfet_05v0 ad=7.04p pd=32.88u as=7.04p ps=32.88u w=16u l=4u
X153 vsua vcasp avdd.t35 avdd.t34 pfet_05v0 ad=0.88p pd=4.88u as=0.88p ps=4.88u w=2u l=2u
X154 rbit2top.t9 b2.t2 rbit3top.t7 dvss nfet_03v3 ad=8.8p pd=40.88u as=8.8p ps=40.88u w=20u l=0.28u
X155 pm2.t6 y1.t18 avdd.t232 avdd.t231 pfet_05v0 ad=9.1344p pd=42.4u as=9.1344p ps=42.4u w=20.76u l=4u
X156 vx2.t9 psrg_m3_feed.t28 avdd.t150 avdd.t149 pfet_05v0 ad=7.37p pd=34.38u as=7.37p ps=34.38u w=16.75u l=2u
X157 vsp.t9 vbp_tail.t10 avdd.t136 avdd.t135 pfet_03v3 ad=12.7204p pd=58.7u as=12.7204p ps=58.7u w=28.91u l=6u
X158 rbit5top.t4 b5.t1 rbit6top.t4 dvss nfet_03v3 ad=1.1p pd=5.88u as=1.1p ps=5.88u w=2.5u l=0.28u
X159 rbit1top.t0 rbit0top.t0 avss ppolyf_u_1k r_width=6.6u r_length=2u
X160 vx1.t10 psrg_m3_feed.t10 avdd.t121 avdd.t120 pfet_05v0 ad=7.37p pd=34.38u as=7.37p ps=34.38u w=16.75u l=2u
X161 vx1.t1 psrg_m3_feed.t19 avdd.t31 avdd.t30 pfet_05v0 ad=7.37p pd=34.38u as=7.37p ps=34.38u w=16.75u l=2u
X162 vaux.t1 psrg_m3_feed.t22 avdd.t97 avdd.t96 pfet_05v0 ad=4.4p pd=20.88u as=4.4p ps=20.88u w=10u l=2u
X163 vsp.t12 vbp_tail.t8 avdd.t215 avdd.t214 pfet_03v3 ad=12.7204p pd=58.7u as=12.7204p ps=58.7u w=28.91u l=6u
X164 b4_b.t1 b4.t0 dvdd.t17 dvdd.t16 pfet_03v3 ad=1.32p pd=6.88u as=1.32p ps=6.88u w=3u l=0.5u
X165 vbn_sink.t18 vbp_i.t45 avdd.t222 avdd.t221 pfet_05v0 ad=8.338p pd=38.78u as=8.338p ps=38.78u w=18.95u l=8u
X166 vbn_sink.t0 vbp_i.t32 avdd.t84 avdd.t83 pfet_05v0 ad=8.338p pd=38.78u as=8.338p ps=38.78u w=18.95u l=8u
X167 rbit2top.t5 b1_b.t2 rbit1top.t2 dvdd.t10 pfet_03v3 ad=17.6p pd=80.88u as=17.6p ps=80.88u w=40u l=0.28u
X168 pm1.t11 y1.t8 avdd.t211 avdd.t210 pfet_05v0 ad=9.1344p pd=42.4u as=9.1344p ps=42.4u w=20.76u l=4u
X169 pm2.t8 y1.t14 avdd.t238 avdd.t237 pfet_05v0 ad=9.1344p pd=42.4u as=9.1344p ps=42.4u w=20.76u l=4u
X170 vbn_sink.t15 vbp_i.t46 avdd.t197 avdd.t196 pfet_05v0 ad=8.338p pd=38.78u as=8.338p ps=38.78u w=18.95u l=8u
X171 vbp_bias.t10 vbp_bias.t9 avdd.t209 avdd.t208 pfet_03v3 ad=8.3864p pd=39u as=8.3864p ps=39u w=19.06u l=8u
X172 vbn_fold.t4 vbp_i.t13 avdd.t60 avdd.t59 pfet_05v0 ad=8.3556p pd=38.86u as=8.3556p ps=38.86u w=18.99u l=8u
X173 vbn_sink.t1 vbp_i.t33 avdd.t86 avdd.t85 pfet_05v0 ad=8.338p pd=38.78u as=8.338p ps=38.78u w=18.95u l=8u
X174 b1_b.t0 b1.t1 dvss dvss nfet_03v3 ad=0.44p pd=2.88u as=0.44p ps=2.88u w=1u l=0.5u
X175 vgn2.t4 vbp_cas.t32 pm2.t3 avdd.t167 pfet_05v0 ad=9.7724p pd=45.3u as=9.7724p ps=45.3u w=22.21u l=8u
X176 xf1.t4 vbn_sink.t30 avss avss nfet_05v0 ad=7.1896p pd=33.56u as=7.1896p ps=33.56u w=16.34u l=8u
X177 rbit1top.t10 b1.t0 rbit2top.t7 dvss nfet_03v3 ad=17.6p pd=80.88u as=17.6p ps=80.88u w=40u l=0.28u
X178 vq2 v2.t0 avss ppolyf_u_1k r_width=4u r_length=42.1u
X179 psrg_m3_feed.t1 vcasp vx2.t1 avdd.t40 pfet_05v0 ad=7.2248p pd=33.72u as=7.2248p ps=33.72u w=16.42u l=4u
X180 b4_b.t0 b4.t1 dvss dvss nfet_03v3 ad=0.44p pd=2.88u as=0.44p ps=2.88u w=1u l=0.5u
X181 xf2.t1 v2.t6 vsp.t3 avdd.t54 pfet_05v0 ad=24.1516p pd=0.11066m as=24.1516p ps=0.11066m w=54.89u l=4u
X182 pm2.t10 y1.t10 avdd.t70 avdd.t69 pfet_05v0 ad=9.1344p pd=42.4u as=9.1344p ps=42.4u w=20.76u l=4u
X183 vref.t0 vcasp vx3.t6 avdd.t52 pfet_05v0 ad=7.2248p pd=33.72u as=7.2248p ps=33.72u w=16.42u l=4u
X184 vref.t10 avss cap_mim_2f0fF c_width=70.7u c_length=70.7u
X185 vref.t11 avss cap_mim_2f0fF c_width=70.7u c_length=70.7u
X186 vgn1.t4 vcasp vx1.t4 avdd.t45 pfet_05v0 ad=7.2248p pd=33.72u as=7.2248p ps=33.72u w=16.42u l=4u
X187 vbn_i.t7 iref_gate.t3 avdd.t248 avdd.t247 pfet_05v0 ad=0.22p pd=1.88u as=0.22p ps=1.88u w=0.5u l=8u
X188 vnx_bias vnx_bias avss avss nfet_03v3 ad=0.7128p pd=4.12u as=0.7128p ps=4.12u w=1.62u l=8u
X189 xf2.t10 vbn_sink.t24 avss avss nfet_05v0 ad=7.1896p pd=33.56u as=7.1896p ps=33.56u w=16.34u l=8u
X190 xf1.t9 v1.t5 vsp.t13 avdd.t216 pfet_05v0 ad=24.1516p pd=0.11066m as=24.1516p ps=0.11066m w=54.89u l=4u
X191 vbp_i.t0 vbn_i.t11 net4 avss nfet_05v0 ad=4.0172p pd=19.14u as=4.0172p ps=19.14u w=9.13u l=8u
X192 pm1.t6 y1.t17 avdd.t230 avdd.t229 pfet_05v0 ad=9.1344p pd=42.4u as=9.1344p ps=42.4u w=20.76u l=4u
X193 iref_gate.t2 vbp_i.t35 avdd.t185 avdd.t184 pfet_05v0 ad=35.2p pd=0.16088m as=35.2p ps=0.16088m w=80u l=1u
X194 xf2.t3 v2.t7 vsp.t6 avdd.t109 pfet_05v0 ad=24.1516p pd=0.11066m as=24.1516p ps=0.11066m w=54.89u l=4u
X195 rbit1top.t6 b0_b.t5 rbit0top.t5 dvdd.t3 pfet_03v3 ad=17.6p pd=80.88u as=17.6p ps=80.88u w=40u l=0.28u
X196 bgsu2 bgsu2 avss avss nfet_03v3 ad=0.44p pd=2.88u as=0.44p ps=2.88u w=1u l=2u
X197 vbn_i.t3 vbp_i.t38 avdd.t156 avdd.t155 pfet_05v0 ad=8.25p pd=38.38u as=8.25p ps=38.38u w=18.75u l=8u
X198 b0_b.t0 b0.t0 dvss dvss nfet_03v3 ad=0.44p pd=2.88u as=0.44p ps=2.88u w=1u l=0.5u
X199 rbit6top.t5 b6.t1 vq3.t2 dvss nfet_03v3 ad=0.55p pd=3.38u as=0.55p ps=3.38u w=1.25u l=0.28u
X200 psrg_vnc.t3 vbp_i.t53 avdd.t68 avdd.t67 pfet_05v0 ad=7.8056p pd=36.36u as=7.8056p ps=36.36u w=17.74u l=4u
X201 vbn_fold.t8 vbp_i.t22 avdd.t102 avdd.t101 pfet_05v0 ad=8.3556p pd=38.86u as=8.3556p ps=38.86u w=18.99u l=8u
X202 auxsu1 auxsu1 auxsu2 avss nfet_03v3 ad=0.44p pd=2.88u as=0.44p ps=2.88u w=1u l=2u
X203 psrg_m3_protected.t0 vgn2.t10 v2.t1 avss nfet_05v0 ad=6.424p pd=30.08u as=6.424p ps=30.08u w=14.6u l=4u
X204 vbn_fold.t13 vbp_i.t15 avdd.t203 avdd.t202 pfet_05v0 ad=8.3556p pd=38.86u as=8.3556p ps=38.86u w=18.99u l=8u
X205 aux_gate vbn_i.t8 avss avss nfet_05v0 ad=0.44p pd=2.88u as=0.44p ps=2.88u w=1u l=8u
X206 vsu1 vbp_i.t56 vsu2 avss nfet_05v0 ad=0.22p pd=1.88u as=0.22p ps=1.88u w=0.5u l=50u
X207 vgn1.t1 vcasp vx1.t6 avdd.t49 pfet_05v0 ad=7.2248p pd=33.72u as=7.2248p ps=33.72u w=16.42u l=4u
X208 vbp_cas.t0 vbn_i.t9 avss avss nfet_05v0 ad=0.286p pd=2.18u as=0.286p ps=2.18u w=0.65u l=8u
X209 pm2.t11 y1.t7 avdd.t187 avdd.t186 pfet_05v0 ad=9.1344p pd=42.4u as=9.1344p ps=42.4u w=20.76u l=4u
X210 vx1.t0 psrg_m3_feed.t27 avdd.t27 avdd.t26 pfet_05v0 ad=7.37p pd=34.38u as=7.37p ps=34.38u w=16.75u l=2u
X211 b6_b.t0 b6.t2 dvss dvss nfet_03v3 ad=0.44p pd=2.88u as=0.44p ps=2.88u w=1u l=0.5u
X212 psrg_mf1_protected.t1 vbn_fold.t14 xf1.t8 avss nfet_05v0 ad=8.1356p pd=37.86u as=8.1356p ps=37.86u w=18.49u l=6u
X213 vbn.t3 aux_gate avdd.t261 avdd.t260 pfet_05v0 ad=0.22p pd=1.88u as=0.22p ps=1.88u w=0.5u l=8u
X214 vsu2 vbp_i.t55 avss avss nfet_05v0 ad=0.22p pd=1.88u as=0.22p ps=1.88u w=0.5u l=50u
X215 vx3.t1 psrg_m3_feed.t18 avdd.t29 avdd.t28 pfet_05v0 ad=7.37p pd=34.38u as=7.37p ps=34.38u w=16.75u l=2u
X216 vgn2.t5 vbp_cas.t28 pm2.t4 avdd.t173 pfet_05v0 ad=9.7724p pd=45.3u as=9.7724p ps=45.3u w=22.21u l=8u
X217 vbp_bias.t18 vbp_bias.t17 avdd.t129 avdd.t128 pfet_03v3 ad=8.3864p pd=39u as=8.3864p ps=39u w=19.06u l=8u
X218 vcasp vbn.t4 avss avss nfet_05v0 ad=3.322p pd=15.98u as=3.322p ps=15.98u w=7.55u l=4u
X219 avss net3 avdd.t75 pplus_u r_width=1u r_length=0.23253m
X220 vgn1.t9 aux_gate psrg_m3_feed.t7 avdd.t259 pfet_05v0 ad=0.88p pd=4.88u as=0.88p ps=4.88u w=2u l=2u
X221 vcasp vcasp avdd.t33 avdd.t32 pfet_05v0 ad=0.396p pd=2.68u as=0.396p ps=2.68u w=0.9u l=2u
X222 psrg_vnc.t8 vbp_i.t49 avdd.t254 avdd.t253 pfet_05v0 ad=7.8056p pd=36.36u as=7.8056p ps=36.36u w=17.74u l=4u
X223 vsp.t11 vbp_tail.t12 avdd.t140 avdd.t139 pfet_03v3 ad=12.7204p pd=58.7u as=12.7204p ps=58.7u w=28.91u l=6u
X224 b2_b.t0 b2.t1 dvss dvss nfet_03v3 ad=0.44p pd=2.88u as=0.44p ps=2.88u w=1u l=0.5u
X225 vgn2.t6 vbp_cas.t29 pm2.t5 avdd.t174 pfet_05v0 ad=9.7724p pd=45.3u as=9.7724p ps=45.3u w=22.21u l=8u
X226 vbn_i.t1 vbn_i.t0 avss avss nfet_05v0 ad=3.4232p pd=16.44u as=3.4232p ps=16.44u w=7.78u l=8u
X227 vbp_bias.t14 vbp_bias.t13 avdd.t226 avdd.t225 pfet_03v3 ad=8.3864p pd=39u as=8.3864p ps=39u w=19.06u l=8u
X228 rbit3top.t4 b2_b.t2 rbit2top.t0 dvdd.t2 pfet_03v3 ad=8.8p pd=40.88u as=8.8p ps=40.88u w=20u l=0.28u
X229 rbit5top.t1 rbit4top.t0 avss ppolyf_u_1k r_width=6.6u r_length=32u
X230 vbn_i.t2 vbp_i.t37 avdd.t8 avdd.t7 pfet_05v0 ad=8.25p pd=38.38u as=8.25p ps=38.38u w=18.75u l=8u
X231 auxsu2 auxsu2 avss avss nfet_03v3 ad=0.44p pd=2.88u as=0.44p ps=2.88u w=1u l=2u
X232 vbn_sink.t19 vbp_i.t28 avdd.t234 avdd.t233 pfet_05v0 ad=8.338p pd=38.78u as=8.338p ps=38.78u w=18.95u l=8u
X233 vbn_sink.t6 vbn_sink.t5 avss avss nfet_05v0 ad=5.4164p pd=25.5u as=5.4164p ps=25.5u w=12.31u l=8u
X234 vgn1.t8 vgn1.t7 v1.t1 avss nfet_05v0 ad=6.424p pd=30.08u as=6.424p ps=30.08u w=14.6u l=4u
X235 b0_b.t1 b0.t1 dvdd.t27 dvdd.t26 pfet_03v3 ad=1.32p pd=6.88u as=1.32p ps=6.88u w=3u l=0.5u
X236 rbit2top.t8 rbit1top.t11 avss ppolyf_u_1k r_width=6.6u r_length=4u
X237 vref.t9 avss cap_mim_2f0fF c_width=70.7u c_length=70.7u
X238 vbn_fold.t7 vbp_i.t12 avdd.t92 avdd.t91 pfet_05v0 ad=8.3556p pd=38.86u as=8.3556p ps=38.86u w=18.99u l=8u
X239 vref.t13 avss cap_mim_2f0fF c_width=70.7u c_length=70.7u
X240 xf1.t0 v1.t4 vsp.t1 avdd.t15 pfet_05v0 ad=24.1516p pd=0.11066m as=24.1516p ps=0.11066m w=54.89u l=4u
X241 psrg_m3_feed.t4 vcasp vx2.t3 avdd.t51 pfet_05v0 ad=7.2248p pd=33.72u as=7.2248p ps=33.72u w=16.42u l=4u
X242 rbit1top.t9 b0_b.t2 rbit0top.t4 dvdd.t20 pfet_03v3 ad=17.6p pd=80.88u as=17.6p ps=80.88u w=40u l=0.28u
X243 vgn1.t3 vcasp vx1.t3 avdd.t42 pfet_05v0 ad=7.2248p pd=33.72u as=7.2248p ps=33.72u w=16.42u l=4u
X244 vsua vsua auxsu1 avss nfet_05v0 ad=0.44p pd=2.88u as=0.44p ps=2.88u w=1u l=2u
X245 xf1.t1 v1.t6 vsp.t2 avdd.t16 pfet_05v0 ad=24.1516p pd=0.11066m as=24.1516p ps=0.11066m w=54.89u l=4u
X246 vx3.t7 psrg_m3_feed.t17 avdd.t64 avdd.t63 pfet_05v0 ad=7.37p pd=34.38u as=7.37p ps=34.38u w=16.75u l=2u
X247 psrg_vnc.t2 vbp_i.t52 avdd.t66 avdd.t65 pfet_05v0 ad=7.8056p pd=36.36u as=7.8056p ps=36.36u w=17.74u l=4u
X248 rbit1top.t5 b0_b.t6 rbit0top.t1 dvdd.t7 pfet_03v3 ad=17.6p pd=80.88u as=17.6p ps=80.88u w=40u l=0.28u
X249 vref.t3 vcasp vx3.t5 avdd.t47 pfet_05v0 ad=7.2248p pd=33.72u as=7.2248p ps=33.72u w=16.42u l=4u
X250 psrg_m3_protected.t2 vgn2.t9 v2.t2 avss nfet_05v0 ad=6.424p pd=30.08u as=6.424p ps=30.08u w=14.6u l=4u
X251 rbit2top.t4 b1_b.t3 rbit1top.t3 dvdd.t12 pfet_03v3 ad=17.6p pd=80.88u as=17.6p ps=80.88u w=40u l=0.28u
X252 psrg_vnc.t6 vbp_i.t54 avdd.t205 avdd.t204 pfet_05v0 ad=7.8056p pd=36.36u as=7.8056p ps=36.36u w=17.74u l=4u
X253 vbn_fold.t6 vbp_i.t17 avdd.t90 avdd.t89 pfet_05v0 ad=8.3556p pd=38.86u as=8.3556p ps=38.86u w=18.99u l=8u
X254 vx2.t8 psrg_m3_feed.t15 avdd.t119 avdd.t118 pfet_05v0 ad=7.37p pd=34.38u as=7.37p ps=34.38u w=16.75u l=2u
X255 pm2.t7 y1.t15 avdd.t240 avdd.t239 pfet_05v0 ad=9.1344p pd=42.4u as=9.1344p ps=42.4u w=20.76u l=4u
X256 vbp_cas.t20 vbp_cas.t19 vbp_bias.t27 avdd.t256 pfet_05v0 ad=8.3292p pd=38.74u as=8.3292p ps=38.74u w=18.93u l=8u
X257 vbn_sink.t2 vbp_i.t23 avdd.t104 avdd.t103 pfet_05v0 ad=8.338p pd=38.78u as=8.338p ps=38.78u w=18.95u l=8u
X258 y1.t3 vbp_cas.t30 pm1.t3 avdd.t165 pfet_05v0 ad=9.7724p pd=45.3u as=9.7724p ps=45.3u w=22.21u l=8u
X259 rbit0top.t8 b0.t3 rbit1top.t12 dvss nfet_03v3 ad=17.6p pd=80.88u as=17.6p ps=80.88u w=40u l=0.28u
X260 vgn1.t0 vcasp vx1.t5 avdd.t48 pfet_05v0 ad=7.2248p pd=33.72u as=7.2248p ps=33.72u w=16.42u l=4u
R0 vref.n6 vref.n5 54.8555
R1 vref vref.n14 53.933
R2 vref.n11 vref.t12 34.6185
R3 vref.n13 vref.t11 34.6113
R4 vref.n9 vref.t13 34.6062
R5 vref.n0 vref.t14 26.519
R6 vref.n6 vref.n0 25.385
R7 vref.n1 vref.t0 18.6289
R8 vref.n5 vref.n4 18.4955
R9 vref.n8 vref.n7 17.2532
R10 vref.n3 vref.t2 15.7039
R11 vref.n1 vref.t3 13.8139
R12 vref.n2 vref.n1 10.4855
R13 vref.n5 vref.t5 10.0775
R14 vref.n2 vref.t1 9.27598
R15 vref.n4 vref.t4 9.27277
R16 vref.n0 vref.t15 9.22104
R17 vref.n7 vref.t10 9.22104
R18 vref.n8 vref.t9 9.22104
R19 vref.n10 vref.t8 9.22104
R20 vref.n12 vref.t7 9.22104
R21 vref.n14 vref.t6 9.22104
R22 vref.n4 vref.n3 9.1355
R23 vref.n9 vref.n8 9.08246
R24 vref.n11 vref.n10 9.01336
R25 vref.n13 vref.n12 8.98764
R26 vref.n14 vref.n13 8.303
R27 vref.n7 vref.n6 8.2805
R28 vref.n12 vref.n11 8.24996
R29 vref.n10 vref.n9 8.20496
R30 vref.n3 vref.n2 4.6355
R31 b1.n1 b1.t0 553.995
R32 b1.n0 b1.t2 52.3518
R33 b1.n0 b1.t1 34.9128
R34 b1 b1.n1 34.0655
R35 b1.n1 b1.n0 8.7305
R36 b2.n0 b2.t2 299.99
R37 b2.n1 b2.t0 44.8554
R38 b2.n0 b2.t1 30.7964
R39 b2 b2.n1 27.8105
R40 b2.n1 b2.n0 23.4005
R41 b6 b6.n1 46.0805
R42 b6.n1 b6.t0 44.9115
R43 b6.n0 b6.t2 44.5322
R44 b6.n0 b6.t1 42.8627
R45 b6.n1 b6.n0 11.8355
R46 b5.n0 b5.t1 63.7544
R47 b5.n0 b5.t2 49.1564
R48 b5.n1 b5.t0 45.1489
R49 b5 b5.n1 37.0805
R50 b5.n1 b5.n0 6.2105
R51 b0.n0 b0.t3 557.883
R52 b0.n0 b0.t2 547.923
R53 b0.n1 b0.t1 44.9587
R54 b0 b0.n2 44.2355
R55 b0.n2 b0.t0 37.0514
R56 b0.n1 b0.n0 19.4405
R57 b0.n2 b0.n1 8.9555
R58 b4.n0 b4.t2 109.124
R59 b4.n1 b4.t0 49.3969
R60 b4 b4.n1 41.0855
R61 b4.n0 b4.t1 35.1074
R62 b4.n1 b4.n0 25.2455
R63 b3.n0 b3.t2 178.858
R64 b3.n1 b3.t0 44.8894
R65 b3 b3.n1 38.0705
R66 b3.n0 b3.t1 37.0593
R67 b3.n1 b3.n0 17.2355
R68 avdd.n56 avdd.t36 770.683
R69 avdd.n160 avdd.t247 648.068
R70 avdd.n163 avdd.t260 648.035
R71 avdd.n158 avdd.t17 582.449
R72 avdd.n166 avdd.t1 577.782
R73 avdd.n49 avdd.t32 243.499
R74 avdd.n293 avdd.t257 202.047
R75 avdd.n159 avdd.t259 200.303
R76 avdd.n325 avdd.t34 197.447
R77 avdd.n126 avdd.t200 139.305
R78 avdd.n127 avdd.t87 139.125
R79 avdd.n178 avdd.t202 134.719
R80 avdd.n105 avdd.t132 131.555
R81 avdd.n287 avdd.t3 131.519
R82 avdd.n106 avdd.t176 131.492
R83 avdd.n122 avdd.t114 130.624
R84 avdd.n185 avdd.t101 130.395
R85 avdd.n123 avdd.t59 129.543
R86 avdd.n363 avdd.t112 128.993
R87 avdd.n367 avdd.t192 128.993
R88 avdd.n372 avdd.t194 128.993
R89 avdd.n360 avdd.t157 128.993
R90 avdd.n356 avdd.t19 128.993
R91 avdd.n351 avdd.t7 128.993
R92 avdd.n364 avdd.t110 128.962
R93 avdd.n97 avdd.t243 128.962
R94 avdd.n358 avdd.t155 128.962
R95 avdd.n353 avdd.t212 128.962
R96 avdd.n231 avdd.t198 128.25
R97 avdd.n46 avdd.t182 128.185
R98 avdd.n131 avdd.t246 128.081
R99 avdd.n154 avdd.t189 128.081
R100 avdd.n152 avdd.t125 128.081
R101 avdd.n228 avdd.t245 128.043
R102 avdd.n226 avdd.t175 128.043
R103 avdd.n155 avdd.t256 128.02
R104 avdd.n153 avdd.t188 128.02
R105 avdd.n217 avdd.t233 128.012
R106 avdd.n146 avdd.t141 128.012
R107 avdd.n138 avdd.t159 128.012
R108 avdd.n252 avdd.t168 128.005
R109 avdd.n256 avdd.t83 128.005
R110 avdd.n244 avdd.t147 127.98
R111 avdd.n240 avdd.t221 127.98
R112 avdd.n133 avdd.t103 127.98
R113 avdd.n136 avdd.t143 127.98
R114 avdd.n253 avdd.t170 127.974
R115 avdd.n117 avdd.t85 127.974
R116 avdd.n243 avdd.t219 127.942
R117 avdd.n86 avdd.t128 127.885
R118 avdd.n122 avdd.t91 127.785
R119 avdd.n176 avdd.t55 127.785
R120 avdd.n180 avdd.t57 127.727
R121 avdd.n171 avdd.t107 127.727
R122 avdd.n376 avdd.t190 127.188
R123 avdd.n87 avdd.t126 127.169
R124 avdd.n10 avdd.t208 127.151
R125 avdd.n2 avdd.t206 127.151
R126 avdd.n381 avdd.t227 127.118
R127 avdd.n93 avdd.t145 127.102
R128 avdd.n88 avdd.t225 127.102
R129 avdd.n227 avdd.t223 123.581
R130 avdd.n225 avdd.t134 123.581
R131 avdd.n151 avdd.t224 123.52
R132 avdd.n119 avdd.t161 123.48
R133 avdd.n249 avdd.t235 123.474
R134 avdd.n232 avdd.t196 123.442
R135 avdd.n169 avdd.t105 123.285
R136 avdd.n168 avdd.t89 123.227
R137 avdd.n384 avdd.t80 122.688
R138 avdd.n111 avdd.t93 121.54
R139 avdd.n267 avdd.t172 114.653
R140 avdd.n279 avdd.t22 114.159
R141 avdd.n113 avdd.t95 114.159
R142 avdd.n115 avdd.t166 114.147
R143 avdd.n109 avdd.t23 114.127
R144 avdd.n114 avdd.t21 114.127
R145 avdd.n266 avdd.t173 114.088
R146 avdd.n264 avdd.t165 114.088
R147 avdd.n277 avdd.t167 114.088
R148 avdd.n265 avdd.t174 109.647
R149 avdd.n111 avdd.t94 109.627
R150 avdd.n247 avdd.t53 92.712
R151 avdd.n318 avdd.t49 91.1774
R152 avdd.n312 avdd.t51 91.1774
R153 avdd.n399 avdd.t44 91.1774
R154 avdd.n424 avdd.t39 91.1774
R155 avdd.n429 avdd.t42 91.1297
R156 avdd.n425 avdd.t40 91.1297
R157 avdd.n62 avdd.t38 91.1297
R158 avdd.n317 avdd.t48 91.1225
R159 avdd.n319 avdd.t50 91.1225
R160 avdd.n51 avdd.t153 89.0865
R161 avdd.n394 avdd.t46 86.6774
R162 avdd.n60 avdd.t41 86.6774
R163 avdd.n29 avdd.t67 86.6575
R164 avdd.n274 avdd.t251 86.644
R165 avdd.n272 avdd.t9 86.644
R166 avdd.n58 avdd.t47 86.6261
R167 avdd.n397 avdd.t45 86.6261
R168 avdd.n391 avdd.t43 86.6261
R169 avdd.n323 avdd.t52 86.6225
R170 avdd.n273 avdd.t253 86.6125
R171 avdd.n430 avdd.t204 86.5945
R172 avdd.n53 avdd.t96 85.7565
R173 avdd.n57 avdd.t65 82.144
R174 avdd.n270 avdd.t11 82.1125
R175 avdd.n307 avdd.t180 80.126
R176 avdd.n329 avdd.t231 79.5545
R177 avdd.n349 avdd.t130 78.7294
R178 avdd.n296 avdd.t217 78.7114
R179 avdd.n297 avdd.t135 78.7024
R180 avdd.n298 avdd.t137 78.6817
R181 avdd.n103 avdd.t214 78.6784
R182 avdd.n102 avdd.t139 78.6732
R183 avdd.n308 avdd.t239 78.146
R184 avdd.n330 avdd.t229 78.146
R185 avdd.n301 avdd.t186 78.1168
R186 avdd.n344 avdd.t249 78.1168
R187 avdd.n307 avdd.t237 78.1145
R188 avdd.n304 avdd.t178 78.0547
R189 avdd.n345 avdd.t210 78.0547
R190 avdd.n341 avdd.t163 73.6168
R191 avdd.n331 avdd.t241 73.6145
R192 avdd.n342 avdd.t69 73.5547
R193 avdd.n409 avdd.t28 65.028
R194 avdd.n408 avdd.t63 65.028
R195 avdd.n407 avdd.t61 65.028
R196 avdd.n389 avdd.t116 64.9641
R197 avdd.n82 avdd.t78 64.9641
R198 avdd.n388 avdd.t76 64.9641
R199 avdd.n81 avdd.t122 64.9641
R200 avdd.n314 avdd.t120 64.9641
R201 avdd.n315 avdd.t13 64.9641
R202 avdd.n420 avdd.t71 64.9569
R203 avdd.n419 avdd.t73 64.9569
R204 avdd.n64 avdd.t24 64.9569
R205 avdd.n416 avdd.t149 62.8419
R206 avdd.n402 avdd.t118 60.528
R207 avdd.n75 avdd.t30 60.528
R208 avdd.n410 avdd.t151 60.528
R209 avdd.n416 avdd.t26 60.4569
R210 avdd.n63 avdd.t98 60.4569
R211 avdd avdd.n50 54.7205
R212 avdd.n198 avdd.t109 45.3505
R213 avdd.n202 avdd.t54 45.3505
R214 avdd.n196 avdd.t15 45.3505
R215 avdd.n207 avdd.t0 45.3505
R216 avdd.n209 avdd.t255 45.3505
R217 avdd.n213 avdd.t82 45.3505
R218 avdd.n201 avdd.t16 45.3082
R219 avdd.n203 avdd.t216 45.3082
R220 avdd.n208 avdd.t124 45.3082
R221 avdd.n194 avdd.t100 45.3082
R222 avdd.n120 avdd.t75 39.2557
R223 avdd.n214 avdd.t184 31.9694
R224 avdd.n214 avdd.t5 30.7859
R225 avdd.n241 avdd.t148 25.7055
R226 avdd.n374 avdd.t193 25.6402
R227 avdd.n164 avdd.t261 22.6651
R228 avdd.n55 avdd.t37 22.4086
R229 avdd.n159 avdd.t248 22.3548
R230 avdd.n89 avdd.t129 21.5447
R231 avdd.n235 avdd.t222 21.2055
R232 avdd.n254 avdd.t169 21.2055
R233 avdd.n365 avdd.t113 21.1402
R234 avdd.n305 avdd.t187 20.5222
R235 avdd.n76 avdd.t14 20.0217
R236 avdd.n8 avdd.n78 19.5755
R237 avdd.n248 avdd.n247 19.3505
R238 avdd.n439 avdd.n6 18.4955
R239 avdd.n49 avdd.t33 18.4294
R240 avdd.n215 avdd.n214 17.9443
R241 avdd.n125 avdd.t115 16.8673
R242 avdd.n303 avdd.t158 16.5502
R243 avdd.n416 avdd.n415 16.4705
R244 avdd.n380 avdd.t228 16.3562
R245 avdd.n135 avdd.t142 16.3005
R246 avdd.n228 avdd.n227 16.2905
R247 avdd.n352 avdd.t8 16.2802
R248 avdd.n357 avdd.t20 16.2802
R249 avdd.n137 avdd.t144 16.2763
R250 avdd.n101 avdd.t213 16.2583
R251 avdd.n224 avdd.t236 16.0722
R252 avdd.n116 avdd.t84 15.8505
R253 avdd.n6 avdd.t252 15.8393
R254 avdd.n324 avdd.t35 15.8275
R255 avdd.n278 avdd.n277 15.3005
R256 avdd.n78 avdd.n77 15.1756
R257 avdd.n405 avdd.t119 14.3056
R258 avdd.n65 avdd.t99 14.2617
R259 avdd.n108 avdd.t4 14.212
R260 avdd.n41 avdd.t207 14.0162
R261 avdd.n39 avdd.t209 14.0027
R262 avdd.n8 avdd.t79 13.9467
R263 avdd.n45 avdd.t203 13.9423
R264 avdd.n43 avdd.t60 13.9423
R265 avdd.n335 avdd.t164 13.9072
R266 avdd.n34 avdd.t31 13.9006
R267 avdd.n44 avdd.t201 13.893
R268 avdd.n33 avdd.t162 13.8913
R269 avdd.n374 avdd.t244 13.8733
R270 avdd.n37 avdd.t136 13.8579
R271 avdd.n310 avdd.t240 13.8558
R272 avdd.n328 avdd.t230 13.8558
R273 avdd.n74 avdd.t29 13.8556
R274 avdd.n414 avdd.t152 13.8556
R275 avdd.n283 avdd.t177 13.848
R276 avdd.n35 avdd.t218 13.8399
R277 avdd.n66 avdd.t72 13.8117
R278 avdd.n42 avdd.t117 13.8117
R279 avdd.n69 avdd.t150 13.8117
R280 avdd.n96 avdd.t195 13.8052
R281 avdd.n38 avdd.t138 13.8022
R282 avdd.n83 avdd.t81 13.8005
R283 avdd.n186 avdd.t102 13.7999
R284 avdd.n6 avdd.t254 13.7976
R285 avdd.n48 avdd.t205 13.7976
R286 avdd.n336 avdd.t179 13.7941
R287 avdd.n378 avdd.t191 13.787
R288 avdd.n24 avdd.t215 13.7819
R289 avdd.n262 avdd.t183 13.7805
R290 avdd.n220 avdd.t234 13.7805
R291 avdd.n236 avdd.t199 13.7805
R292 avdd.n30 avdd.t66 13.7693
R293 avdd.n438 avdd.t10 13.7693
R294 avdd.n327 avdd.t232 13.7604
R295 avdd.n128 avdd.t88 13.758
R296 avdd.n148 avdd.t104 13.7563
R297 avdd.n216 avdd.t185 13.7345
R298 avdd.n304 avdd.n303 13.7255
R299 avdd.n7 avdd.t131 13.7229
R300 avdd.n215 avdd.t6 13.6082
R301 avdd.n158 avdd.t18 13.4369
R302 avdd.n165 avdd.t2 13.435
R303 avdd.n173 avdd.t90 13.03
R304 avdd.n350 avdd.n7 12.3755
R305 avdd.n333 avdd.n332 12.1055
R306 avdd.n375 avdd.n374 11.9705
R307 avdd.n182 avdd.n175 11.9705
R308 avdd.n230 avdd.n116 11.8805
R309 avdd.n169 avdd.n168 11.8805
R310 avdd.n387 avdd.n41 11.7905
R311 avdd.n383 avdd.n39 11.6105
R312 avdd.n219 avdd.n46 11.6105
R313 avdd.n309 avdd.t181 11.3808
R314 avdd.n242 avdd.n241 11.335
R315 avdd.n292 avdd.t258 11.2672
R316 avdd.n306 avdd.n305 11.0705
R317 avdd.n328 avdd.n327 10.9805
R318 avdd.n77 avdd.n76 10.7105
R319 avdd.n426 avdd.n425 10.6205
R320 avdd.n414 avdd.n413 10.4405
R321 avdd.n161 avdd.n160 9.8105
R322 avdd.n50 avdd.t154 9.50051
R323 avdd.n54 avdd.t97 9.50051
R324 avdd.n248 avdd.n225 9.4955
R325 avdd.n91 avdd.t146 9.45774
R326 avdd.n182 avdd.t56 9.43487
R327 avdd.n365 avdd.t111 9.41833
R328 avdd.n284 avdd.t133 9.38192
R329 avdd.n404 avdd.t62 9.3556
R330 avdd.n403 avdd.t64 9.3556
R331 avdd.n183 avdd.t58 9.33997
R332 avdd.n175 avdd.t108 9.33997
R333 avdd.n67 avdd.t74 9.31173
R334 avdd.n72 avdd.t25 9.31173
R335 avdd.n76 avdd.t121 9.31173
R336 avdd.n77 avdd.t123 9.31173
R337 avdd.n68 avdd.t27 9.31173
R338 avdd.n173 avdd.t106 9.29987
R339 avdd.n437 avdd.t12 9.29763
R340 avdd.n433 avdd.t68 9.29763
R341 avdd.n305 avdd.t211 9.2941
R342 avdd.n334 avdd.t70 9.2941
R343 avdd.n89 avdd.t127 9.29299
R344 avdd.n90 avdd.t226 9.28695
R345 avdd.n100 avdd.t156 9.28333
R346 avdd.n139 avdd.t160 9.28054
R347 avdd.n306 avdd.t250 9.27224
R348 avdd.n309 avdd.t238 9.26035
R349 avdd.n311 avdd.t242 9.26035
R350 avdd.n124 avdd.t92 9.25804
R351 avdd.n254 avdd.t171 9.23217
R352 avdd.n261 avdd.t86 9.23217
R353 avdd.n294 avdd.t140 9.16723
R354 avdd.n24 avdd.n293 9.0455
R355 avdd.n198 avdd.n103 8.5505
R356 avdd.n283 avdd.n282 8.0105
R357 avdd.n236 avdd.n235 7.4705
R358 avdd.n180 avdd.n178 7.4705
R359 avdd.n410 avdd.n42 7.4255
R360 avdd.n265 avdd.n264 7.3805
R361 avdd.n133 avdd.n130 7.3805
R362 avdd.n226 avdd.n225 7.3805
R363 avdd.n139 avdd.n33 7.2905
R364 avdd.n266 avdd.n265 7.2005
R365 avdd.n152 avdd.n151 7.2005
R366 avdd.n227 avdd.n226 7.2005
R367 avdd.n217 avdd.n119 7.1105
R368 avdd.n140 avdd.n139 7.0205
R369 avdd.n285 avdd.n283 6.9755
R370 avdd.n359 avdd.n100 6.9755
R371 avdd.n38 avdd.n294 6.9305
R372 avdd.n294 avdd.n7 6.9305
R373 avdd.n261 avdd.n260 6.8405
R374 avdd.n124 avdd.n123 6.8405
R375 avdd.n255 avdd.n254 6.8405
R376 avdd.n234 avdd.n233 6.83504
R377 avdd.n366 avdd.n365 6.7955
R378 avdd.n438 avdd.n437 6.7055
R379 avdd.n73 avdd.n72 6.6155
R380 avdd.n182 avdd.n181 6.6155
R381 avdd.n92 avdd.n91 6.6155
R382 avdd.n311 avdd.n310 6.5705
R383 avdd.n63 avdd.n62 6.5255
R384 avdd.n328 avdd.n311 6.4355
R385 avdd.n429 avdd.n60 6.3905
R386 avdd.n394 avdd.n393 6.3905
R387 avdd.n335 avdd.n334 6.3905
R388 avdd.n310 avdd.n309 6.3905
R389 avdd.n331 avdd.n330 6.3005
R390 avdd.n384 avdd.n383 6.3005
R391 avdd.n399 avdd.n391 6.2105
R392 avdd.n397 avdd.n396 6.2105
R393 avdd.n67 avdd.n66 6.1655
R394 avdd.n432 avdd.n58 6.1655
R395 avdd.n403 avdd.n74 6.1655
R396 avdd.n402 avdd.n401 6.1655
R397 avdd.n333 avdd.n306 6.1205
R398 avdd.n286 avdd.n285 6.0755
R399 avdd.n69 avdd.n68 6.0755
R400 avdd.n168 avdd.n167 5.97949
R401 avdd.n284 avdd.n108 5.93792
R402 avdd.n411 avdd.n410 5.8955
R403 avdd.n233 avdd.n231 5.8505
R404 avdd.n407 avdd.n402 5.8505
R405 avdd.n409 avdd.n75 5.8505
R406 avdd.n72 avdd.n71 5.8055
R407 avdd.n51 avdd.n50 5.7155
R408 avdd.n165 avdd.n164 5.7155
R409 avdd.n131 avdd.n130 5.7155
R410 avdd.n326 avdd.n323 5.6705
R411 avdd.n56 avdd.n55 5.5805
R412 avdd.n405 avdd.n404 5.4905
R413 avdd.n292 avdd.n291 5.4455
R414 avdd.n334 avdd.n333 5.3555
R415 avdd.n112 avdd.n111 5.24672
R416 avdd.n174 avdd.n172 5.22849
R417 avdd.n151 avdd.n150 5.21723
R418 avdd.n18 avdd.n433 5.0855
R419 avdd.n341 avdd.n340 5.0405
R420 avdd.n323 avdd.n322 4.9505
R421 avdd.n417 avdd.n416 4.9505
R422 avdd.n412 avdd.n75 4.8605
R423 avdd.n303 avdd.n100 4.8605
R424 avdd.n439 avdd.n56 4.8155
R425 avdd.n185 avdd.n184 4.8155
R426 avdd.n78 avdd.t77 4.81173
R427 avdd.n401 avdd.n391 4.7705
R428 avdd.n271 avdd.n270 4.7705
R429 avdd.n241 avdd.t220 4.74502
R430 avdd.n234 avdd.t197 4.74502
R431 avdd.n32 avdd.n261 4.6355
R432 avdd.n421 avdd.n63 4.5905
R433 avdd.n440 avdd.n54 4.5905
R434 avdd.n343 avdd.n342 4.5905
R435 avdd.n71 avdd.n68 4.5905
R436 avdd.n426 avdd.n60 4.5005
R437 avdd.n398 avdd.n397 4.5005
R438 avdd.n396 avdd.n394 4.5005
R439 avdd.n393 avdd.n58 4.5005
R440 avdd.n433 avdd.n432 4.5005
R441 avdd.n434 avdd.n57 4.5005
R442 avdd.n437 avdd.n436 4.5005
R443 avdd.n235 avdd.n234 4.5005
R444 avdd.n232 avdd.n230 4.5005
R445 avdd.n250 avdd.n249 4.5005
R446 avdd.n162 avdd.n158 4.5005
R447 avdd.n166 avdd.n165 4.5005
R448 avdd.n170 avdd.n169 4.5005
R449 avdd.n332 avdd.n331 4.5005
R450 avdd.n385 avdd.n384 4.5005
R451 avdd.n125 avdd.n124 4.5005
R452 avdd.n178 avdd.n177 4.5005
R453 avdd.n141 avdd.n119 4.5005
R454 avdd avdd.n442 4.3285
R455 avdd.n440 avdd.n439 3.8705
R456 avdd.n207 avdd.n196 3.6005
R457 avdd.n249 avdd.n248 3.5555
R458 avdd.n49 avdd.n155 3.5105
R459 avdd.n246 avdd.n228 3.23972
R460 avdd.n153 avdd.n152 2.8805
R461 avdd.n155 avdd.n154 2.8805
R462 avdd.n90 avdd.n89 2.8805
R463 avdd.n217 avdd.n216 2.8805
R464 avdd.n193 avdd.n192 2.81079
R465 avdd.n277 avdd.n115 2.7905
R466 avdd.n183 avdd.n182 2.7905
R467 avdd.n91 avdd.n90 2.7905
R468 avdd.n43 avdd.n125 2.7905
R469 avdd.n264 avdd.n115 2.7005
R470 avdd.n240 avdd.n230 2.7005
R471 avdd.n244 avdd.n243 2.7005
R472 avdd.n256 avdd.n117 2.7005
R473 avdd.n253 avdd.n252 2.7005
R474 avdd.n154 avdd.n153 2.7005
R475 avdd.n114 avdd.n113 2.7005
R476 avdd.n367 avdd.n97 2.7005
R477 avdd.n364 avdd.n363 2.7005
R478 avdd.n262 avdd.n32 2.6105
R479 avdd.n430 avdd.n48 2.5655
R480 avdd.n171 avdd.n170 2.5205
R481 avdd.n279 avdd.n114 2.5205
R482 avdd.n372 avdd.n97 2.5205
R483 avdd.n93 avdd.n88 2.5205
R484 avdd.n88 avdd.n87 2.5205
R485 avdd.n220 avdd.n219 2.5205
R486 avdd.n163 avdd.n162 2.4305
R487 avdd.n329 avdd.n328 2.4305
R488 avdd.n279 avdd.n278 2.4305
R489 avdd.n148 avdd.n147 2.3855
R490 avdd.n386 avdd.n385 2.3855
R491 avdd.n373 avdd.n372 2.3405
R492 avdd.n184 avdd.n183 2.2505
R493 avdd.n276 avdd.n268 2.16964
R494 avdd.n296 avdd.n103 2.1605
R495 avdd.n298 avdd.n297 2.1605
R496 avdd.n298 avdd.n102 2.1605
R497 avdd.n349 avdd.n102 2.1605
R498 avdd.n106 avdd.n105 2.1605
R499 avdd.n377 avdd.n376 2.1605
R500 avdd.n35 avdd.n24 2.08831
R501 avdd.n29 avdd.n18 2.0705
R502 avdd.n6 avdd.n438 2.0705
R503 avdd.n37 avdd.n36 0.525448
R504 avdd.n297 avdd.n296 1.9805
R505 avdd.n336 avdd.n335 1.9805
R506 avdd.n332 avdd.n308 1.9805
R507 avdd.n276 avdd.n275 1.9285
R508 avdd.n436 avdd.n30 1.8905
R509 avdd.n184 avdd.n130 1.8905
R510 avdd.n202 avdd.n201 1.8905
R511 avdd.n317 avdd.n315 1.8905
R512 avdd.n37 avdd.n35 1.8905
R513 avdd.n376 avdd.n375 1.8905
R514 avdd.n351 avdd.n350 1.8905
R515 avdd.n174 avdd.n173 1.8905
R516 avdd.n377 avdd.n39 1.8455
R517 avdd.n41 avdd.n386 1.8455
R518 avdd.n425 avdd.n424 1.8005
R519 avdd.n399 avdd.n398 1.8005
R520 avdd.n270 avdd.n57 1.8005
R521 avdd.n274 avdd.n273 1.8005
R522 avdd.n213 avdd.n194 1.8005
R523 avdd.n209 avdd.n208 1.8005
R524 avdd.n203 avdd.n196 1.8005
R525 avdd.n342 avdd.n341 1.8005
R526 avdd.n345 avdd.n301 1.8005
R527 avdd.n308 avdd.n307 1.8005
R528 avdd.n319 avdd.n318 1.8005
R529 avdd.n127 avdd.n45 1.8005
R530 avdd.n413 avdd.n412 1.7555
R531 avdd.n374 avdd.n373 1.7555
R532 avdd.n273 avdd.n272 1.7105
R533 avdd.n242 avdd.n240 1.7105
R534 avdd.n256 avdd.n255 1.7105
R535 avdd.n252 avdd.n224 1.7105
R536 avdd.n138 avdd.n137 1.7105
R537 avdd.n136 avdd.n135 1.7105
R538 avdd.n147 avdd.n146 1.7105
R539 avdd.n181 avdd.n180 1.7105
R540 avdd.n344 avdd.n343 1.7105
R541 avdd.n345 avdd.n344 1.7105
R542 avdd.n367 avdd.n366 1.7105
R543 avdd.n92 avdd.n10 1.7105
R544 avdd.n353 avdd.n352 1.7105
R545 avdd.n356 avdd.n101 1.7105
R546 avdd.n358 avdd.n357 1.7105
R547 avdd.n360 avdd.n359 1.7105
R548 avdd.n380 avdd.n2 1.7105
R549 avdd.n326 avdd.n325 1.7105
R550 avdd.n126 avdd.n43 1.7105
R551 avdd.n141 avdd.n140 1.7105
R552 avdd.n8 avdd.n79 1.6655
R553 avdd.n404 avdd.n403 1.6655
R554 avdd.n13 avdd.n49 1.6485
R555 avdd.n72 avdd.n67 1.6205
R556 avdd.n424 avdd.n62 1.6205
R557 avdd.n434 avdd.n29 1.6205
R558 avdd.n214 avdd.n213 1.6205
R559 avdd.n209 avdd.n194 1.6205
R560 avdd.n208 avdd.n207 1.6205
R561 avdd.n203 avdd.n202 1.6205
R562 avdd.n319 avdd.n312 1.6205
R563 avdd.n318 avdd.n317 1.6205
R564 avdd.n215 avdd.n118 1.5535
R565 avdd.n272 avdd.n271 1.5305
R566 avdd.n53 avdd.n50 1.5305
R567 avdd.n177 avdd.n44 1.5305
R568 avdd.n48 avdd.n429 1.4855
R569 avdd.n192 avdd.n191 1.46907
R570 avdd.n237 avdd.n236 1.4415
R571 avdd.n219 avdd.n33 1.4405
R572 avdd.n291 avdd.n105 1.3955
R573 avdd.n36 avdd.n38 0.618683
R574 avdd.n337 avdd.n336 1.3775
R575 avdd.n251 avdd.n250 1.3655
R576 avdd.n180 avdd.n179 1.3655
R577 avdd.n170 avdd.n121 1.3655
R578 avdd.n4 avdd.n381 1.3655
R579 avdd.n419 avdd.n64 1.3505
R580 avdd.n420 avdd.n419 1.3505
R581 avdd.n201 avdd.n200 1.3505
R582 avdd.n340 avdd.n304 1.3505
R583 avdd.n327 avdd.n326 1.3505
R584 avdd.n315 avdd.n314 1.3505
R585 avdd.n314 avdd.n81 1.3505
R586 avdd.n388 avdd.n81 1.3505
R587 avdd.n408 avdd.n407 1.3505
R588 avdd.n409 avdd.n408 1.3505
R589 avdd.n287 avdd.n286 1.3505
R590 avdd.n260 avdd.n46 1.3505
R591 avdd.n407 avdd.n406 1.3295
R592 avdd.n401 avdd.n400 1.3175
R593 avdd.n327 avdd.n22 1.3175
R594 avdd.n18 avdd.n30 1.3055
R595 avdd.n1 avdd.n8 0.429826
R596 avdd.n277 avdd.n276 1.3015
R597 avdd.n65 avdd.n21 1.2975
R598 avdd.n436 avdd.n9 1.2975
R599 avdd.n25 avdd.n409 1.2855
R600 avdd.n222 avdd.n33 1.2825
R601 avdd.n142 avdd.n141 1.2815
R602 avdd.n143 avdd.n138 1.2815
R603 avdd.n144 avdd.n136 1.2815
R604 avdd.n146 avdd.n145 1.2815
R605 avdd.n160 avdd.n157 1.2775
R606 avdd.n70 avdd.n69 1.2695
R607 avdd.n322 avdd.n312 1.2605
R608 avdd.n324 avdd.n22 1.24379
R609 avdd.n32 avdd.n31 1.2375
R610 avdd.n1 avdd.n0 0.39598
R611 avdd.n370 avdd.n96 1.2215
R612 avdd.n267 avdd.n266 1.2207
R613 avdd.n442 avdd.n51 1.2175
R614 avdd.n149 avdd.n148 1.2175
R615 avdd.n339 avdd.n338 1.2175
R616 avdd.n84 avdd.n83 1.2175
R617 avdd.n379 avdd.n378 1.2175
R618 avdd.n348 avdd.n7 1.2155
R619 avdd.n17 avdd.n414 1.2055
R620 avdd.n1 avdd.n42 0.421088
R621 avdd.n192 avdd.n120 1.1855
R622 avdd.n5 avdd.n43 1.1825
R623 avdd.n24 avdd.n23 1.17792
R624 avdd.n431 avdd.n430 1.1735
R625 avdd.n421 avdd.n420 1.1705
R626 avdd.n415 avdd.n74 1.1705
R627 avdd.n48 avdd.n47 1.1705
R628 avdd.n46 avdd.n259 1.1705
R629 avdd.n41 avdd.n40 1.1705
R630 avdd.n39 avdd.n382 1.1705
R631 avdd.n295 avdd.n35 1.1705
R632 avdd.n20 avdd.n18 1.1705
R633 avdd.n29 avdd.n19 1.1705
R634 avdd.n288 avdd.n287 1.1575
R635 avdd.n55 avdd.n52 1.1535
R636 avdd.n188 avdd.n128 1.13808
R637 avdd.n189 avdd.n45 1.1375
R638 avdd.n190 avdd.n44 1.1375
R639 avdd.n441 avdd.n440 1.1255
R640 avdd.n429 avdd.n428 1.1255
R641 avdd.n422 avdd.n62 1.1255
R642 avdd.n424 avdd.n423 1.1255
R643 avdd.n425 avdd.n61 1.1255
R644 avdd.n427 avdd.n426 1.1255
R645 avdd.n21 avdd.n421 1.1255
R646 avdd.n419 avdd.n418 1.1255
R647 avdd.n14 avdd.n417 1.1255
R648 avdd.n71 avdd.n70 1.1255
R649 avdd.n432 avdd.n20 1.1255
R650 avdd.n400 avdd.n399 1.1255
R651 avdd.n398 avdd.n392 1.1255
R652 avdd.n396 avdd.n395 1.1255
R653 avdd.n393 avdd.n59 1.1255
R654 avdd.n435 avdd.n434 1.1255
R655 avdd.n271 avdd.n9 1.1255
R656 avdd.n273 avdd.n269 1.1255
R657 avdd.n275 avdd.n274 1.1255
R658 avdd.n263 avdd.n262 1.1255
R659 avdd.n238 avdd.n230 1.1255
R660 avdd.n240 avdd.n239 1.1255
R661 avdd.n243 avdd.n229 1.1255
R662 avdd.n245 avdd.n244 1.1255
R663 avdd.n237 avdd.n231 1.1255
R664 avdd.n258 avdd.n117 1.1255
R665 avdd.n257 avdd.n256 1.1255
R666 avdd.n253 avdd.n223 1.1255
R667 avdd.n252 avdd.n251 1.1255
R668 avdd.n221 avdd.n220 1.1255
R669 avdd.n163 avdd.n156 1.1255
R670 avdd.n162 avdd.n157 1.1255
R671 avdd.n162 avdd.n161 1.1255
R672 avdd.n179 avdd.n176 1.1255
R673 avdd.n134 avdd.n132 1.1255
R674 avdd.n214 avdd.n193 1.1255
R675 avdd.n213 avdd.n212 1.1255
R676 avdd.n211 avdd.n194 1.1255
R677 avdd.n210 avdd.n209 1.1255
R678 avdd.n208 avdd.n195 1.1255
R679 avdd.n207 avdd.n206 1.1255
R680 avdd.n205 avdd.n196 1.1255
R681 avdd.n204 avdd.n203 1.1255
R682 avdd.n202 avdd.n197 1.1255
R683 avdd.n200 avdd.n199 1.1255
R684 avdd.n104 avdd.n103 1.1255
R685 avdd.n296 avdd.n28 1.1255
R686 avdd.n297 avdd.n27 1.1255
R687 avdd.n299 avdd.n298 1.1255
R688 avdd.n300 avdd.n102 1.1255
R689 avdd.n349 avdd.n16 1.1255
R690 avdd.n337 avdd.n304 1.1255
R691 avdd.n346 avdd.n345 1.1255
R692 avdd.n347 avdd.n301 1.1255
R693 avdd.n343 avdd.n302 1.1255
R694 avdd.n340 avdd.n339 1.1255
R695 avdd.n322 avdd.n22 1.1255
R696 avdd.n321 avdd.n312 1.1255
R697 avdd.n320 avdd.n319 1.1255
R698 avdd.n318 avdd.n313 1.1255
R699 avdd.n317 avdd.n316 1.1255
R700 avdd.n314 avdd.n80 1.1255
R701 avdd.n26 avdd.n388 1.1255
R702 avdd.n411 avdd.n25 1.1255
R703 avdd.n34 avdd.n17 1.1255
R704 avdd.n406 avdd.n405 1.1255
R705 avdd.n390 avdd.n389 1.1255
R706 avdd.n385 avdd.n3 1.1255
R707 avdd.n4 avdd.n2 1.1255
R708 avdd.n88 avdd.n85 1.1255
R709 avdd.n376 avdd.n11 1.1255
R710 avdd.n12 avdd.n10 1.1255
R711 avdd.n94 avdd.n93 1.1255
R712 avdd.n374 avdd.n95 1.1255
R713 avdd.n361 avdd.n360 1.1255
R714 avdd.n358 avdd.n99 1.1255
R715 avdd.n356 avdd.n355 1.1255
R716 avdd.n354 avdd.n353 1.1255
R717 avdd.n351 avdd.n15 1.1255
R718 avdd.n369 avdd.n97 1.1255
R719 avdd.n368 avdd.n367 1.1255
R720 avdd.n364 avdd.n98 1.1255
R721 avdd.n363 avdd.n362 1.1255
R722 avdd.n372 avdd.n371 1.1255
R723 avdd.n291 avdd.n290 1.1255
R724 avdd.n107 avdd.n106 1.1255
R725 avdd.n289 avdd.n105 1.1255
R726 avdd.n282 avdd.n281 1.1255
R727 avdd.n280 avdd.n279 1.1255
R728 avdd.n114 avdd.n110 1.1255
R729 avdd.n187 avdd.n186 1.1255
R730 avdd.n218 avdd.n217 1.1255
R731 avdd.n247 avdd.n246 1.1255
R732 avdd.n216 avdd.n215 1.11425
R733 avdd.n140 avdd.n138 0.9905
R734 avdd.n146 avdd.n135 0.9905
R735 avdd.n373 avdd.n96 0.9905
R736 avdd.n352 avdd.n351 0.9905
R737 avdd.n357 avdd.n356 0.9905
R738 avdd.n383 avdd.n2 0.9905
R739 avdd.n389 avdd.n79 0.9905
R740 avdd.n175 avdd.n174 0.9905
R741 avdd.n66 avdd.n65 0.9455
R742 avdd.n339 avdd.n335 0.9455
R743 avdd.n177 avdd.n45 0.9455
R744 avdd.n44 avdd.n126 0.9455
R745 avdd.n47 avdd.n52 0.9365
R746 avdd.n233 avdd.n232 0.9005
R747 avdd.n387 avdd.n82 0.9005
R748 avdd.n122 avdd.n120 0.9005
R749 avdd.n123 avdd.n122 0.9005
R750 avdd.n243 avdd.n242 0.8105
R751 avdd.n260 avdd.n117 0.8105
R752 avdd.n255 avdd.n253 0.8105
R753 avdd.n250 avdd.n224 0.8105
R754 avdd.n137 avdd.n136 0.8105
R755 avdd.n164 avdd.n163 0.8105
R756 avdd.n181 avdd.n176 0.8105
R757 avdd.n366 avdd.n364 0.8105
R758 avdd.n375 avdd.n10 0.8105
R759 avdd.n93 avdd.n92 0.8105
R760 avdd.n353 avdd.n101 0.8105
R761 avdd.n359 avdd.n358 0.8105
R762 avdd.n381 avdd.n380 0.8105
R763 avdd.n386 avdd.n83 0.8105
R764 avdd.n378 avdd.n377 0.8105
R765 avdd.n128 avdd.n127 0.8105
R766 avdd.n281 avdd.n107 0.791357
R767 avdd.n199 avdd.n104 0.7765
R768 avdd.n32 avdd.n116 0.7655
R769 avdd.n268 avdd.n263 0.7445
R770 avdd.n191 avdd.n5 0.7365
R771 avdd.n150 avdd.n149 0.65143
R772 avdd.n350 avdd.n349 0.6305
R773 avdd.n286 avdd.n105 0.6305
R774 avdd.n150 avdd.n131 0.584461
R775 avdd.n87 avdd.n86 0.584461
R776 avdd.n112 avdd.n110 0.572252
R777 avdd.n246 avdd.n245 0.5685
R778 avdd.n113 avdd.n112 0.547843
R779 avdd.n288 avdd.n108 0.544175
R780 avdd.n330 avdd.n329 0.5405
R781 avdd.n86 avdd.n85 0.53943
R782 avdd.n167 avdd.n166 0.527202
R783 avdd.n268 avdd.n267 0.512058
R784 avdd.n362 avdd.n361 0.4965
R785 avdd.n348 avdd.n347 0.4885
R786 avdd.n290 avdd.n23 0.467611
R787 avdd.n188 avdd.n187 0.467268
R788 avdd.n147 avdd.n134 0.4505
R789 avdd.n388 avdd.n387 0.4505
R790 avdd.n412 avdd.n411 0.4505
R791 avdd.n417 avdd.n73 0.4505
R792 avdd.n186 avdd.n185 0.4505
R793 avdd.n441 avdd.n52 0.4485
R794 avdd.n172 avdd.n171 0.447879
R795 avdd.n73 avdd.n64 0.3605
R796 avdd.n82 avdd.n79 0.3605
R797 avdd.n278 avdd.n109 0.3605
R798 avdd.n282 avdd.n109 0.3605
R799 avdd.n172 avdd.n121 0.359922
R800 avdd.n206 avdd.n205 0.3365
R801 avdd.n167 avdd.n13 0.325735
R802 avdd.n346 avdd.n302 0.3205
R803 avdd.n161 avdd.n159 0.3155
R804 avdd.n293 avdd.n292 0.3155
R805 avdd.n269 avdd.n9 0.3045
R806 avdd.n316 avdd.n80 0.3045
R807 avdd.n199 avdd.n197 0.3045
R808 avdd.n28 avdd.n295 0.2965
R809 avdd.n221 avdd.n218 0.2965
R810 avdd.n16 avdd.n348 0.2805
R811 avdd.n134 avdd.n133 0.2705
R812 avdd.n200 avdd.n198 0.2705
R813 avdd.n325 avdd.n324 0.2705
R814 avdd.n239 avdd.n238 0.2565
R815 avdd.n245 avdd.n229 0.2565
R816 avdd.n258 avdd.n257 0.2565
R817 avdd.n251 avdd.n223 0.2565
R818 avdd.n179 avdd.n121 0.2565
R819 avdd.n143 avdd.n142 0.2565
R820 avdd.n145 avdd.n144 0.2565
R821 avdd.n26 avdd.n80 0.2565
R822 avdd.n369 avdd.n368 0.2565
R823 avdd.n362 avdd.n98 0.2565
R824 avdd.n355 avdd.n99 0.2565
R825 avdd.n354 avdd.n15 0.2565
R826 avdd.n5 avdd.n190 0.2565
R827 avdd.n189 avdd.n188 0.245307
R828 avdd.n239 avdd.n229 0.2405
R829 avdd.n257 avdd.n223 0.2405
R830 avdd.n142 avdd.n118 0.2405
R831 avdd.n144 avdd.n143 0.2405
R832 avdd.n12 avdd.n94 0.2405
R833 avdd.n94 avdd.n85 0.2405
R834 avdd.n371 avdd.n369 0.2405
R835 avdd.n368 avdd.n98 0.2405
R836 avdd.n361 avdd.n99 0.2405
R837 avdd.n355 avdd.n354 0.2405
R838 avdd.n190 avdd.n189 0.2405
R839 avdd.n281 avdd.n280 0.237325
R840 avdd.n95 avdd.n12 0.2325
R841 avdd.n280 avdd.n110 0.231611
R842 avdd.n338 avdd.n302 0.2245
R843 avdd.n20 avdd.n431 0.2205
R844 avdd.n17 avdd.n14 0.2165
R845 avdd.n237 avdd.n31 0.2165
R846 avdd.n259 avdd.n222 0.2165
R847 avdd.n0 avdd.n25 0.2165
R848 avdd.n26 avdd.n40 0.2165
R849 avdd.n3 avdd.n84 0.2165
R850 avdd.n406 avdd.n21 0.2165
R851 avdd.n418 avdd.n14 0.2085
R852 avdd.n238 avdd.n237 0.2085
R853 avdd.n259 avdd.n258 0.2085
R854 avdd.n145 avdd.n129 0.2085
R855 avdd.n16 avdd.n300 0.2085
R856 avdd.n300 avdd.n299 0.2085
R857 avdd.n299 avdd.n27 0.2085
R858 avdd.n28 avdd.n104 0.2085
R859 avdd.n295 avdd.n23 0.2085
R860 avdd.n289 avdd.n107 0.2085
R861 avdd.n187 avdd.n129 0.2045
R862 avdd.n157 avdd.n156 0.2005
R863 avdd.n382 avdd.n4 0.2005
R864 avdd.n379 avdd.n11 0.2005
R865 avdd.n371 avdd.n370 0.2005
R866 avdd.n295 avdd.n36 0.542125
R867 avdd.n5 avdd.n121 0.3445
R868 avdd.n390 avdd.n26 0.2565
R869 avdd.n12 avdd.n11 0.2565
R870 avdd.n4 avdd.n3 0.2565
R871 avdd.n17 avdd.n25 0.2485
R872 avdd.n0 avdd.n390 0.2485
R873 avdd.n16 avdd.n15 0.2405
R874 avdd.n418 avdd.n21 0.234786
R875 avdd.n70 avdd.n14 0.2165
R876 avdd.n28 avdd.n27 0.1925
R877 avdd.n9 avdd.n435 0.1925
R878 avdd.n422 avdd.n21 0.186786
R879 avdd.n191 avdd.n13 0.1845
R880 avdd.n22 avdd.n321 0.1845
R881 avdd.n20 avdd.n59 0.1845
R882 avdd.n415 avdd.n34 0.1805
R883 avdd.n423 avdd.n61 0.1765
R884 avdd.n400 avdd.n392 0.1765
R885 avdd.n395 avdd.n59 0.1765
R886 avdd.n275 avdd.n269 0.1765
R887 avdd.n347 avdd.n346 0.1765
R888 avdd.n320 avdd.n313 0.1765
R889 avdd.n205 avdd.n204 0.1765
R890 avdd.n210 avdd.n195 0.1765
R891 avdd.n212 avdd.n211 0.1765
R892 avdd.n428 avdd.n427 0.170786
R893 avdd.n431 avdd.n47 0.1685
R894 avdd.n442 avdd.n441 0.1605
R895 avdd.n423 avdd.n422 0.1605
R896 avdd.n427 avdd.n61 0.1605
R897 avdd.n395 avdd.n392 0.1605
R898 avdd.n435 avdd.n19 0.1605
R899 avdd.n316 avdd.n313 0.1605
R900 avdd.n321 avdd.n320 0.1605
R901 avdd.n84 avdd.n40 0.1605
R902 avdd.n382 avdd.n379 0.1605
R903 avdd.n370 avdd.n95 0.1605
R904 avdd.n289 avdd.n288 0.1605
R905 avdd.n204 avdd.n197 0.1605
R906 avdd.n206 avdd.n195 0.1605
R907 avdd.n211 avdd.n210 0.1605
R908 avdd.n212 avdd.n193 0.154786
R909 avdd.n20 avdd.n19 0.1525
R910 avdd.n156 avdd.n13 0.1525
R911 avdd.n428 avdd.n47 0.138786
R912 avdd.n132 avdd.n129 0.1365
R913 avdd.n218 avdd.n118 0.1365
R914 avdd.n54 avdd.n53 0.1355
R915 avdd.n413 avdd.n34 0.1355
R916 avdd.n285 avdd.n284 0.1355
R917 avdd.n263 avdd.n31 0.1285
R918 avdd.n222 avdd.n221 0.1285
R919 avdd.n338 avdd.n337 0.1285
R920 avdd.n149 avdd.n132 0.1205
R921 avdd.n290 avdd.n289 0.115611
R922 dvdd.n31 dvdd.t28 109.894
R923 dvdd.n30 dvdd.t18 109.692
R924 dvdd.n10 dvdd.t24 109.422
R925 dvdd.n6 dvdd.t26 109.272
R926 dvdd.n26 dvdd.t16 109.264
R927 dvdd.n12 dvdd.t22 104.746
R928 dvdd.n9 dvdd.t14 100.174
R929 dvdd.n7 dvdd.t21 82.4916
R930 dvdd.n1 dvdd.t6 60.7437
R931 dvdd.n14 dvdd.t9 45.3749
R932 dvdd.n38 dvdd.t8 39.4649
R933 dvdd.n39 dvdd.t4 39.4347
R934 dvdd.n13 dvdd.t5 33.4172
R935 dvdd.n18 dvdd.t10 31.6601
R936 dvdd.n15 dvdd.t13 31.4969
R937 dvdd.n20 dvdd.t20 30.6194
R938 dvdd.n18 dvdd.t12 30.6149
R939 dvdd.n17 dvdd.t1 30.6059
R940 dvdd.n21 dvdd.t0 30.578
R941 dvdd.n19 dvdd.t11 30.5714
R942 dvdd.n16 dvdd.t3 30.5689
R943 dvdd.n15 dvdd.t7 30.5667
R944 dvdd.n3 dvdd.t2 30.4271
R945 dvdd.n8 dvdd.n7 24.3348
R946 dvdd.n33 dvdd.n30 19.1255
R947 dvdd.n5 dvdd.n3 15.8855
R948 dvdd.n11 dvdd.t23 15.5386
R949 dvdd.n31 dvdd.t29 15.1483
R950 dvdd.n29 dvdd.t25 15.0481
R951 dvdd.n34 dvdd.t19 15.0481
R952 dvdd.n40 dvdd.n0 14.8505
R953 dvdd.n9 dvdd.n8 14.186
R954 dvdd dvdd.n1 12.4205
R955 dvdd.n7 dvdd.n6 11.5239
R956 dvdd.n5 dvdd.t27 10.5249
R957 dvdd.n8 dvdd.t15 10.5033
R958 dvdd.n27 dvdd.t17 10.4782
R959 dvdd.n33 dvdd.n32 9.8105
R960 dvdd.n0 dvdd.n3 9.37175
R961 dvdd.n35 dvdd.n9 9.288
R962 dvdd.n13 dvdd.n12 6.5255
R963 dvdd.n28 dvdd.n27 6.0305
R964 dvdd.n6 dvdd.n5 5.3555
R965 dvdd.n27 dvdd.n26 5.0405
R966 dvdd.n12 dvdd.n11 4.5005
R967 dvdd.n40 dvdd.n1 4.5005
R968 dvdd.n35 dvdd.n34 2.4755
R969 dvdd.n23 dvdd.n22 1.79223
R970 dvdd.n25 dvdd.n13 1.40779
R971 dvdd.n32 dvdd.n4 1.3015
R972 dvdd.n20 dvdd.n19 1.2605
R973 dvdd.n41 dvdd.n40 1.2375
R974 dvdd.n26 dvdd.n11 1.1705
R975 dvdd.n38 dvdd.n2 1.1255
R976 dvdd.n0 dvdd.n37 1.1255
R977 dvdd.n36 dvdd.n35 1.1255
R978 dvdd.n26 dvdd.n25 1.1255
R979 dvdd.n30 dvdd.n29 1.0805
R980 dvdd.n21 dvdd.n20 1.0805
R981 dvdd.n16 dvdd.n15 1.0805
R982 dvdd.n14 dvdd.n10 0.9905
R983 dvdd.n23 dvdd.n14 0.966612
R984 dvdd.n19 dvdd.n18 0.9005
R985 dvdd.n17 dvdd.n16 0.9005
R986 dvdd.n39 dvdd.n38 0.8105
R987 dvdd.n37 dvdd.n36 0.6965
R988 dvdd.n22 dvdd.n17 0.5855
R989 dvdd dvdd.n41 0.4925
R990 dvdd.n41 dvdd.n2 0.4885
R991 dvdd.n32 dvdd.n31 0.4505
R992 dvdd.n0 dvdd.n39 0.4505
R993 dvdd.n28 dvdd.n10 0.2705
R994 dvdd.n25 dvdd.n24 0.234786
R995 dvdd.n22 dvdd.n21 0.2255
R996 dvdd.n24 dvdd.n4 0.1845
R997 dvdd.n34 dvdd.n33 0.1355
R998 dvdd.n29 dvdd.n28 0.1355
R999 dvdd.n37 dvdd.n2 0.1285
R1000 dvdd.n36 dvdd.n4 0.1205
R1001 dvdd.n24 dvdd.n23 0.103319
R1002 psrg_mf1_protected psrg_mf1_protected.t0 24.2068
R1003 psrg_mf1_protected psrg_mf1_protected.t1 4.75063
R1004 su_state su_state.n0 21.9515
R1005 su_state.n0 su_state.t1 17.9745
R1006 su_state.n0 su_state.t2 16.4814
R1007 su_state su_state.t0 8.9205
R1008 xf1.n0 xf1.t8 42.5749
R1009 xf1.n5 xf1.t6 27.3149
R1010 xf1.n0 xf1.t7 18.355
R1011 xf1.n3 xf1.n2 16.2005
R1012 xf1.n4 xf1.t5 14.035
R1013 xf1.n2 xf1.t11 13.9
R1014 xf1.n1 xf1.t3 13.8599
R1015 xf1.n3 xf1.t4 13.8599
R1016 xf1.n8 xf1.t0 13.6805
R1017 xf1.n7 xf1.t10 13.6805
R1018 xf1.n9 xf1.t9 13.6404
R1019 xf1 xf1.n9 13.0678
R1020 xf1.n6 xf1.n5 12.3305
R1021 xf1.n6 xf1.t2 9.14039
R1022 xf1.n8 xf1.n7 7.7405
R1023 xf1.n7 xf1.n6 6.6605
R1024 xf1 xf1.t1 4.5781
R1025 xf1.n2 xf1.n1 3.0605
R1026 xf1.n4 xf1.n3 2.9705
R1027 xf1.n1 xf1.n0 2.7905
R1028 xf1.n5 xf1.n4 2.7005
R1029 xf1.n9 xf1.n8 1.9805
R1030 vsp.n0 vsp.t8 16.0674
R1031 vsp.n5 vsp.t4 15.7916
R1032 vsp.n13 vsp.n4 14.8955
R1033 vsp.n3 vsp.t14 13.7319
R1034 vsp.n0 vsp.t11 13.7004
R1035 vsp.n2 vsp.t9 13.6959
R1036 vsp.n1 vsp.t10 13.6717
R1037 vsp.n4 vsp.t12 13.6659
R1038 vsp.n12 vsp.t2 13.6535
R1039 vsp.n10 vsp.t13 13.6535
R1040 vsp.n5 vsp.t5 13.6535
R1041 vsp.n7 vsp.t7 13.6535
R1042 vsp.n8 vsp.t0 13.6316
R1043 vsp.n11 vsp.t3 13.6316
R1044 vsp.n9 vsp.t1 13.6316
R1045 vsp.n6 vsp.t15 13.6316
R1046 vsp.n13 vsp.n12 6.5255
R1047 vsp vsp.t6 4.5781
R1048 vsp vsp.n13 4.55402
R1049 vsp.n9 vsp.n8 3.9605
R1050 vsp.n4 vsp.n3 2.5205
R1051 vsp.n2 vsp.n1 2.5205
R1052 vsp.n1 vsp.n0 2.5205
R1053 vsp.n3 vsp.n2 2.3405
R1054 vsp.n10 vsp.n9 2.1605
R1055 vsp.n12 vsp.n11 2.1605
R1056 vsp.n7 vsp.n6 2.1605
R1057 vsp.n11 vsp.n10 1.9805
R1058 vsp.n8 vsp.n7 1.9805
R1059 vsp.n6 vsp.n5 1.9805
R1060 iref_gate.n1 iref_gate.t1 79.3175
R1061 iref_gate.n0 iref_gate.t3 74.4705
R1062 iref_gate.n0 iref_gate.t2 13.8913
R1063 iref_gate iref_gate.n1 9.18991
R1064 iref_gate iref_gate.t0 4.55384
R1065 iref_gate.n1 iref_gate.n0 1.0805
R1066 xf2.n6 xf2.t9 37.1877
R1067 xf2.n1 xf2.t4 24.115
R1068 xf2.n4 xf2.n3 20.3855
R1069 xf2 xf2.n9 17.6529
R1070 xf2.n9 xf2.n8 16.8305
R1071 xf2.n0 xf2.t7 16.8299
R1072 xf2.n0 xf2.t6 14.035
R1073 xf2.n3 xf2.t11 13.9
R1074 xf2.n8 xf2.n7 11.2505
R1075 xf2.n4 xf2.t8 9.6749
R1076 xf2.n2 xf2.t10 9.3599
R1077 xf2.n8 xf2.t0 9.18048
R1078 xf2.n5 xf2.t2 9.18048
R1079 xf2.n9 xf2.t1 9.18048
R1080 xf2.n7 xf2.t5 9.14039
R1081 xf2.n1 xf2.n0 8.7305
R1082 xf2.n3 xf2.n2 7.5605
R1083 xf2.n5 xf2.n4 5.9405
R1084 xf2 xf2.t3 4.5781
R1085 xf2.n7 xf2.n6 3.0155
R1086 xf2.n6 xf2.n5 2.7905
R1087 xf2.n2 xf2.n1 2.7905
R1088 vbn_fold.n6 vbn_fold.t15 66.9311
R1089 vbn_fold.n7 vbn_fold.t14 28.7855
R1090 vbn_fold.n0 vbn_fold.t0 18.9113
R1091 vbn_fold.n0 vbn_fold.t1 14.4891
R1092 vbn_fold.n4 vbn_fold.t2 13.813
R1093 vbn_fold.n2 vbn_fold.t9 13.813
R1094 vbn_fold.n5 vbn_fold.t3 13.7911
R1095 vbn_fold.n1 vbn_fold.t6 13.7911
R1096 vbn_fold.n3 vbn_fold.t10 13.7911
R1097 vbn_fold.n8 vbn_fold.t7 13.7803
R1098 vbn_fold.n10 vbn_fold.t12 13.7803
R1099 vbn_fold.n7 vbn_fold.t11 13.7512
R1100 vbn_fold.n9 vbn_fold.t4 13.7512
R1101 vbn_fold.n11 vbn_fold.t13 13.7512
R1102 vbn_fold.n6 vbn_fold.t8 9.31296
R1103 vbn_fold.n12 vbn_fold.n11 7.4255
R1104 vbn_fold.n6 vbn_fold.n5 7.3805
R1105 vbn_fold.n1 vbn_fold.n0 5.4005
R1106 vbn_fold.n12 vbn_fold.n6 5.3555
R1107 vbn_fold vbn_fold.t5 4.72634
R1108 vbn_fold vbn_fold.n12 4.5545
R1109 vbn_fold.n5 vbn_fold.n4 3.0605
R1110 vbn_fold.n11 vbn_fold.n10 3.0605
R1111 vbn_fold.n9 vbn_fold.n8 3.0605
R1112 vbn_fold.n3 vbn_fold.n2 3.0605
R1113 vbn_fold.n10 vbn_fold.n9 2.8805
R1114 vbn_fold.n8 vbn_fold.n7 2.8805
R1115 vbn_fold.n4 vbn_fold.n3 2.8805
R1116 vbn_fold.n2 vbn_fold.n1 2.8805
R1117 vbp_tail.n1 vbp_tail.n0 69.0755
R1118 vbp_tail.n0 vbp_tail.t6 41.9642
R1119 vbp_tail.n8 vbp_tail.t9 32.3537
R1120 vbp_tail.n9 vbp_tail.t10 32.3447
R1121 vbp_tail.n10 vbp_tail.t11 32.29
R1122 vbp_tail.n11 vbp_tail.t12 32.2887
R1123 vbp_tail.n1 vbp_tail.t8 27.7895
R1124 vbp_tail.n2 vbp_tail.t0 25.2678
R1125 vbp_tail.n3 vbp_tail.t4 24.8343
R1126 vbp_tail.n7 vbp_tail.n6 23.5355
R1127 vbp_tail vbp_tail.t13 23.284
R1128 vbp_tail.n2 vbp_tail.t2 23.1438
R1129 vbp_tail.n0 vbp_tail.t7 17.1211
R1130 vbp_tail.n3 vbp_tail.t5 14.5794
R1131 vbp_tail.n6 vbp_tail.t1 13.9791
R1132 vbp_tail.n4 vbp_tail.t3 13.8954
R1133 vbp_tail vbp_tail.n11 11.4282
R1134 vbp_tail.n7 vbp_tail.n1 6.1205
R1135 vbp_tail.n11 vbp_tail.n10 2.3405
R1136 vbp_tail.n10 vbp_tail.n9 2.3405
R1137 vbp_tail.n9 vbp_tail.n8 2.1605
R1138 vbp_tail.n5 vbp_tail.n2 1.7105
R1139 vbp_tail.n4 vbp_tail.n3 1.6205
R1140 vbp_tail.n6 vbp_tail.n5 1.5305
R1141 vbp_tail.n5 vbp_tail.n4 0.9005
R1142 vbp_tail.n8 vbp_tail.n7 0.7205
R1143 psrg_m3_protected.n0 psrg_m3_protected.t1 15.8499
R1144 psrg_m3_protected.n1 psrg_m3_protected.t2 13.8481
R1145 psrg_m3_protected.n0 psrg_m3_protected.t3 13.8481
R1146 psrg_m3_protected psrg_m3_protected.n1 11.0795
R1147 psrg_m3_protected psrg_m3_protected.t0 4.81592
R1148 psrg_m3_protected.n1 psrg_m3_protected.n0 1.2605
R1149 v2.n4 v2.t6 65.4785
R1150 v2.n3 v2.t5 65.4785
R1151 v2.n2 v2.t4 65.4173
R1152 v2.n1 v2.t3 60.9785
R1153 v2 v2.t7 56.411
R1154 v2.n1 v2.n0 43.4705
R1155 v2.n5 v2.t0 38.5239
R1156 v2.n0 v2.t2 15.9669
R1157 v2.n0 v2.t1 13.9918
R1158 v2.n2 v2.n1 10.4405
R1159 v2.n5 v2.n4 8.4605
R1160 v2.n4 v2.n3 7.7405
R1161 v2 v2.n5 4.568
R1162 v2.n3 v2.n2 1.8005
R1163 v1.n3 v1.t4 65.4785
R1164 v1.n2 v1.t3 65.4785
R1165 v1.n4 v1.t5 65.4173
R1166 v1.n1 v1.t2 60.9173
R1167 v1 v1.t6 56.411
R1168 v1.n1 v1.n0 41.2205
R1169 v1.n5 v1 30.488
R1170 v1.n0 v1.t1 15.9181
R1171 v1.n0 v1.t0 14.0049
R1172 v1 v1.n5 9.1418
R1173 v1.n3 v1.n2 7.7405
R1174 v1.n2 v1.n1 6.3005
R1175 v1.n5 v1.n4 3.8705
R1176 v1.n4 v1.n3 1.9805
R1177 vbn vbn.n2 59.162
R1178 vbn.n0 vbn.t1 22.2684
R1179 vbn.n1 vbn.t4 22.2196
R1180 vbn.n2 vbn.t3 17.9215
R1181 vbn.n0 vbn.t2 15.5707
R1182 vbn.n2 vbn.n1 10.1255
R1183 vbn vbn.t0 4.76719
R1184 vbn.n1 vbn.n0 4.3655
R1185 vbp_bias.n23 vbp_bias.n22 97.3355
R1186 vbp_bias.n6 vbp_bias.t1 26.1327
R1187 vbp_bias.n1 vbp_bias.t25 25.8148
R1188 vbp_bias.n19 vbp_bias.t15 25.6872
R1189 vbp_bias.n15 vbp_bias.t11 25.6575
R1190 vbp_bias.n17 vbp_bias.t13 25.6514
R1191 vbp_bias.n7 vbp_bias.t5 25.32
R1192 vbp_bias.n11 vbp_bias.t7 24.3102
R1193 vbp_bias.n22 vbp_bias.t17 24.1122
R1194 vbp_bias.n6 vbp_bias.t3 23.2167
R1195 vbp_bias.n12 vbp_bias.t9 23.1942
R1196 vbp_bias.n2 vbp_bias.t27 16.8913
R1197 vbp_bias.n13 vbp_bias.t8 15.6757
R1198 vbp_bias.n7 vbp_bias.t6 14.7137
R1199 vbp_bias.n0 vbp_bias.n1 14.1755
R1200 vbp_bias.n10 vbp_bias.t2 13.9342
R1201 vbp_bias.n21 vbp_bias.t18 13.928
R1202 vbp_bias.n18 vbp_bias.t14 13.8407
R1203 vbp_bias.n3 vbp_bias.t21 13.8313
R1204 vbp_bias.n8 vbp_bias.t4 13.8083
R1205 vbp_bias.n20 vbp_bias.t16 13.8047
R1206 vbp_bias.n1 vbp_bias.t23 13.8047
R1207 vbp_bias.n16 vbp_bias.t12 13.8002
R1208 vbp_bias.n14 vbp_bias.t10 13.7948
R1209 vbp_bias.n2 vbp_bias.t22 13.7912
R1210 vbp_bias.n0 vbp_bias.t0 13.7912
R1211 vbp_bias.n4 vbp_bias.t19 12.3647
R1212 vbp_bias.n4 vbp_bias.t20 9.34477
R1213 vbp_bias.n5 vbp_bias.t24 9.33127
R1214 vbp_bias vbp_bias.n23 9.20003
R1215 vbp_bias.n1 vbp_bias.n4 7.5155
R1216 vbp_bias.n23 vbp_bias.n5 7.4705
R1217 vbp_bias.n5 vbp_bias.n0 7.3805
R1218 vbp_bias vbp_bias.t26 4.72664
R1219 vbp_bias.n0 vbp_bias.n3 3.0605
R1220 vbp_bias.n11 vbp_bias.n10 2.9705
R1221 vbp_bias.n3 vbp_bias.n2 2.8805
R1222 vbp_bias.n21 vbp_bias.n20 2.7905
R1223 vbp_bias.n13 vbp_bias.n12 2.4305
R1224 vbp_bias.n9 vbp_bias.n6 2.0705
R1225 vbp_bias.n22 vbp_bias.n21 2.0705
R1226 vbp_bias.n8 vbp_bias.n7 1.9805
R1227 vbp_bias.n19 vbp_bias.n18 1.8905
R1228 vbp_bias.n17 vbp_bias.n16 1.8905
R1229 vbp_bias.n15 vbp_bias.n14 1.8905
R1230 vbp_bias.n10 vbp_bias.n9 1.8905
R1231 vbp_bias.n12 vbp_bias.n11 1.8005
R1232 vbp_bias.n20 vbp_bias.n19 1.1705
R1233 vbp_bias.n18 vbp_bias.n17 0.9905
R1234 vbp_bias.n16 vbp_bias.n15 0.9905
R1235 vbp_bias.n14 vbp_bias.n13 0.9905
R1236 vbp_bias.n9 vbp_bias.n8 0.9005
R1237 vbn_sink.n4 vbn_sink.t27 24.6307
R1238 vbn_sink.n0 vbn_sink.t21 24.6181
R1239 vbn_sink.n16 vbn_sink.t3 22.5236
R1240 vbn_sink.n4 vbn_sink.t28 21.9622
R1241 vbn_sink.n6 vbn_sink.t30 21.9622
R1242 vbn_sink.n29 vbn_sink.t32 21.9622
R1243 vbn_sink.n0 vbn_sink.t22 21.9532
R1244 vbn_sink.n2 vbn_sink.t24 21.9532
R1245 vbn_sink.n5 vbn_sink.t29 21.9307
R1246 vbn_sink.n7 vbn_sink.t31 21.9307
R1247 vbn_sink.n1 vbn_sink.t23 21.9181
R1248 vbn_sink.n3 vbn_sink.t25 21.9181
R1249 vbn_sink.n17 vbn_sink.t5 21.5084
R1250 vbn_sink.n8 vbn_sink.t2 21.2325
R1251 vbn_sink.n12 vbn_sink.t9 16.8101
R1252 vbn_sink.n21 vbn_sink.t20 16.6875
R1253 vbn_sink.n26 vbn_sink.n25 14.1755
R1254 vbn_sink.n18 vbn_sink.t6 13.9332
R1255 vbn_sink.n16 vbn_sink.t4 13.9114
R1256 vbn_sink.n15 vbn_sink.t16 13.8851
R1257 vbn_sink.n12 vbn_sink.t17 13.8075
R1258 vbn_sink.n14 vbn_sink.t15 13.8075
R1259 vbn_sink.n9 vbn_sink.t8 13.8075
R1260 vbn_sink.n11 vbn_sink.t11 13.8075
R1261 vbn_sink.n24 vbn_sink.t1 13.8075
R1262 vbn_sink.n22 vbn_sink.t13 13.8075
R1263 vbn_sink.n10 vbn_sink.t10 13.7644
R1264 vbn_sink.n26 vbn_sink.t19 13.7644
R1265 vbn_sink.n13 vbn_sink.t18 13.7501
R1266 vbn_sink.n23 vbn_sink.t0 13.7337
R1267 vbn_sink.n21 vbn_sink.t12 13.7337
R1268 vbn_sink.n19 vbn_sink.n18 12.9605
R1269 vbn_sink vbn_sink.t26 12.8857
R1270 vbn_sink.n8 vbn_sink.t7 9.26438
R1271 vbn_sink vbn_sink.n30 9.248
R1272 vbn_sink.n20 vbn_sink.t14 9.2337
R1273 vbn_sink.n20 vbn_sink.n19 7.7405
R1274 vbn_sink.n9 vbn_sink.n8 7.5605
R1275 vbn_sink.n30 vbn_sink.n29 4.8605
R1276 vbn_sink.n25 vbn_sink.n20 4.6355
R1277 vbn_sink.n28 vbn_sink.n27 3.1505
R1278 vbn_sink.n24 vbn_sink.n23 3.0605
R1279 vbn_sink.n14 vbn_sink.n13 3.0605
R1280 vbn_sink.n11 vbn_sink.n10 3.0605
R1281 vbn_sink.n22 vbn_sink.n21 3.0605
R1282 vbn_sink.n13 vbn_sink.n12 2.8805
R1283 vbn_sink.n10 vbn_sink.n9 2.8805
R1284 vbn_sink.n7 vbn_sink.n6 2.8805
R1285 vbn_sink.n5 vbn_sink.n4 2.8805
R1286 vbn_sink.n3 vbn_sink.n2 2.8805
R1287 vbn_sink.n1 vbn_sink.n0 2.8805
R1288 vbn_sink.n23 vbn_sink.n22 2.8805
R1289 vbn_sink.n25 vbn_sink.n24 2.7905
R1290 vbn_sink.n15 vbn_sink.n14 2.7905
R1291 vbn_sink.n27 vbn_sink.n11 2.7905
R1292 vbn_sink.n6 vbn_sink.n5 2.7005
R1293 vbn_sink.n2 vbn_sink.n1 2.7005
R1294 vbn_sink.n30 vbn_sink.n3 2.5205
R1295 vbn_sink.n19 vbn_sink.n15 1.9355
R1296 vbn_sink.n17 vbn_sink.n16 1.8905
R1297 vbn_sink.n28 vbn_sink.n7 1.8005
R1298 vbn_sink.n18 vbn_sink.n17 1.1705
R1299 vbn_sink.n29 vbn_sink.n28 0.9005
R1300 vbn_sink.n27 vbn_sink.n26 0.1355
R1301 vbn_i.n5 vbn_i.n4 49.6967
R1302 vbn_i.n3 vbn_i.n1 48.7805
R1303 vbn_i.n0 vbn_i.t7 32.0695
R1304 vbn_i.n1 vbn_i.n0 29.5655
R1305 vbn_i.n6 vbn_i.n5 26.0749
R1306 vbn_i.n2 vbn_i.t1 20.6658
R1307 vbn_i.n1 vbn_i.t10 16.3059
R1308 vbn_i vbn_i.n9 14.87
R1309 vbn_i.n4 vbn_i.t11 14.5102
R1310 vbn_i.n7 vbn_i.t3 13.8322
R1311 vbn_i.n6 vbn_i.t2 13.7921
R1312 vbn_i.n9 vbn_i.t5 13.7921
R1313 vbn_i.n8 vbn_i.t4 13.7921
R1314 vbn_i.n2 vbn_i.t0 13.4854
R1315 vbn_i.n9 vbn_i.n8 11.3405
R1316 vbn_i.n0 vbn_i.t8 10.3992
R1317 vbn_i.n7 vbn_i.n6 8.6405
R1318 vbn_i.n4 vbn_i.n3 7.5605
R1319 vbn_i.n5 vbn_i.t9 5.72603
R1320 vbn_i vbn_i.t6 4.72757
R1321 vbn_i.n3 vbn_i.n2 4.5005
R1322 vbn_i.n8 vbn_i.n7 2.8805
R1323 y1.n13 y1.t6 82.8267
R1324 y1.n16 y1.n10 36.4505
R1325 y1.n0 y1.t12 36.316
R1326 y1.n5 y1.t18 36.2645
R1327 y1.n4 y1.t7 34.3675
R1328 y1.n2 y1.t9 34.3675
R1329 y1.n0 y1.t11 34.3675
R1330 y1.n3 y1.t8 34.336
R1331 y1.n9 y1.t13 34.3349
R1332 y1.n7 y1.t15 34.3349
R1333 y1.n5 y1.t17 34.3349
R1334 y1.n8 y1.t14 34.2845
R1335 y1.n1 y1.t10 29.836
R1336 y1.n6 y1.t16 29.7845
R1337 y1.n11 y1.t5 26.9336
R1338 y1.n14 y1.n13 11.8805
R1339 y1.n12 y1.n11 11.8355
R1340 y1.n12 y1.t4 9.38362
R1341 y1.n11 y1.t3 9.28871
R1342 y1.n13 y1.t1 9.27408
R1343 y1.n14 y1.t2 9.20433
R1344 y1.n2 y1.n1 6.4805
R1345 y1.n7 y1.n6 6.4805
R1346 y1.n1 y1.n0 6.3005
R1347 y1.n6 y1.n5 6.3005
R1348 y1.n15 y1.n12 6.1205
R1349 y1.n15 y1.n14 5.8505
R1350 y1.n10 y1.n4 5.7605
R1351 y1 y1.t0 4.69308
R1352 y1 y1.n16 4.5815
R1353 y1.n16 y1.n15 2.8355
R1354 y1.n4 y1.n3 1.9805
R1355 y1.n9 y1.n8 1.9805
R1356 y1.n3 y1.n2 1.8005
R1357 y1.n8 y1.n7 1.8005
R1358 y1.n10 y1.n9 0.2705
R1359 pm1.n8 pm1.n7 31.9955
R1360 pm1.n5 pm1.t9 28.451
R1361 pm1.n1 pm1.t5 26.8117
R1362 pm1.n4 pm1.t6 20.4924
R1363 pm1.n0 pm1.t1 16.6719
R1364 pm1.n5 pm1.t11 15.851
R1365 pm1.n6 pm1.n5 14.5355
R1366 pm1.n5 pm1.t10 13.9561
R1367 pm1.n0 pm1.t2 13.8821
R1368 pm1.n2 pm1.n1 12.1055
R1369 pm1.n3 pm1.n2 10.3955
R1370 pm1.n7 pm1.t8 9.28735
R1371 pm1.n2 pm1.t4 9.26171
R1372 pm1.n1 pm1.t3 9.23985
R1373 pm1.n4 pm1.t7 9.22476
R1374 pm1.n7 pm1.n6 8.4155
R1375 pm1.n8 pm1.n3 7.2905
R1376 pm1.n6 pm1.n4 6.3905
R1377 pm1.n3 pm1.n0 5.5805
R1378 pm1 pm1.t0 4.69308
R1379 pm1 pm1.n8 4.50934
R1380 vgn2.n7 vgn2.t8 59.0967
R1381 vgn2.n0 vgn2.t10 33.695
R1382 vgn2.n0 vgn2.t9 33.2139
R1383 vgn2.n1 vgn2.t4 20.8087
R1384 vgn2.n1 vgn2.t5 19.102
R1385 vgn2.n2 vgn2.t2 19.031
R1386 vgn2.n5 vgn2.t0 18.3058
R1387 vgn2.n1 vgn2.t6 18.282
R1388 vgn2.n2 vgn2.t1 18.2741
R1389 vgn2.n4 vgn2.t3 18.2377
R1390 vgn2.n7 vgn2.n6 14.7605
R1391 vgn2.n6 vgn2.n5 9.22717
R1392 vgn2.n8 vgn2.t7 9.22128
R1393 vgn2.n8 vgn2.n7 7.3265
R1394 vgn2 vgn2.n8 4.5005
R1395 vgn2.n6 vgn2.n0 2.90717
R1396 vgn2.n3 vgn2.n1 1.78717
R1397 vgn2.n4 vgn2.n3 1.70717
R1398 vgn2.n5 vgn2.n4 0.813833
R1399 vgn2.n3 vgn2.n2 0.813833
R1400 pm2 pm2.n8 45.4055
R1401 pm2.n0 pm2.t3 31.2449
R1402 pm2.n1 pm2.n0 21.1505
R1403 pm2.n4 pm2.t11 19.5811
R1404 pm2.n2 pm2.t2 16.2671
R1405 pm2.n6 pm2.t6 15.4348
R1406 pm2.n2 pm2.n1 15.3905
R1407 pm2.n4 pm2.t10 13.781
R1408 pm2.n8 pm2.t8 13.7248
R1409 pm2.n6 pm2.n5 10.7105
R1410 pm2.n3 pm2.n2 10.6205
R1411 pm2.n5 pm2.t9 9.3211
R1412 pm2.n7 pm2.t7 9.28735
R1413 pm2.n3 pm2.t0 9.20192
R1414 pm2.n7 pm2.n6 8.5505
R1415 pm2 pm2.n3 7.61787
R1416 pm2.n5 pm2.n4 6.7055
R1417 pm2.n8 pm2.n7 6.6605
R1418 pm2.n0 pm2.t5 4.76171
R1419 pm2 pm2.t1 4.74708
R1420 pm2.n1 pm2.t4 4.73985
R1421 vbp_cas.n30 vbp_cas.t0 48.2304
R1422 vbp_cas.n19 vbp_cas.n18 31.2305
R1423 vbp_cas.n10 vbp_cas.t17 30.3349
R1424 vbp_cas.n15 vbp_cas.t13 30.3349
R1425 vbp_cas.n24 vbp_cas.t27 27.5103
R1426 vbp_cas.n0 vbp_cas.t5 25.8619
R1427 vbp_cas.n7 vbp_cas.t19 25.4416
R1428 vbp_cas.n6 vbp_cas.t1 25.2769
R1429 vbp_cas.n1 vbp_cas.t7 25.2454
R1430 vbp_cas.n25 vbp_cas.t29 24.6303
R1431 vbp_cas.n27 vbp_cas.t31 24.6303
R1432 vbp_cas.n23 vbp_cas.t25 24.6303
R1433 vbp_cas.n24 vbp_cas.t28 24.5961
R1434 vbp_cas.n26 vbp_cas.t30 24.5961
R1435 vbp_cas.n28 vbp_cas.t32 24.5961
R1436 vbp_cas.n20 vbp_cas.t22 24.5673
R1437 vbp_cas.n22 vbp_cas.t24 24.5673
R1438 vbp_cas.n17 vbp_cas.t9 23.1349
R1439 vbp_cas.n0 vbp_cas.t3 23.1304
R1440 vbp_cas.n21 vbp_cas.t23 20.1303
R1441 vbp_cas.n19 vbp_cas.t21 20.1303
R1442 vbp_cas.n10 vbp_cas.t15 18.6016
R1443 vbp_cas.n15 vbp_cas.t11 18.6016
R1444 vbp_cas.n3 vbp_cas.n2 16.5605
R1445 vbp_cas vbp_cas.t26 15.5628
R1446 vbp_cas.n29 vbp_cas.n28 15.1655
R1447 vbp_cas.n1 vbp_cas.t8 14.6959
R1448 vbp_cas.n7 vbp_cas.t20 14.6824
R1449 vbp_cas.n14 vbp_cas.t10 13.9393
R1450 vbp_cas.n8 vbp_cas.t18 13.8043
R1451 vbp_cas.n12 vbp_cas.t14 13.8043
R1452 vbp_cas.n3 vbp_cas.t4 13.7959
R1453 vbp_cas.n9 vbp_cas.t16 13.7824
R1454 vbp_cas.n18 vbp_cas.n17 12.2855
R1455 vbp_cas.n5 vbp_cas.t2 9.31777
R1456 vbp_cas.n2 vbp_cas.t6 9.31777
R1457 vbp_cas.n13 vbp_cas.t12 9.28241
R1458 vbp_cas.n13 vbp_cas.n12 7.6055
R1459 vbp_cas.n20 vbp_cas.n19 7.3805
R1460 vbp_cas.n22 vbp_cas.n21 7.3805
R1461 vbp_cas.n14 vbp_cas.n13 7.2905
R1462 vbp_cas.n21 vbp_cas.n20 7.2005
R1463 vbp_cas.n11 vbp_cas.n10 6.8405
R1464 vbp_cas.n5 vbp_cas.n4 6.5255
R1465 vbp_cas.n2 vbp_cas.n1 6.5255
R1466 vbp_cas.n16 vbp_cas.n15 6.3005
R1467 vbp_cas.n6 vbp_cas.n5 5.5805
R1468 vbp_cas.n30 vbp_cas.n29 4.6805
R1469 vbp_cas vbp_cas.n30 4.505
R1470 vbp_cas.n9 vbp_cas.n8 3.0605
R1471 vbp_cas.n28 vbp_cas.n27 2.8805
R1472 vbp_cas.n26 vbp_cas.n25 2.8805
R1473 vbp_cas.n29 vbp_cas.n23 2.7005
R1474 vbp_cas.n23 vbp_cas.n22 2.7005
R1475 vbp_cas.n27 vbp_cas.n26 2.7005
R1476 vbp_cas.n25 vbp_cas.n24 2.7005
R1477 vbp_cas.n4 vbp_cas.n0 2.0705
R1478 vbp_cas.n16 vbp_cas.n14 2.0705
R1479 vbp_cas.n12 vbp_cas.n11 1.9805
R1480 vbp_cas.n8 vbp_cas.n7 1.9805
R1481 vbp_cas.n17 vbp_cas.n16 1.0805
R1482 vbp_cas.n4 vbp_cas.n3 0.9005
R1483 vbp_cas.n11 vbp_cas.n9 0.9005
R1484 vbp_cas.n18 vbp_cas.n6 0.1805
R1485 vaux vaux.n0 72.6164
R1486 vaux.n0 vaux.t1 15.5393
R1487 vaux.n0 vaux.t2 14.1443
R1488 vaux vaux.t0 4.76719
R1489 psrg_vnc.n4 psrg_vnc.n3 83.0705
R1490 psrg_vnc.n2 psrg_vnc.t9 60.8876
R1491 psrg_vnc.n3 psrg_vnc.t11 28.7139
R1492 psrg_vnc.n0 psrg_vnc.t5 24.5053
R1493 psrg_vnc.n2 psrg_vnc.t10 24.1617
R1494 psrg_vnc.n9 psrg_vnc.n1 14.2205
R1495 psrg_vnc.n0 psrg_vnc.t4 14.212
R1496 psrg_vnc.n6 psrg_vnc.t0 13.8246
R1497 psrg_vnc.n7 psrg_vnc.t1 13.7764
R1498 psrg_vnc.n5 psrg_vnc.t8 13.7764
R1499 psrg_vnc.n9 psrg_vnc.n8 11.0255
R1500 psrg_vnc.n8 psrg_vnc.t2 9.32463
R1501 psrg_vnc.n4 psrg_vnc.t7 9.32463
R1502 psrg_vnc.n1 psrg_vnc.t6 9.26409
R1503 psrg_vnc.n1 psrg_vnc.n0 9.1805
R1504 psrg_vnc.n8 psrg_vnc.n7 6.7055
R1505 psrg_vnc.n5 psrg_vnc.n4 6.4805
R1506 psrg_vnc.n3 psrg_vnc.n2 6.3005
R1507 psrg_vnc psrg_vnc.t3 4.74363
R1508 psrg_vnc psrg_vnc.n9 4.53323
R1509 psrg_vnc.n6 psrg_vnc.n5 2.1605
R1510 psrg_vnc.n7 psrg_vnc.n6 1.9805
R1511 vgn1.n4 vgn1.n3 77.1305
R1512 vgn1.n0 vgn1.t9 49.5595
R1513 vgn1.n2 vgn1.t7 30.1539
R1514 vgn1.n3 vgn1.t5 28.6617
R1515 vgn1.n1 vgn1.t6 13.9918
R1516 vgn1.n5 vgn1.t2 13.9078
R1517 vgn1.n4 vgn1.t3 13.8139
R1518 vgn1.n6 vgn1.t4 13.8139
R1519 vgn1.n7 vgn1.t1 13.7792
R1520 vgn1 vgn1.n7 11.0795
R1521 vgn1.n0 vgn1.t8 9.39692
R1522 vgn1.n7 vgn1.n6 6.6605
R1523 vgn1.n1 vgn1.n0 6.3905
R1524 vgn1.n6 vgn1.n5 6.3005
R1525 vgn1 vgn1.t0 4.75991
R1526 vgn1.n5 vgn1.n4 2.0705
R1527 vgn1.n2 vgn1.n1 1.5305
R1528 vgn1.n3 vgn1.n2 0.5405
R1529 vx3.n1 vx3.t6 23.1445
R1530 vx3.n6 vx3.t10 20.0487
R1531 vx3.n0 vx3.t8 19.9587
R1532 vx3.n2 vx3.n1 15.1655
R1533 vx3.n2 vx3.t2 14.1559
R1534 vx3.n4 vx3.n3 13.3655
R1535 vx3.n5 vx3.n4 10.6205
R1536 vx3.n5 vx3.t1 9.3826
R1537 vx3.n4 vx3.t7 9.3826
R1538 vx3.n2 vx3.t4 9.34091
R1539 vx3.n0 vx3.t0 9.33873
R1540 vx3.n3 vx3.t3 9.28037
R1541 vx3.n1 vx3.t5 9.28037
R1542 vx3.n5 vx3.n0 5.0405
R1543 vx3.n6 vx3.n5 4.8605
R1544 vx3 vx3.t9 4.75773
R1545 vx3 vx3.n6 4.5815
R1546 vx3.n3 vx3.n2 2.1605
R1547 vx1.n0 vx1.t8 18.2487
R1548 vx1.n6 vx1.t6 16.0009
R1549 vx1.n2 vx1.t3 15.7563
R1550 vx1.n0 vx1.t0 13.9737
R1551 vx1.n2 vx1.t2 13.8409
R1552 vx1.n7 vx1.t10 13.8387
R1553 vx1.n6 vx1.t5 13.7845
R1554 vx1.n3 vx1.t4 13.7804
R1555 vx1.n4 vx1.n3 11.2055
R1556 vx1.n4 vx1.t7 9.3826
R1557 vx1.n1 vx1.t1 9.3826
R1558 vx1.n1 vx1.n0 9.3155
R1559 vx1.n8 vx1.n5 9.1355
R1560 vx1.n8 vx1.n7 9.0455
R1561 vx1.n5 vx1.n4 8.9105
R1562 vx1.n3 vx1.n2 7.5605
R1563 vx1 vx1.t9 4.75773
R1564 vx1.n5 vx1.n1 4.6355
R1565 vx1 vx1.n8 4.5815
R1566 vx1.n7 vx1.n6 2.8805
R1567 vx2.n0 vx2.t9 23.3787
R1568 vx2.n4 vx2.t2 23.2009
R1569 vx2.n2 vx2.t6 13.9737
R1570 vx2.n3 vx2.t8 13.8826
R1571 vx2.n8 vx2.n0 13.8605
R1572 vx2.n7 vx2.t0 13.8387
R1573 vx2.n1 vx2.t1 13.5063
R1574 vx2.n8 vx2.n7 11.8805
R1575 vx2.n5 vx2.n4 11.2505
R1576 vx2.n6 vx2.n5 9.6305
R1577 vx2.n0 vx2.t10 9.3826
R1578 vx2.n4 vx2.t3 9.34091
R1579 vx2.n5 vx2.t5 9.28446
R1580 vx2.n1 vx2.t4 9.27627
R1581 vx2.n2 vx2.n1 5.7605
R1582 vx2.n3 vx2.n2 4.8155
R1583 vx2 vx2.t7 4.75773
R1584 vx2.n6 vx2.n3 4.6805
R1585 vx2 vx2.n8 4.5815
R1586 vx2.n7 vx2.n6 0.1355
R1587 psrg_m3_feed.n11 psrg_m3_feed.n10 67.6607
R1588 psrg_m3_feed.n12 psrg_m3_feed.n11 51.1655
R1589 psrg_m3_feed.n0 psrg_m3_feed.t9 49.1358
R1590 psrg_m3_feed.n4 psrg_m3_feed.t15 49.0656
R1591 psrg_m3_feed.n0 psrg_m3_feed.t10 47.6958
R1592 psrg_m3_feed.n1 psrg_m3_feed.t11 47.6958
R1593 psrg_m3_feed.n2 psrg_m3_feed.t12 47.6958
R1594 psrg_m3_feed.n3 psrg_m3_feed.t13 47.6958
R1595 psrg_m3_feed.n17 psrg_m3_feed.t23 47.6913
R1596 psrg_m3_feed.n18 psrg_m3_feed.t24 47.6913
R1597 psrg_m3_feed.n19 psrg_m3_feed.t25 47.6913
R1598 psrg_m3_feed.n20 psrg_m3_feed.t26 47.6913
R1599 psrg_m3_feed.n21 psrg_m3_feed.t27 47.6913
R1600 psrg_m3_feed.n22 psrg_m3_feed.t28 47.6913
R1601 psrg_m3_feed.n4 psrg_m3_feed.t16 47.6255
R1602 psrg_m3_feed.n5 psrg_m3_feed.t17 47.6255
R1603 psrg_m3_feed.n6 psrg_m3_feed.t18 47.6255
R1604 psrg_m3_feed.n7 psrg_m3_feed.t19 47.6255
R1605 psrg_m3_feed.n24 psrg_m3_feed.t20 47.6255
R1606 psrg_m3_feed psrg_m3_feed.t14 38.6237
R1607 psrg_m3_feed.n8 psrg_m3_feed.t21 36.8148
R1608 psrg_m3_feed.n8 psrg_m3_feed.t22 35.3747
R1609 psrg_m3_feed.n10 psrg_m3_feed.t7 27.7165
R1610 psrg_m3_feed.n10 psrg_m3_feed.n9 25.5155
R1611 psrg_m3_feed.n15 psrg_m3_feed.n12 21.2855
R1612 psrg_m3_feed.n9 psrg_m3_feed.t6 15.9268
R1613 psrg_m3_feed.n13 psrg_m3_feed.t3 15.7039
R1614 psrg_m3_feed.n9 psrg_m3_feed.t5 14.0319
R1615 psrg_m3_feed.n13 psrg_m3_feed.t4 13.9142
R1616 psrg_m3_feed.n16 psrg_m3_feed.t0 13.8139
R1617 psrg_m3_feed.n14 psrg_m3_feed.t2 13.776
R1618 psrg_m3_feed.n11 psrg_m3_feed.t8 11.7515
R1619 psrg_m3_feed.n15 psrg_m3_feed.n14 11.0255
R1620 psrg_m3_feed.n15 psrg_m3_feed.t1 9.31391
R1621 psrg_m3_feed psrg_m3_feed.n25 9.2525
R1622 psrg_m3_feed.n16 psrg_m3_feed.n15 8.4605
R1623 psrg_m3_feed.n23 psrg_m3_feed.n22 4.8605
R1624 psrg_m3_feed.n25 psrg_m3_feed.n24 4.8605
R1625 psrg_m3_feed.n14 psrg_m3_feed.n13 4.5905
R1626 psrg_m3_feed.n17 psrg_m3_feed.n16 4.4105
R1627 psrg_m3_feed.n12 psrg_m3_feed.n8 3.6005
R1628 psrg_m3_feed.n22 psrg_m3_feed.n21 1.4405
R1629 psrg_m3_feed.n21 psrg_m3_feed.n20 1.4405
R1630 psrg_m3_feed.n20 psrg_m3_feed.n19 1.4405
R1631 psrg_m3_feed.n19 psrg_m3_feed.n18 1.4405
R1632 psrg_m3_feed.n18 psrg_m3_feed.n17 1.4405
R1633 psrg_m3_feed.n7 psrg_m3_feed.n6 1.4405
R1634 psrg_m3_feed.n6 psrg_m3_feed.n5 1.4405
R1635 psrg_m3_feed.n5 psrg_m3_feed.n4 1.4405
R1636 psrg_m3_feed.n3 psrg_m3_feed.n2 1.4405
R1637 psrg_m3_feed.n2 psrg_m3_feed.n1 1.4405
R1638 psrg_m3_feed.n1 psrg_m3_feed.n0 1.4405
R1639 psrg_m3_feed.n23 psrg_m3_feed.n7 1.2605
R1640 psrg_m3_feed.n25 psrg_m3_feed.n3 1.2605
R1641 psrg_m3_feed.n24 psrg_m3_feed.n23 0.1805
R1642 vbp_i.n1 vbp_i.t36 313.836
R1643 vbp_i.n1 vbp_i.t35 312.575
R1644 vbp_i.n31 vbp_i.n30 42.6605
R1645 vbp_i.n36 vbp_i.t53 31.74
R1646 vbp_i.n31 vbp_i.t48 31.5915
R1647 vbp_i.n33 vbp_i.t50 31.5915
R1648 vbp_i.n37 vbp_i.t52 31.5915
R1649 vbp_i.n32 vbp_i.t49 31.56
R1650 vbp_i.n38 vbp_i.t51 31.56
R1651 vbp_i.n35 vbp_i.t54 31.5146
R1652 vbp_i.n34 vbp_i.t56 26.4981
R1653 vbp_i.n7 vbp_i.t17 26.0243
R1654 vbp_i.n25 vbp_i.t43 26.024
R1655 vbp_i.n2 vbp_i.t11 25.9874
R1656 vbp_i.n40 vbp_i.t37 25.953
R1657 vbp_i.n20 vbp_i.t29 25.8017
R1658 vbp_i.n7 vbp_i.t18 23.1758
R1659 vbp_i.n9 vbp_i.t20 23.1758
R1660 vbp_i.n11 vbp_i.t22 23.1758
R1661 vbp_i.n14 vbp_i.t24 23.1643
R1662 vbp_i.n16 vbp_i.t26 23.1643
R1663 vbp_i.n18 vbp_i.t28 23.1643
R1664 vbp_i.n2 vbp_i.t12 23.1623
R1665 vbp_i.n4 vbp_i.t14 23.1623
R1666 vbp_i.n6 vbp_i.t16 23.1623
R1667 vbp_i.n8 vbp_i.t19 23.1443
R1668 vbp_i.n10 vbp_i.t21 23.1443
R1669 vbp_i.n20 vbp_i.t30 23.144
R1670 vbp_i.n22 vbp_i.t32 23.144
R1671 vbp_i.n24 vbp_i.t34 23.144
R1672 vbp_i.n26 vbp_i.t45 23.144
R1673 vbp_i.n28 vbp_i.t47 23.144
R1674 vbp_i.n13 vbp_i.t23 23.1328
R1675 vbp_i.n15 vbp_i.t25 23.1328
R1676 vbp_i.n17 vbp_i.t27 23.1328
R1677 vbp_i.n3 vbp_i.t13 23.1074
R1678 vbp_i.n5 vbp_i.t15 23.1074
R1679 vbp_i.n21 vbp_i.t31 23.1017
R1680 vbp_i.n23 vbp_i.t33 23.1017
R1681 vbp_i.n25 vbp_i.t44 23.0783
R1682 vbp_i.n27 vbp_i.t46 23.0783
R1683 vbp_i.n43 vbp_i.t7 23.073
R1684 vbp_i.n46 vbp_i.t39 23.073
R1685 vbp_i.n47 vbp_i.t5 23.073
R1686 vbp_i.n50 vbp_i.t40 23.073
R1687 vbp_i.n40 vbp_i.t9 23.0415
R1688 vbp_i.n45 vbp_i.t38 23.0415
R1689 vbp_i.n49 vbp_i.t3 23.0415
R1690 vbp_i.n52 vbp_i.t1 23.0415
R1691 vbp_i.n39 vbp_i.n38 17.8205
R1692 vbp_i.n0 vbp_i.t6 16.7621
R1693 vbp_i.n41 vbp_i.t10 16.6222
R1694 vbp_i.n51 vbp_i.t2 15.9472
R1695 vbp_i.n36 vbp_i.n35 14.2655
R1696 vbp_i.n30 vbp_i.t0 14.0219
R1697 vbp_i vbp_i.t41 13.9853
R1698 vbp_i.n0 vbp_i.t4 13.9672
R1699 vbp_i.n41 vbp_i.t8 13.9271
R1700 vbp_i.n34 vbp_i.t55 13.8317
R1701 vbp_i.n39 vbp_i.t42 13.8039
R1702 vbp_i.n19 vbp_i.n18 12.6455
R1703 vbp_i vbp_i.n52 11.7883
R1704 vbp_i.n13 vbp_i.n12 7.4705
R1705 vbp_i.n30 vbp_i.n29 5.7605
R1706 vbp_i.n47 vbp_i.n46 5.5805
R1707 vbp_i.n12 vbp_i.n6 5.4005
R1708 vbp_i.n29 vbp_i.n24 4.8605
R1709 vbp_i.n35 vbp_i.n34 4.1405
R1710 vbp_i.n23 vbp_i.n22 2.8805
R1711 vbp_i.n21 vbp_i.n20 2.8805
R1712 vbp_i.n17 vbp_i.n16 2.8805
R1713 vbp_i.n15 vbp_i.n14 2.8805
R1714 vbp_i.n11 vbp_i.n10 2.8805
R1715 vbp_i.n9 vbp_i.n8 2.8805
R1716 vbp_i.n6 vbp_i.n5 2.8805
R1717 vbp_i.n4 vbp_i.n3 2.8805
R1718 vbp_i.n27 vbp_i.n26 2.8805
R1719 vbp_i.n50 vbp_i.n49 2.7005
R1720 vbp_i.n46 vbp_i.n45 2.7005
R1721 vbp_i.n24 vbp_i.n23 2.7005
R1722 vbp_i.n22 vbp_i.n21 2.7005
R1723 vbp_i.n18 vbp_i.n17 2.7005
R1724 vbp_i.n16 vbp_i.n15 2.7005
R1725 vbp_i.n14 vbp_i.n13 2.7005
R1726 vbp_i.n10 vbp_i.n9 2.7005
R1727 vbp_i.n8 vbp_i.n7 2.7005
R1728 vbp_i.n5 vbp_i.n4 2.7005
R1729 vbp_i.n3 vbp_i.n2 2.7005
R1730 vbp_i.n28 vbp_i.n27 2.7005
R1731 vbp_i.n26 vbp_i.n25 2.7005
R1732 vbp_i.n19 vbp_i.n1 2.1605
R1733 vbp_i.n51 vbp_i.n50 1.9805
R1734 vbp_i.n48 vbp_i.n47 1.9805
R1735 vbp_i.n38 vbp_i.n33 1.9805
R1736 vbp_i.n32 vbp_i.n31 1.9805
R1737 vbp_i.n42 vbp_i.n41 1.8905
R1738 vbp_i.n48 vbp_i.n0 1.8905
R1739 vbp_i.n24 vbp_i.n19 1.8905
R1740 vbp_i.n45 vbp_i.n44 1.8005
R1741 vbp_i.n42 vbp_i.n40 1.8005
R1742 vbp_i.n37 vbp_i.n36 1.8005
R1743 vbp_i.n38 vbp_i.n37 1.8005
R1744 vbp_i.n33 vbp_i.n32 1.8005
R1745 vbp_i.n44 vbp_i.n39 1.6205
R1746 vbp_i.n44 vbp_i.n43 1.0805
R1747 vbp_i.n52 vbp_i.n51 0.9005
R1748 vbp_i.n49 vbp_i.n48 0.9005
R1749 vbp_i.n43 vbp_i.n42 0.9005
R1750 vbp_i.n29 vbp_i.n28 0.6305
R1751 vbp_i.n12 vbp_i.n11 0.1805
R1752 b3_b b3_b.t2 413.057
R1753 b3_b.n0 b3_b.t1 30.5101
R1754 b3_b.n0 b3_b.t0 18.2995
R1755 b3_b b3_b.n0 11.9367
R1756 b1_b.n1 b1_b.t2 552.784
R1757 b1_b.n2 b1_b.t3 552.491
R1758 b1_b b1_b.t4 543.413
R1759 b1_b.n0 b1_b.t0 19.0513
R1760 b1_b.n0 b1_b.t1 17.9371
R1761 b1_b b1_b.n2 9.91021
R1762 b1_b.n1 b1_b.n0 7.6505
R1763 b1_b.n2 b1_b.n1 0.7205
R1764 vq3.n0 vq3 86.063
R1765 vq3.n0 vq3.t0 28.5582
R1766 vq3 vq3.n1 21.2567
R1767 vq3.n1 vq3.n0 14.3555
R1768 vq3.n1 vq3.t2 13.5475
R1769 vq3 vq3.t1 5.63583
R1770 b6_b b6_b.t2 70.8681
R1771 b6_b.n0 b6_b.t0 27.1512
R1772 b6_b.n0 b6_b.t1 24.2956
R1773 b6_b b6_b.n0 8.52575
R1774 b4_b b4_b.t2 217.519
R1775 b4_b.n0 b4_b.t0 38.4035
R1776 b4_b.n0 b4_b.t1 20.5606
R1777 b4_b b4_b.n0 19.2897
R1778 b0_b.n1 b0_b.t2 552.495
R1779 b0_b.n3 b0_b.t4 552.482
R1780 b0_b.n2 b0_b.t3 552.424
R1781 b0_b.n4 b0_b.t5 547.922
R1782 b0_b.n5 b0_b.t6 547.922
R1783 b0_b b0_b.t7 543.413
R1784 b0_b.n0 b0_b.t1 21.7749
R1785 b0_b.n0 b0_b.t0 18.3369
R1786 b0_b b0_b.n5 14.4612
R1787 b0_b.n5 b0_b.n4 10.0805
R1788 b0_b.n1 b0_b.n0 5.8055
R1789 b0_b.n4 b0_b.n3 5.4005
R1790 b0_b.n3 b0_b.n2 1.0805
R1791 b0_b.n2 b0_b.n1 1.0805
R1792 rbit0top.n1 rbit0top.t7 47.8149
R1793 rbit0top.n1 rbit0top.t0 27.35
R1794 rbit0top.n2 rbit0top.n1 24.7955
R1795 rbit0top.n0 rbit0top.t8 14.9729
R1796 rbit0top.n3 rbit0top.t6 13.6904
R1797 rbit0top.n0 rbit0top.t9 13.6898
R1798 rbit0top.n5 rbit0top.t5 13.6634
R1799 rbit0top.n7 rbit0top.t1 13.6544
R1800 rbit0top.n4 rbit0top.t3 13.6145
R1801 rbit0top rbit0top.n7 10.3573
R1802 rbit0top.n6 rbit0top.n0 10.2155
R1803 rbit0top.n2 rbit0top.t4 9.11555
R1804 rbit0top.n3 rbit0top.n2 5.7605
R1805 rbit0top rbit0top.t2 4.60718
R1806 rbit0top.n5 rbit0top.n4 1.2605
R1807 rbit0top.n4 rbit0top.n3 1.0805
R1808 rbit0top.n6 rbit0top.n5 0.8105
R1809 rbit0top.n7 rbit0top.n6 0.2705
R1810 rbit1top.n2 rbit1top.n1 31.9505
R1811 rbit1top.n1 rbit1top.t11 22.274
R1812 rbit1top.n0 rbit1top.t13 14.8598
R1813 rbit1top.n7 rbit1top.t8 13.8254
R1814 rbit1top.n9 rbit1top.t6 13.7984
R1815 rbit1top.n10 rbit1top.t5 13.7894
R1816 rbit1top.n2 rbit1top.t10 13.7888
R1817 rbit1top.n0 rbit1top.t12 13.7579
R1818 rbit1top.n8 rbit1top.t7 13.7495
R1819 rbit1top.n3 rbit1top.t2 13.6949
R1820 rbit1top.n5 rbit1top.t1 13.6724
R1821 rbit1top.n6 rbit1top.t9 13.6155
R1822 rbit1top.n4 rbit1top.t3 13.6152
R1823 rbit1top.n11 rbit1top.n0 10.3055
R1824 rbit1top.n1 rbit1top.t0 10.142
R1825 rbit1top rbit1top.n11 9.00729
R1826 rbit1top rbit1top.t4 4.60718
R1827 rbit1top.n3 rbit1top.n2 1.5305
R1828 rbit1top.n5 rbit1top.n4 1.2605
R1829 rbit1top.n4 rbit1top.n3 1.2605
R1830 rbit1top.n11 rbit1top.n10 1.2155
R1831 rbit1top.n7 rbit1top.n6 1.1705
R1832 rbit1top.n6 rbit1top.n5 1.0805
R1833 rbit1top.n9 rbit1top.n8 1.0805
R1834 rbit1top.n10 rbit1top.n9 0.9005
R1835 rbit1top.n8 rbit1top.n7 0.9005
R1836 rbit2top.n1 rbit2top.n0 34.9521
R1837 rbit2top.n0 rbit2top.t8 25.739
R1838 rbit2top.n4 rbit2top.t2 15.0003
R1839 rbit2top.n5 rbit2top.t0 13.9426
R1840 rbit2top.n4 rbit2top.t1 13.9336
R1841 rbit2top.n6 rbit2top.t9 13.8011
R1842 rbit2top.n3 rbit2top.t4 13.7502
R1843 rbit2top.n2 rbit2top.t5 13.6949
R1844 rbit2top.n7 rbit2top.n6 11.9255
R1845 rbit2top.n6 rbit2top.n5 10.6655
R1846 rbit2top.n0 rbit2top.t6 10.106
R1847 rbit2top rbit2top.n7 9.20075
R1848 rbit2top.n1 rbit2top.t7 9.11557
R1849 rbit2top.n2 rbit2top.n1 5.5805
R1850 rbit2top rbit2top.t3 4.60718
R1851 rbit2top.n3 rbit2top.n2 1.1705
R1852 rbit2top.n7 rbit2top.n3 1.0805
R1853 rbit2top.n5 rbit2top.n4 0.9005
R1854 b2_b.n1 b2_b.t2 291.709
R1855 b2_b.n2 b2_b.t3 291.709
R1856 b2_b b2_b.t4 282.7
R1857 b2_b.n0 b2_b.t1 29.7878
R1858 b2_b.n1 b2_b.n0 29.7455
R1859 b2_b b2_b.n2 9.96125
R1860 b2_b.n0 b2_b.t0 9.37191
R1861 b2_b.n2 b2_b.n1 1.0805
R1862 rbit6top.n2 rbit6top.t2 20.1082
R1863 rbit6top rbit6top.n3 16.4243
R1864 rbit6top.n2 rbit6top.t1 16.2905
R1865 rbit6top.n3 rbit6top.n0 11.8353
R1866 rbit6top.n3 rbit6top.t3 10.197
R1867 rbit6top.n1 rbit6top.n2 9.5405
R1868 rbit6top.n1 rbit6top.t5 9.02203
R1869 rbit6top.n1 rbit6top.n0 4.4644
R1870 rbit6top rbit6top.t0 5.06817
R1871 rbit6top.n0 rbit6top.t4 17.5032
R1872 rbit5top.n2 rbit5top.n1 30.1505
R1873 rbit5top rbit5top.t4 29.4175
R1874 rbit5top.n1 rbit5top.t2 28.961
R1875 rbit5top rbit5top.n2 16.7383
R1876 rbit5top.n2 rbit5top.n0 12.9155
R1877 rbit5top.n0 rbit5top.t0 11.3205
R1878 rbit5top.n0 rbit5top.t3 9.9581
R1879 rbit5top.n1 rbit5top.t1 5.59703
R1880 rbit5top rbit5top.t5 4.78433
R1881 b5_b b5_b.t2 119.752
R1882 b5_b b5_b.n0 34.8211
R1883 b5_b.n0 b5_b.t1 31.9875
R1884 b5_b.n0 b5_b.t0 9.33465
R1885 rbit3top.n0 rbit3top.t1 38.816
R1886 rbit3top.n3 rbit3top.n0 34.9205
R1887 rbit3top.n1 rbit3top.t5 18.735
R1888 rbit3top.n0 rbit3top.t6 15.7715
R1889 rbit3top.n5 rbit3top.n4 15.2105
R1890 rbit3top.n1 rbit3top.t2 13.9653
R1891 rbit3top.n4 rbit3top.t4 13.8076
R1892 rbit3top.n2 rbit3top.t3 13.7986
R1893 rbit3top rbit3top.n5 12.5895
R1894 rbit3top.n5 rbit3top.t7 9.43613
R1895 rbit3top rbit3top.t0 4.64242
R1896 rbit3top.n2 rbit3top.n1 1.0805
R1897 rbit3top.n3 rbit3top.n2 0.9905
R1898 rbit3top.n4 rbit3top.n3 0.1355
R1899 rbit4top.n2 rbit4top.t4 31.76
R1900 rbit4top.n3 rbit4top.n2 20.2505
R1901 rbit4top.n0 rbit4top.t3 17.61
R1902 rbit4top.n1 rbit4top.n0 17.0555
R1903 rbit4top.n0 rbit4top.t2 14.5188
R1904 rbit4top.n1 rbit4top.t5 13.9981
R1905 rbit4top.n3 rbit4top.n1 12.2405
R1906 rbit4top.n2 rbit4top.t0 10.097
R1907 rbit4top rbit4top.t1 4.64242
R1908 rbit4top rbit4top.n3 4.53446
Cconserve0 aux_gate avdd 4.74183e-15
Cconserve1 aux_gate psrg_m3_feed 8.6845e-16
Cconserve2 aux_gate psrg_vnc 8.2529e-16
Cconserve3 aux_gate rb_mid 1.8215e-16
Cconserve4 aux_gate vbn 3.2604e-16
Cconserve5 vbn_fold aux_gate 3.7711e-16
Cconserve6 vbn_i aux_gate 3.67685e-15
Cconserve7 aux_gate vbp_cas 2.1008e-16
Cconserve8 vbp_i aux_gate 2.2855e-16
Cconserve9 vbp_tail aux_gate 1.10491e-15
Cconserve10 vcasp aux_gate 5.46621e-15
Cconserve11 aux_gate vgn1 1.56319e-15
Cconserve12 aux_gate vgn2 1.6589e-16
Cconserve13 vsu aux_gate 1.5823e-16
Cconserve14 auxsu2 auxsu1 2.2066e-16
Cconserve15 auxsu1 avss 8.10797e-15
Cconserve16 vsua auxsu1 2.4101e-16
Cconserve17 avdd avss 3.1976755110477e-12
Cconserve18 avdd.n0 avss 6.7236170705736e-16
Cconserve19 avdd.n2 avss 2.5435630269506e-15
Cconserve20 avdd.n3 avss 3.6540867704284e-16
Cconserve21 avdd.n4 avss 8.9837554457988e-16
Cconserve22 avdd.n5 avss 1.3135748264965e-15
Cconserve23 avdd.n6 avss 2.5929137022136e-16
Cconserve24 avdd.n7 avss 1.0264500525093e-16
Cconserve25 avdd.n8 avss 1.2089422821113e-16
Cconserve26 avdd.n9 avss 8.1855188788658e-16
Cconserve27 avdd.n10 avss 2.5401692842391e-15
Cconserve28 avdd.n11 avss 3.6540867704284e-16
Cconserve29 avdd.n12 avss 7.0973215631334e-16
Cconserve30 avdd.n13 avss 1.573023314436e-15
Cconserve31 avdd.n14 avss 6.5351543676829e-16
Cconserve32 avdd.n15 avss 3.7946285692911e-16
Cconserve33 avdd.n16 avss 6.9567797642708e-16
Cconserve34 avdd.n17 avss 6.2543850053939e-16
Cconserve35 avdd.n18 avss 8.5856977069296e-17
Cconserve36 avdd.n19 avss 3.0919195749779e-16
Cconserve37 avdd.n20 avss 6.113528971095e-16
Cconserve38 avdd.n21 avss 9.7020976530654e-16
Cconserve39 avdd.n22 avss 8.8817074878768e-16
Cconserve40 avdd.n23 avss 6.2865941376095e-16
Cconserve41 avdd.n24 avss 1.4802845813128e-16
Cconserve42 avdd.n25 avss 7.2299289172308e-16
Cconserve43 avdd.n26 avss 6.8162379654082e-16
Cconserve44 avdd.n27 avss 3.0919195749779e-16
Cconserve45 avdd.n28 avss 6.5351543676829e-16
Cconserve46 avdd.n29 avss 1.6462087475385e-15
Cconserve47 avdd.n31 avss 5.219686272683e-16
Cconserve48 avdd.n32 avss 9.6705955505814e-17
Cconserve49 avdd.n33 avss 1.4558527761444e-16
Cconserve50 avdd.n35 avss 9.8654215210561e-17
Cconserve51 avdd.n36 avss 1.8971964463569e-16
Cconserve52 avdd.n37 avss 9.8544232807874e-17
Cconserve53 avdd.n38 avss 1.6826522022575e-16
Cconserve54 avdd.n39 avss 1.3265448941277e-16
Cconserve55 avdd.n40 avss 3.6540867704284e-16
Cconserve56 avdd.n41 avss 1.331965455403e-16
Cconserve57 avdd.n42 avss 1.3280375124499e-16
Cconserve58 avdd.n43 avss 1.0828553133161e-16
Cconserve59 avdd.n45 avss 8.0844921861115e-17
Cconserve60 avdd.n46 avss 2.6167720277108e-15
Cconserve61 avdd.n47 avss 1.1491982697943e-15
Cconserve62 avdd.n48 avss 9.6132475834658e-17
Cconserve63 avdd.n49 avss 5.9762080854539e-16
Cconserve64 avdd.t154 avss 7.5681248054944e-16
Cconserve65 avdd.n50 avss 8.1887397920873e-16
Cconserve66 avdd.t153 avss 6.3592610822422e-16
Cconserve67 avdd.n51 avss 8.7959212137806e-16
Cconserve68 avdd.n52 avss 1.3120664964025e-15
Cconserve69 avdd.t97 avss 7.4972647146201e-16
Cconserve70 avdd.t96 avss 6.0449470871335e-16
Cconserve71 avdd.n53 avss 9.1634981153336e-16
Cconserve72 avdd.t36 avss 4.2543550125242e-16
Cconserve73 avdd.n56 avss 7.8882521561737e-16
Cconserve74 avdd.t252 avss 1.1574705176536e-15
Cconserve75 avdd.t12 avss 1.149143278593e-15
Cconserve76 avdd.t66 avss 1.1520970916937e-15
Cconserve77 avdd.t65 avss 1.3811904364915e-15
Cconserve78 avdd.n57 avss 1.67573902266e-15
Cconserve79 avdd.t68 avss 1.1501016966735e-15
Cconserve80 avdd.t47 avss 1.278678981301e-15
Cconserve81 avdd.n58 avss 1.5951769126916e-15
Cconserve82 avdd.n59 avss 2.6351783683891e-16
Cconserve83 avdd.t205 avss 1.15106797064e-15
Cconserve84 avdd.t42 avss 1.3561458722224e-15
Cconserve85 avdd.t41 avss 1.279684534697e-15
Cconserve86 avdd.n60 avss 1.5925059114834e-15
Cconserve87 avdd.n61 avss 2.9513777761153e-16
Cconserve88 avdd.t40 avss 1.3561458722224e-15
Cconserve89 avdd.t39 avss 1.3570650108734e-15
Cconserve90 avdd.t38 avss 1.3561458722224e-15
Cconserve91 avdd.n62 avss 1.5816569330469e-15
Cconserve92 avdd.t98 avss 9.7019405353473e-16
Cconserve93 avdd.n63 avss 1.1920442715269e-15
Cconserve94 avdd.t73 avss 1.0512353725435e-15
Cconserve95 avdd.t24 avss 1.0512353725435e-15
Cconserve96 avdd.n64 avss 1.1156693487465e-15
Cconserve97 avdd.t99 avss 1.1837563118959e-15
Cconserve98 avdd.n65 avss 8.6273339022327e-17
Cconserve99 avdd.t72 avss 1.1832928146274e-15
Cconserve100 avdd.t74 avss 1.1805982457616e-15
Cconserve101 avdd.t25 avss 1.1805982457616e-15
Cconserve102 avdd.t27 avss 1.1805982457616e-15
Cconserve103 avdd.t150 avss 1.1832928146274e-15
Cconserve104 avdd.n70 avss 4.3842128065544e-16
Cconserve105 avdd.n72 avss 9.73187146065e-17
Cconserve106 avdd.t26 avss 9.7019405353473e-16
Cconserve107 avdd.t149 avss 1.0161588419721e-15
Cconserve108 avdd.t29 avss 1.1837091765804e-15
Cconserve109 avdd.t31 avss 1.183740600124e-15
Cconserve110 avdd.t30 avss 9.7174951894416e-16
Cconserve111 avdd.n75 avss 1.1849504065536e-15
Cconserve112 avdd.t151 avss 9.7174951894416e-16
Cconserve113 avdd.t117 avss 1.1284665868877e-15
Cconserve114 avdd.t79 avss 1.183410652916e-15
Cconserve115 avdd.t121 avss 1.1806375251911e-15
Cconserve116 avdd.t14 avss 1.2016048846748e-15
Cconserve117 avdd.t123 avss 1.1806375251911e-15
Cconserve118 avdd.t77 avss 1.1755469111238e-15
Cconserve119 avdd.n78 avss 7.9462285941617e-17
Cconserve120 avdd.n80 avss 4.9189629601921e-16
Cconserve121 avdd.t122 avss 1.0514003461475e-15
Cconserve122 avdd.n81 avss 1.1314361117603e-15
Cconserve123 avdd.t76 avss 1.0514003461475e-15
Cconserve124 avdd.t78 avss 1.0514003461475e-15
Cconserve125 avdd.n82 avss 1.1085754837731e-15
Cconserve126 avdd.t207 avss 3.3519336867026e-15
Cconserve127 avdd.t81 avss 3.3996267700394e-15
Cconserve128 avdd.n84 avss 5.5109039632273e-16
Cconserve129 avdd.t206 avss 2.3228833359584e-15
Cconserve130 avdd.t209 avss 3.3509595568503e-15
Cconserve131 avdd.t208 avss 2.3228440565288e-15
Cconserve132 avdd.n85 avss 7.8075722079166e-16
Cconserve133 avdd.t126 avss 2.3232368508242e-15
Cconserve134 avdd.t128 avss 2.3377702397507e-15
Cconserve135 avdd.n86 avss 2.8670212732541e-15
Cconserve136 avdd.n87 avss 2.5829602947704e-15
Cconserve137 avdd.t225 avss 2.321822791361e-15
Cconserve138 avdd.n88 avss 2.580305005334e-15
Cconserve139 avdd.t145 avss 2.3217835119315e-15
Cconserve140 avdd.t146 avss 3.3878822206096e-15
Cconserve141 avdd.t129 avss 3.3817467737168e-15
Cconserve142 avdd.t127 avss 3.388180744274e-15
Cconserve143 avdd.n89 avss 1.5677991503083e-16
Cconserve144 avdd.t226 avss 3.3873087409384e-15
Cconserve145 avdd.n90 avss 1.0292781714356e-16
Cconserve146 avdd.n91 avss 1.1710769120432e-16
Cconserve147 avdd.n93 avss 2.5527622693468e-15
Cconserve148 avdd.n94 avss 4.216253965879e-16
Cconserve149 avdd.n95 avss 3.7946285692911e-16
Cconserve150 avdd.t193 avss 2.3279111029384e-15
Cconserve151 avdd.t244 avss 2.2964090004543e-15
Cconserve152 avdd.t195 avss 2.1383878554503e-15
Cconserve153 avdd.t243 avss 2.3111702100722e-15
Cconserve154 avdd.n97 avss 2.6027021360527e-15
Cconserve155 avdd.t194 avss 2.3118772398037e-15
Cconserve156 avdd.n98 avss 4.3567957647416e-16
Cconserve157 avdd.t112 avss 2.3118772398037e-15
Cconserve158 avdd.n99 avss 4.3567957647416e-16
Cconserve159 avdd.t156 avss 2.2934316196959e-15
Cconserve160 avdd.t20 avss 2.3209429321395e-15
Cconserve161 avdd.t213 avss 2.3197959727972e-15
Cconserve162 avdd.n101 avss 1.0383909990868e-16
Cconserve163 avdd.t19 avss 2.3118772398037e-15
Cconserve164 avdd.t8 avss 2.3525157375967e-15
Cconserve165 avdd.t139 avss 2.9905550791297e-15
Cconserve166 avdd.n102 avss 2.7480674488618e-15
Cconserve167 avdd.t130 avss 2.992621177123e-15
Cconserve168 avdd.t214 avss 2.9906650615324e-15
Cconserve169 avdd.n103 avss 2.8494555123677e-15
Cconserve170 avdd.t217 avss 2.991953426821e-15
Cconserve171 avdd.n104 avss 9.3060824445318e-16
Cconserve172 avdd.t132 avss 1.4161805523179e-15
Cconserve173 avdd.n105 avss 1.7426476029235e-15
Cconserve174 avdd.t176 avss 1.4152771254387e-15
Cconserve175 avdd.n106 avss 1.7120096478892e-15
Cconserve176 avdd.n107 avss 9.3450476386268e-16
Cconserve177 avdd.t4 avss 1.5923802173089e-15
Cconserve178 avdd.n108 avss 1.9795261306543e-16
Cconserve179 avdd.t23 avss 2.7312322853647e-15
Cconserve180 avdd.n109 avss 2.8092569441855e-15
Cconserve181 avdd.n110 avss 7.6855702997927e-16
Cconserve182 avdd.t95 avss 2.7321121445862e-15
Cconserve183 avdd.t93 avss 2.9052637258457e-15
Cconserve184 avdd.t94 avss 2.6164342246168e-15
Cconserve185 avdd.n111 avss 5.640966010291e-15
Cconserve186 avdd.n112 avss 3.6429314124416e-16
Cconserve187 avdd.n113 avss 2.8983269785904e-15
Cconserve188 avdd.t21 avss 2.7312322853647e-15
Cconserve189 avdd.n114 avss 2.9006130413892e-15
Cconserve190 avdd.t22 avss 2.7321121445862e-15
Cconserve191 avdd.t166 avss 2.7317193502909e-15
Cconserve192 avdd.n115 avss 2.8818688976169e-15
Cconserve193 avdd.t167 avss 2.7301324613379e-15
Cconserve194 avdd.t84 avss 2.3229461830456e-15
Cconserve195 avdd.n116 avss 1.2052500157353e-16
Cconserve196 avdd.t86 avss 2.3137155171058e-15
Cconserve197 avdd.t85 avss 2.3349656884822e-15
Cconserve198 avdd.n117 avss 2.5933457759384e-15
Cconserve199 avdd.t182 avss 2.3392235786434e-15
Cconserve200 avdd.n118 avss 1.0315406665766e-15
Cconserve201 avdd.t161 avss 2.2434053382449e-15
Cconserve202 avdd.n119 avss 2.661998362873e-15
Cconserve203 avdd.t233 avss 2.3358298359319e-15
Cconserve204 avdd.t185 avss 1.8438549810536e-15
Cconserve205 avdd.t6 avss 1.8444127489529e-15
Cconserve206 avdd.t184 avss 5.6976462271046e-15
Cconserve207 avdd.t75 avss 1.5738481824561e-14
Cconserve208 avdd.n120 avss 1.0779375287388e-15
Cconserve209 avdd.n121 avss 1.1198015447332e-15
Cconserve210 avdd.t115 avss 2.3642445752547e-15
Cconserve211 avdd.t114 avss 2.3955424247052e-15
Cconserve212 avdd.t91 avss 2.3398991848313e-15
Cconserve213 avdd.n122 avss 5.1022957695861e-15
Cconserve214 avdd.t59 avss 2.3743865239597e-15
Cconserve215 avdd.n123 avss 2.5687097177364e-15
Cconserve216 avdd.t92 avss 2.3188454106026e-15
Cconserve217 avdd.n125 avss 1.4391197391641e-16
Cconserve218 avdd.t60 avss 2.3219641973073e-15
Cconserve219 avdd.t200 avss 2.5526051516286e-15
Cconserve220 avdd.n126 avss 2.4325357914377e-15
Cconserve221 avdd.t201 avss 2.3215164118107e-15
Cconserve222 avdd.t87 avss 2.5493371030916e-15
Cconserve223 avdd.n127 avss 2.431758058733e-15
Cconserve224 avdd.t88 avss 2.3214299970657e-15
Cconserve225 avdd.n129 avss 4.8411111308613e-16
Cconserve226 avdd.t56 avss 2.3202594700657e-15
Cconserve227 avdd.t1 avss 4.0951162052048e-16
Cconserve228 avdd.t261 avss 1.0159003833258e-14
Cconserve229 avdd.t33 avss 5.4091702407415e-16
Cconserve230 avdd.t32 avss 1.736150785279e-16
Cconserve231 avdd.t224 avss 2.2398623337012e-15
Cconserve232 avdd.t246 avss 2.3327267609989e-15
Cconserve233 avdd.n131 avss 2.6086647534556e-15
Cconserve234 avdd.n132 avss 2.8108359772527e-16
Cconserve235 avdd.t103 avss 2.3351149503144e-15
Cconserve236 avdd.n133 avss 2.5914682192068e-15
Cconserve237 avdd.t141 avss 2.3358298359319e-15
Cconserve238 avdd.t142 avss 2.3485406593282e-15
Cconserve239 avdd.n135 avss 1.0025681593543e-16
Cconserve240 avdd.t143 avss 2.3351149503144e-15
Cconserve241 avdd.n136 avss 2.5987663372137e-15
Cconserve242 avdd.t144 avss 2.3474015558717e-15
Cconserve243 avdd.n137 avss 9.7287291062876e-17
Cconserve244 avdd.t159 avss 2.3358298359319e-15
Cconserve245 avdd.n138 avss 2.6023250535292e-15
Cconserve246 avdd.t160 avss 2.3159701563609e-15
Cconserve247 avdd.t162 avss 2.3177691542334e-15
Cconserve248 avdd.n139 avss 9.0814041076134e-17
Cconserve249 avdd.n142 avss 7.2389631860229e-16
Cconserve250 avdd.n143 avss 7.2389631860229e-16
Cconserve251 avdd.n144 avss 7.2389631860229e-16
Cconserve252 avdd.n145 avss 6.9579581471567e-16
Cconserve253 avdd.n146 avss 2.6023250535292e-15
Cconserve254 avdd.t104 avss 2.3176748836025e-15
Cconserve255 avdd.n149 avss 9.9430376738098e-16
Cconserve256 avdd.n150 avss 5.0188898289195e-16
Cconserve257 avdd.n151 avss 2.6649993112892e-15
Cconserve258 avdd.t125 avss 2.3327267609989e-15
Cconserve259 avdd.n152 avss 2.6007774440057e-15
Cconserve260 avdd.t188 avss 2.3314462515962e-15
Cconserve261 avdd.n153 avss 2.6009659852675e-15
Cconserve262 avdd.t189 avss 2.3327267609989e-15
Cconserve263 avdd.n154 avss 2.601091679442e-15
Cconserve264 avdd.t256 avss 2.3314462515962e-15
Cconserve265 avdd.n155 avss 2.6138732058114e-15
Cconserve266 avdd.n156 avss 3.1480891592075e-16
Cconserve267 avdd.t260 avss 3.6088368676085e-16
Cconserve268 avdd.n157 avss 5.2745989151676e-16
Cconserve269 avdd.t17 avss 4.1538782317834e-16
Cconserve270 avdd.n158 avss 7.5896499328775e-16
Cconserve271 avdd.t248 avss 2.7394652537945e-15
Cconserve272 avdd.t259 avss 2.2971395978436e-16
Cconserve273 avdd.n159 avss 5.1769502533531e-16
Cconserve274 avdd.t247 avss 3.6093867796219e-16
Cconserve275 avdd.n160 avss 7.2521610743454e-16
Cconserve276 avdd.n162 avss 7.9509421257055e-17
Cconserve277 avdd.n163 avss 7.3409325850859e-16
Cconserve278 avdd.t2 avss 3.0521687922923e-16
Cconserve279 avdd.n166 avss 8.0783645951047e-16
Cconserve280 avdd.n167 avss 9.5095498895035e-17
Cconserve281 avdd.t89 avss 2.2466105396947e-15
Cconserve282 avdd.n168 avss 2.6724859705579e-15
Cconserve283 avdd.t105 avss 2.2478989049833e-15
Cconserve284 avdd.n169 avss 2.670215619531e-15
Cconserve285 avdd.n170 avss 1.0648653345908e-16
Cconserve286 avdd.t107 avss 2.3386029636568e-15
Cconserve287 avdd.n171 avss 2.6071957027911e-15
Cconserve288 avdd.t90 avss 2.3730510233556e-15
Cconserve289 avdd.t106 avss 2.3200866405758e-15
Cconserve290 avdd.n173 avss 1.5388894901733e-16
Cconserve291 avdd.t108 avss 2.320400876012e-15
Cconserve292 avdd.n175 avss 9.7303002834688e-17
Cconserve293 avdd.t55 avss 2.3398599054018e-15
Cconserve294 avdd.n176 avss 2.5555825323871e-15
Cconserve295 avdd.t202 avss 2.4710296323782e-15
Cconserve296 avdd.t203 avss 2.3219641973073e-15
Cconserve297 avdd.n178 avss 2.5478916200849e-15
Cconserve298 avdd.t57 avss 2.3386029636568e-15
Cconserve299 avdd.n179 avss 6.3837714462696e-16
Cconserve300 avdd.n180 avss 2.635107665416e-15
Cconserve301 avdd.n182 avss 1.4750211377556e-16
Cconserve302 avdd.t58 avss 2.320400876012e-15
Cconserve303 avdd.n183 avss 9.1426800176821e-17
Cconserve304 avdd.t101 avss 2.3937748503763e-15
Cconserve305 avdd.n185 avss 2.567240667072e-15
Cconserve306 avdd.t102 avss 2.3228833359584e-15
Cconserve307 avdd.n187 avss 6.56304276265e-16
Cconserve308 avdd.n188 avss 6.8673797826578e-16
Cconserve309 avdd.n189 avss 4.8384401296532e-16
Cconserve310 avdd.n190 avss 4.9140923109303e-16
Cconserve311 avdd.n191 avss 2.183747740673e-15
Cconserve312 avdd.n192 avss 3.9273930411065e-15
Cconserve313 avdd.n193 avss 2.651023690262e-15
Cconserve314 avdd.t82 avss 5.2504106424623e-15
Cconserve315 avdd.t100 avss 5.2474411175898e-15
Cconserve316 avdd.n194 avss 2.9596893034041e-15
Cconserve317 avdd.n195 avss 2.9513777761153e-16
Cconserve318 avdd.t255 avss 5.2504106424623e-15
Cconserve319 avdd.t124 avss 5.2474411175898e-15
Cconserve320 avdd.t0 avss 5.2504106424623e-15
Cconserve321 avdd.t15 avss 5.2504106424623e-15
Cconserve322 avdd.n196 avss 2.9890546049216e-15
Cconserve323 avdd.n197 avss 4.0757121670163e-16
Cconserve324 avdd.t216 avss 5.2474411175898e-15
Cconserve325 avdd.t54 avss 5.2504106424623e-15
Cconserve326 avdd.t109 avss 5.2504106424623e-15
Cconserve327 avdd.n198 avss 3.0242489737816e-15
Cconserve328 avdd.n199 avss 9.5263614853428e-16
Cconserve329 avdd.t16 avss 5.2474411175898e-15
Cconserve330 avdd.n201 avss 2.9347154421082e-15
Cconserve331 avdd.n202 avss 2.9594064915115e-15
Cconserve332 avdd.n203 avss 2.9596893034041e-15
Cconserve333 avdd.n204 avss 2.9513777761153e-16
Cconserve334 avdd.n205 avss 4.4973375636042e-16
Cconserve335 avdd.n206 avss 4.3567957647416e-16
Cconserve336 avdd.n207 avss 2.9862421977672e-15
Cconserve337 avdd.n208 avss 2.9596893034041e-15
Cconserve338 avdd.n209 avss 2.9581338379947e-15
Cconserve339 avdd.n210 avss 2.9513777761153e-16
Cconserve340 avdd.n211 avss 2.9513777761153e-16
Cconserve341 avdd.n212 avss 2.9123340231613e-16
Cconserve342 avdd.n213 avss 2.9581338379947e-15
Cconserve343 avdd.t5 avss 5.6417280312239e-15
Cconserve344 avdd.n214 avss 3.1045518395152e-15
Cconserve345 avdd.n215 avss 3.4553328570006e-16
Cconserve346 avdd.n217 avss 2.616253539241e-15
Cconserve347 avdd.n218 avss 4.3833486591047e-16
Cconserve348 avdd.n219 avss 1.0305351131806e-16
Cconserve349 avdd.t234 avss 2.3188296988308e-15
Cconserve350 avdd.n221 avss 4.1896225126568e-16
Cconserve351 avdd.n222 avss 5.219686272683e-16
Cconserve352 avdd.n223 avss 4.3567957647416e-16
Cconserve353 avdd.t236 avss 2.3737266295436e-15
Cconserve354 avdd.n224 avss 9.3485042284255e-17
Cconserve355 avdd.t168 avss 2.3356884299855e-15
Cconserve356 avdd.t134 avss 2.2412135460771e-15
Cconserve357 avdd.n225 avss 2.6612127742824e-15
Cconserve358 avdd.t53 avss 1.3218549302417e-15
Cconserve359 avdd.t175 avss 2.331964740066e-15
Cconserve360 avdd.n226 avss 2.6058916257307e-15
Cconserve361 avdd.t223 avss 2.2412135460771e-15
Cconserve362 avdd.n227 avss 2.683704175632e-15
Cconserve363 avdd.t245 avss 2.331964740066e-15
Cconserve364 avdd.n228 avss 3.8948775293406e-15
Cconserve365 avdd.n229 avss 4.3567957647416e-16
Cconserve366 avdd.t147 avss 2.3351228062003e-15
Cconserve367 avdd.t219 avss 2.3342665146365e-15
Cconserve368 avdd.t221 avss 2.3351228062003e-15
Cconserve369 avdd.n230 avss 1.2145985199638e-16
Cconserve370 avdd.t198 avss 2.3404333850729e-15
Cconserve371 avdd.n231 avss 2.5564781033804e-15
Cconserve372 avdd.t222 avss 2.3473229970127e-15
Cconserve373 avdd.t197 avss 2.3083263793741e-15
Cconserve374 avdd.t196 avss 2.2425490466812e-15
Cconserve375 avdd.n232 avss 2.6203778793418e-15
Cconserve376 avdd.n235 avss 1.4428905643991e-16
Cconserve377 avdd.t199 avss 2.3176591718307e-15
Cconserve378 avdd.n236 avss 1.3403712533227e-16
Cconserve379 avdd.n237 avss 9.2614610125844e-16
Cconserve380 avdd.n238 avss 4.0757121670163e-16
Cconserve381 avdd.n239 avss 4.3567957647416e-16
Cconserve382 avdd.n240 avss 2.6077534706904e-15
Cconserve383 avdd.t220 avss 2.3083263793741e-15
Cconserve384 avdd.t148 avss 2.3926671704635e-15
Cconserve385 avdd.n241 avss 1.4063606949351e-16
Cconserve386 avdd.n243 avss 2.5929922610726e-15
Cconserve387 avdd.n244 avss 2.5826067799046e-15
Cconserve388 avdd.n245 avss 7.886131066979e-16
Cconserve389 avdd.n246 avss 3.1470521822679e-15
Cconserve390 avdd.n247 avss 1.6048003729267e-15
Cconserve391 avdd.n248 avss 1.4308710589625e-16
Cconserve392 avdd.t235 avss 2.2432560764127e-15
Cconserve393 avdd.n249 avss 2.6625168513428e-15
Cconserve394 avdd.n250 avss 7.9470141827523e-17
Cconserve395 avdd.n251 avss 6.3837714462696e-16
Cconserve396 avdd.n252 avss 2.6082483915025e-15
Cconserve397 avdd.t170 avss 2.3349656884822e-15
Cconserve398 avdd.n253 avss 2.5933457759384e-15
Cconserve399 avdd.t169 avss 2.3471894469523e-15
Cconserve400 avdd.t171 avss 2.3137155171058e-15
Cconserve401 avdd.n254 avss 1.4232508496335e-16
Cconserve402 avdd.t83 avss 2.3356884299855e-15
Cconserve403 avdd.n256 avss 2.6082483915025e-15
Cconserve404 avdd.n257 avss 4.3567957647416e-16
Cconserve405 avdd.n258 avss 4.0757121670163e-16
Cconserve406 avdd.n259 avss 4.0757121670163e-16
Cconserve407 avdd.t183 avss 2.3175884688576e-15
Cconserve408 avdd.n263 avss 8.0047549441632e-16
Cconserve409 avdd.t174 avss 2.6169684248585e-15
Cconserve410 avdd.t165 avss 2.7301324613379e-15
Cconserve411 avdd.n264 avss 2.9116427052015e-15
Cconserve412 avdd.n265 avss 2.96589545327e-15
Cconserve413 avdd.t173 avss 2.7301324613379e-15
Cconserve414 avdd.n266 avss 2.8999688587449e-15
Cconserve415 avdd.t172 avss 2.7442573441973e-15
Cconserve416 avdd.n267 avss 3.0572122710442e-15
Cconserve417 avdd.n268 avss 3.1903773930408e-15
Cconserve418 avdd.n269 avss 4.216253965879e-16
Cconserve419 avdd.t251 avss 1.4668431605272e-15
Cconserve420 avdd.t11 avss 1.3804834067599e-15
Cconserve421 avdd.n270 avss 1.6754169313379e-15
Cconserve422 avdd.t9 avss 1.4668431605272e-15
Cconserve423 avdd.n272 avss 1.6142981389873e-15
Cconserve424 avdd.t253 avss 1.4661282749097e-15
Cconserve425 avdd.n273 avss 1.6398533358403e-15
Cconserve426 avdd.n274 avss 1.6153901071283e-15
Cconserve427 avdd.n275 avss 1.8505874752752e-15
Cconserve428 avdd.n276 avss 4.0650595857275e-15
Cconserve429 avdd.n277 avss 2.9983088385192e-15
Cconserve430 avdd.n278 avss 1.3700665020482e-16
Cconserve431 avdd.n279 avss 2.8968186484965e-15
Cconserve432 avdd.n280 avss 4.9874662852946e-16
Cconserve433 avdd.n281 avss 9.6269168249427e-16
Cconserve434 avdd.n282 avss 1.550987554469e-16
Cconserve435 avdd.t177 avss 1.5863940322484e-15
Cconserve436 avdd.n283 avss 1.624125852256e-16
Cconserve437 avdd.t133 avss 1.571342154852e-15
Cconserve438 avdd.n285 avss 1.0223649918381e-16
Cconserve439 avdd.t3 avss 1.4156542079622e-15
Cconserve440 avdd.n287 avss 1.7009721281909e-15
Cconserve441 avdd.n288 avss 5.9655240806214e-16
Cconserve442 avdd.n289 avss 4.2646462230614e-16
Cconserve443 avdd.n290 avss 5.9623031673999e-16
Cconserve444 avdd.t258 avss 1.9522662065597e-16
Cconserve445 avdd.t257 avss 2.329113053482e-16
Cconserve446 avdd.n293 avss 4.9341248199912e-16
Cconserve447 avdd.t215 avss 2.9797768036663e-15
Cconserve448 avdd.t140 avss 3.0541956108562e-15
Cconserve449 avdd.n294 avss 8.6925377552545e-17
Cconserve450 avdd.t138 avss 3.0566937825743e-15
Cconserve451 avdd.t218 avss 3.0587834482254e-15
Cconserve452 avdd.t136 avss 3.0589405659435e-15
Cconserve453 avdd.n295 avss 9.5683119160821e-16
Cconserve454 avdd.n296 avss 2.7448465356402e-15
Cconserve455 avdd.t135 avss 2.991615623727e-15
Cconserve456 avdd.n297 avss 2.7448936709557e-15
Cconserve457 avdd.t137 avss 2.9907357645055e-15
Cconserve458 avdd.n298 avss 2.7470383278081e-15
Cconserve459 avdd.n299 avss 3.6540867704284e-16
Cconserve460 avdd.n300 avss 3.6540867704284e-16
Cconserve461 avdd.t186 avss 1.7239348826948e-15
Cconserve462 avdd.n301 avss 1.7712194599645e-15
Cconserve463 avdd.n302 avss 4.7783426024704e-16
Cconserve464 avdd.t210 avss 1.7224029849431e-15
Cconserve465 avdd.t69 avss 1.6172205285445e-15
Cconserve466 avdd.t163 avss 1.6188388410411e-15
Cconserve467 avdd.t158 avss 2.3061345872063e-15
Cconserve468 avdd.n303 avss 1.5224706886293e-16
Cconserve469 avdd.t178 avss 1.7224029849431e-15
Cconserve470 avdd.n304 avss 1.8646495110474e-15
Cconserve471 avdd.t164 avss 2.1252528142151e-15
Cconserve472 avdd.t250 avss 2.1222047304835e-15
Cconserve473 avdd.t211 avss 2.1216391066982e-15
Cconserve474 avdd.t187 avss 2.1370209313026e-15
Cconserve475 avdd.n305 avss 9.652527012997e-17
Cconserve476 avdd.t180 avss 1.7681320968033e-15
Cconserve477 avdd.t237 avss 1.7239663062385e-15
Cconserve478 avdd.n307 avss 3.4883668572363e-15
Cconserve479 avdd.t239 avss 1.7248147419163e-15
Cconserve480 avdd.n308 avss 1.779468140166e-15
Cconserve481 avdd.t241 avss 1.6188309851552e-15
Cconserve482 avdd.t230 avss 2.1230453102754e-15
Cconserve483 avdd.t240 avss 2.1230453102754e-15
Cconserve484 avdd.t181 avss 2.128866521732e-15
Cconserve485 avdd.t238 avss 2.1195494410472e-15
Cconserve486 avdd.n309 avss 1.2843587868112e-16
Cconserve487 avdd.t242 avss 2.0668285907304e-15
Cconserve488 avdd.t52 avss 1.2786082783278e-15
Cconserve489 avdd.t51 avss 1.3570335873298e-15
Cconserve490 avdd.n312 avss 1.5576257780597e-15
Cconserve491 avdd.n313 avss 2.9513777761153e-16
Cconserve492 avdd.t50 avss 1.3560044662761e-15
Cconserve493 avdd.t49 avss 1.3570335873298e-15
Cconserve494 avdd.t48 avss 1.3560044662761e-15
Cconserve495 avdd.t120 avss 1.0514003461475e-15
Cconserve496 avdd.n314 avss 1.1531733480629e-15
Cconserve497 avdd.t13 avss 1.0514003461475e-15
Cconserve498 avdd.n315 avss 1.1398183420223e-15
Cconserve499 avdd.n316 avss 4.0757121670163e-16
Cconserve500 avdd.n317 avss 1.5669585705163e-15
Cconserve501 avdd.n318 avss 1.566062999523e-15
Cconserve502 avdd.n319 avss 1.5656859169995e-15
Cconserve503 avdd.n320 avss 2.9513777761153e-16
Cconserve504 avdd.n321 avss 2.5297523795274e-16
Cconserve505 avdd.n323 avss 1.5823325392349e-15
Cconserve506 avdd.t34 avss 2.2307573619359e-16
Cconserve507 avdd.n325 avss 4.5384238468939e-16
Cconserve508 avdd.n326 avss 8.4568611780673e-17
Cconserve509 avdd.t232 avss 2.1438948314706e-15
Cconserve510 avdd.n327 avss 1.1501016966735e-16
Cconserve511 avdd.n328 avss 1.2093350764066e-16
Cconserve512 avdd.t231 avss 1.7555312558097e-15
Cconserve513 avdd.n329 avss 1.7810785967768e-15
Cconserve514 avdd.t229 avss 1.7248147419163e-15
Cconserve515 avdd.n330 avss 1.7701903389108e-15
Cconserve516 avdd.n331 avss 1.8413253857918e-15
Cconserve517 avdd.n333 avss 1.2016363082185e-16
Cconserve518 avdd.t70 avss 2.0688004180929e-15
Cconserve519 avdd.n335 avss 1.1249628617736e-16
Cconserve520 avdd.t179 avss 2.1463223002156e-15
Cconserve521 avdd.n336 avss 1.1072085596255e-16
Cconserve522 avdd.n337 avss 5.7724264050461e-16
Cconserve523 avdd.n338 avss 4.9718330723411e-16
Cconserve524 avdd.n341 avss 1.8520643818256e-15
Cconserve525 avdd.n342 avss 1.8513416403222e-15
Cconserve526 avdd.t249 avss 1.7239348826948e-15
Cconserve527 avdd.n344 avss 1.7729163313202e-15
Cconserve528 avdd.n345 avss 1.796483989039e-15
Cconserve529 avdd.n346 avss 4.3567957647416e-16
Cconserve530 avdd.n347 avss 6.3220241830466e-16
Cconserve531 avdd.t131 avss 2.8752856652274e-15
Cconserve532 avdd.n348 avss 7.3104517477697e-16
Cconserve533 avdd.n349 avss 2.723250705284e-15
Cconserve534 avdd.n350 avss 9.4899101747379e-17
Cconserve535 avdd.t7 avss 2.3118772398037e-15
Cconserve536 avdd.n351 avss 2.5664707902532e-15
Cconserve537 avdd.n352 avss 1.0679291300943e-16
Cconserve538 avdd.t212 avss 2.3111702100722e-15
Cconserve539 avdd.n353 avss 2.5600760991255e-15
Cconserve540 avdd.n354 avss 4.3567957647416e-16
Cconserve541 avdd.n355 avss 4.3567957647416e-16
Cconserve542 avdd.n356 avss 2.5636426713269e-15
Cconserve543 avdd.n357 avss 1.0679291300943e-16
Cconserve544 avdd.t155 avss 2.3111702100722e-15
Cconserve545 avdd.n358 avss 2.5600760991255e-15
Cconserve546 avdd.t157 avss 2.3118772398037e-15
Cconserve547 avdd.n360 avss 2.5498477356756e-15
Cconserve548 avdd.n361 avss 6.464844188822e-16
Cconserve549 avdd.n362 avss 6.6053859876847e-16
Cconserve550 avdd.n363 avss 2.5654495250853e-15
Cconserve551 avdd.t110 avss 2.3111702100722e-15
Cconserve552 avdd.n364 avss 2.5756857444212e-15
Cconserve553 avdd.t111 avss 2.2936123050717e-15
Cconserve554 avdd.t113 avss 2.3115472925957e-15
Cconserve555 avdd.n365 avss 1.6249114408467e-16
Cconserve556 avdd.t192 avss 2.3118772398037e-15
Cconserve557 avdd.n367 avss 2.5906040717571e-15
Cconserve558 avdd.n368 avss 4.3567957647416e-16
Cconserve559 avdd.n369 avss 4.3567957647416e-16
Cconserve560 avdd.n370 avss 5.3650201619484e-16
Cconserve561 avdd.n371 avss 4.216253965879e-16
Cconserve562 avdd.n372 avss 2.5991826991667e-15
Cconserve563 avdd.n373 avss 8.1245572042334e-17
Cconserve564 avdd.n374 avss 2.0138563520646e-16
Cconserve565 avdd.t190 avss 2.3236217892336e-15
Cconserve566 avdd.n376 avss 2.5661329871592e-15
Cconserve567 avdd.t191 avss 3.3687217148843e-15
Cconserve568 avdd.n379 avss 5.3703621643647e-16
Cconserve569 avdd.t227 avss 2.3221370267973e-15
Cconserve570 avdd.t228 avss 3.4154406683687e-15
Cconserve571 avdd.n380 avss 9.8143582626656e-17
Cconserve572 avdd.n381 avss 2.558269245367e-15
Cconserve573 avdd.n382 avss 3.5135449715658e-16
Cconserve574 avdd.t80 avss 2.2327134775266e-15
Cconserve575 avdd.n384 avss 2.6065829436904e-15
Cconserve576 avdd.n386 avss 8.0491406995335e-17
Cconserve577 avdd.n388 avss 1.1387420856531e-15
Cconserve578 avdd.t116 avss 1.0514003461475e-15
Cconserve579 avdd.n389 avss 1.1279952337334e-15
Cconserve580 avdd.n390 avss 3.5135449715658e-16
Cconserve581 avdd.t118 avss 9.7174951894416e-16
Cconserve582 avdd.t43 avss 1.278678981301e-15
Cconserve583 avdd.n391 avss 1.5834009397181e-15
Cconserve584 avdd.n392 avss 2.9513777761153e-16
Cconserve585 avdd.t46 avss 1.2796766788111e-15
Cconserve586 avdd.n394 avss 1.592372361423e-15
Cconserve587 avdd.n395 avss 2.9513777761153e-16
Cconserve588 avdd.t45 avss 1.278678981301e-15
Cconserve589 avdd.n397 avss 1.610975099249e-15
Cconserve590 avdd.t44 avss 1.3570492991016e-15
Cconserve591 avdd.n399 avss 1.5799364940334e-15
Cconserve592 avdd.n400 avss 4.9731685729452e-16
Cconserve593 avdd.n401 avss 9.6595973103126e-17
Cconserve594 avdd.n402 avss 1.1958308085338e-15
Cconserve595 avdd.t61 avss 1.0527672702952e-15
Cconserve596 avdd.t119 avss 1.1923663628491e-15
Cconserve597 avdd.t62 avss 1.1806218134193e-15
Cconserve598 avdd.t64 avss 1.1806218134193e-15
Cconserve599 avdd.n406 avss 6.1935018896205e-16
Cconserve600 avdd.n407 avss 1.2055956747152e-15
Cconserve601 avdd.t63 avss 1.0527672702952e-15
Cconserve602 avdd.n408 avss 1.1322452680086e-15
Cconserve603 avdd.t28 avss 1.0527672702952e-15
Cconserve604 avdd.n409 avss 1.1848247123791e-15
Cconserve605 avdd.n410 avss 1.2169709975074e-15
Cconserve606 avdd.t152 avss 1.1837091765804e-15
Cconserve607 avdd.n415 avss 8.3830158505487e-17
Cconserve608 avdd.n416 avss 2.4270052477597e-15
Cconserve609 avdd.n418 avss 3.3730031727032e-16
Cconserve610 avdd.n419 avss 1.1530555097743e-15
Cconserve611 avdd.t71 avss 1.0512353725435e-15
Cconserve612 avdd.n420 avss 1.128529433975e-15
Cconserve613 avdd.n422 avss 3.0509118505473e-16
Cconserve614 avdd.n423 avss 2.9513777761153e-16
Cconserve615 avdd.n424 avss 1.566314387872e-15
Cconserve616 avdd.n425 avss 1.5756393244427e-15
Cconserve617 avdd.n427 avss 2.9112341991344e-16
Cconserve618 avdd.n428 avss 3.1697714043088e-16
Cconserve619 avdd.n429 avss 1.5711693253621e-15
Cconserve620 avdd.t204 avss 1.4657433365003e-15
Cconserve621 avdd.n430 avss 1.6307169405314e-15
Cconserve622 avdd.n431 avss 4.9224195499909e-16
Cconserve623 avdd.t67 avss 1.4669374311581e-15
Cconserve624 avdd.n435 avss 2.3892105806648e-16
Cconserve625 avdd.n436 avss 7.9839368465117e-17
Cconserve626 avdd.t10 avss 1.1520970916937e-15
Cconserve627 avdd.n438 avss 8.3838014391393e-17
Cconserve628 avdd.t254 avss 1.1519713975192e-15
Cconserve629 avdd.n439 avss 2.274985999588e-16
Cconserve630 avdd.n440 avss 8.695680109617e-17
Cconserve631 avdd.n441 avss 5.340509797921e-16
Cconserve632 avdd.n442 avss 4.1746491941195e-15
Cconserve633 iref_gate avdd 2.30842e-14
Cconserve634 net3 avdd 8.57008e-15
Cconserve635 net4 avdd 3.35642e-15
Cconserve636 avdd pm1 2.82695e-14
Cconserve637 avdd pm2 2.9349e-14
Cconserve638 avdd psrg_m3_feed 4.937762e-14
Cconserve639 psrg_m3_protected avdd 3.0122e-16
Cconserve640 psrg_mf1_protected avdd 1.47e-16
Cconserve641 psrg_vnc avdd 2.05436e-14
Cconserve642 rb_mid avdd 6.6006e-16
Cconserve643 rbit0top avdd 1.1793e-16
Cconserve644 rbit1top avdd 1.7165e-16
Cconserve645 su_state avdd 5.5904e-16
Cconserve646 v1 avdd 1.091031e-14
Cconserve647 avdd v2 1.1518e-14
Cconserve648 vaux avdd 7.21322e-15
Cconserve649 avdd vbn 4.68956e-15
Cconserve650 vbn_fold avdd 3.32305e-14
Cconserve651 vbn_i avdd 1.66478e-14
Cconserve652 vbn_sink avdd 4.33135e-14
Cconserve653 vbp_bias avdd 7.966632e-14
Cconserve654 vbp_cas avdd 8.50735e-14
Cconserve655 vbp_i avdd 1.9559e-13
Cconserve656 vbp_tail avdd 4.4571e-14
Cconserve657 vcasp avdd 3.53456e-14
Cconserve658 vgn1 avdd 1.28104e-14
Cconserve659 avdd vgn2 1.98834e-14
Cconserve660 vnx_bias avdd 3.8636e-16
Cconserve661 vq2 avdd 2.6912e-16
Cconserve662 vq3 avdd 2.66812e-15
Cconserve663 vref avdd 8.862e-15
Cconserve664 vsp avdd 6.77775e-14
Cconserve665 vsu avdd 6.58151e-15
Cconserve666 vsu1 avdd 2.41666e-15
Cconserve667 vsu2 avdd 1.8862e-16
Cconserve668 vsua avdd 6.92823e-15
Cconserve669 avdd vx1 2.34275e-14
Cconserve670 avdd vx2 2.23199e-14
Cconserve671 vx3 avdd 2.13216e-14
Cconserve672 avdd xf1 2.58176e-14
Cconserve673 xf2 avdd 2.49025e-14
Cconserve674 y1 avdd 4.58673e-14
Cconserve675 b1_b avss 3.7576350034456e-16
Cconserve676 b1_b.t0 avss 5.0670900785395e-17
Cconserve677 b1_b.t1 avss 1.3349075960647e-16
Cconserve678 b1_b.n0 avss 5.0063786540595e-16
Cconserve679 b1_b.n1 avss 4.1876834421852e-16
Cconserve680 b1_b.n2 avss 2.115286296391e-16
Cconserve681 b2_b avss 2.4954303690072e-16
Cconserve682 b2_b.t0 avss 1.8977785439539e-17
Cconserve683 b2_b.t1 avss 9.4450178304955e-17
Cconserve684 b2_b.n0 avss 3.3275474356795e-16
Cconserve685 b2_b.n1 avss 3.1074146578901e-16
Cconserve686 b2_b.n2 avss 8.3212789997823e-17
Cconserve687 b5_b avss 5.4078184773529e-16
Cconserve688 b5_b.t0 avss 3.1482081187897e-17
Cconserve689 b5_b.t1 avss 6.8936787330599e-17
Cconserve690 b5_b.n0 avss 3.1814928374621e-16
Cconserve691 dvdd avss 1.597780319474e-13
Cconserve692 dvdd.n0 avss 1.8914631776283e-16
Cconserve693 dvdd.t6 avss 4.7768612095428e-16
Cconserve694 dvdd.n1 avss 9.1641823549497e-16
Cconserve695 dvdd.n2 avss 8.9371738141366e-16
Cconserve696 dvdd.t2 avss 1.1231360855004e-15
Cconserve697 dvdd.n3 avss 1.5227493961387e-15
Cconserve698 dvdd.n4 avss 9.6289799389679e-16
Cconserve699 dvdd.t15 avss 1.4930652484698e-16
Cconserve700 dvdd.t26 avss 2.8661716582219e-16
Cconserve701 dvdd.t27 avss 1.386358874476e-16
Cconserve702 dvdd.n5 avss 1.0450907414326e-16
Cconserve703 dvdd.n6 avss 6.3110571645906e-16
Cconserve704 dvdd.t21 avss 2.5268948281682e-16
Cconserve705 dvdd.n7 avss 6.6970952820896e-16
Cconserve706 dvdd.n8 avss 1.0141912122838e-16
Cconserve707 dvdd.t14 avss 2.4023353928883e-16
Cconserve708 dvdd.n9 avss 5.9638151225785e-16
Cconserve709 dvdd.t19 avss 1.6742738205224e-16
Cconserve710 dvdd.t18 avss 2.8839560538876e-16
Cconserve711 dvdd.t24 avss 2.8709095860247e-16
Cconserve712 dvdd.n10 avss 5.5146046343753e-16
Cconserve713 dvdd.t23 avss 1.7411541347245e-16
Cconserve714 dvdd.t22 avss 2.6440383764523e-16
Cconserve715 dvdd.n12 avss 5.8016269273575e-16
Cconserve716 dvdd.t5 avss 2.3411268589256e-15
Cconserve717 dvdd.n13 avss 1.5087759424014e-15
Cconserve718 dvdd.t9 avss 1.0581440758574e-15
Cconserve719 dvdd.n14 avss 1.2625547610198e-15
Cconserve720 dvdd.t13 avss 3.339655443212e-15
Cconserve721 dvdd.t7 avss 3.2958811102512e-15
Cconserve722 dvdd.n15 avss 2.9290830995689e-15
Cconserve723 dvdd.t3 avss 3.295853644003e-15
Cconserve724 dvdd.n16 avss 1.4975697131635e-15
Cconserve725 dvdd.t1 avss 3.2981127429119e-15
Cconserve726 dvdd.n17 avss 1.4850725702633e-15
Cconserve727 dvdd.t10 avss 3.3462954086979e-15
Cconserve728 dvdd.t12 avss 3.2986620678746e-15
Cconserve729 dvdd.n18 avss 2.9229306599872e-15
Cconserve730 dvdd.t11 avss 3.295846777441e-15
Cconserve731 dvdd.n19 avss 1.5015042532084e-15
Cconserve732 dvdd.t20 avss 3.2989367303559e-15
Cconserve733 dvdd.n20 avss 1.5056035907422e-15
Cconserve734 dvdd.t0 avss 3.2959017099373e-15
Cconserve735 dvdd.n21 avss 1.4798745828043e-15
Cconserve736 dvdd.n22 avss 8.8619162942542e-16
Cconserve737 dvdd.n24 avss 2.5489364922943e-15
Cconserve738 dvdd.n25 avss 1.1281692754706e-15
Cconserve739 dvdd.t16 avss 2.8655536676389e-16
Cconserve740 dvdd.n26 avss 6.0661955624915e-16
Cconserve741 dvdd.t17 avss 1.48688534264e-16
Cconserve742 dvdd.t25 avss 1.6290231767245e-16
Cconserve743 dvdd.n30 avss 5.8775711034432e-16
Cconserve744 dvdd.t29 avss 1.726528357594e-16
Cconserve745 dvdd.t28 avss 2.8960412030658e-16
Cconserve746 dvdd.n31 avss 5.7582302553085e-16
Cconserve747 dvdd.n32 avss 1.1061344779065e-16
Cconserve748 dvdd.n33 avss 7.4522797744861e-17
Cconserve749 dvdd.n34 avss 7.7550951601443e-17
Cconserve750 dvdd.n35 avss 1.163538936503e-16
Cconserve751 dvdd.n36 avss 1.2056515614518e-15
Cconserve752 dvdd.n37 avss 1.1921244342466e-15
Cconserve753 dvdd.t8 avss 1.4582792452103e-15
Cconserve754 dvdd.n38 avss 1.1866929836785e-15
Cconserve755 dvdd.t4 avss 1.4572217946572e-15
Cconserve756 dvdd.n39 avss 1.1595082645896e-15
Cconserve757 dvdd.n40 avss 2.1347454704598e-16
Cconserve758 dvdd.n41 avss 1.7092726872049e-15
Cconserve759 dvss avss 3.19811e-14
Cconserve760 net3 avss 2.263894e-14
Cconserve761 net4 avss 1.064265e-14
Cconserve762 pm1 avss 1.563572674987e-15
Cconserve763 pm1.t2 avss 1.1252295112209e-15
Cconserve764 pm1.t1 avss 1.2144124963776e-15
Cconserve765 pm1.n0 avss 3.3278715010113e-16
Cconserve766 pm1.t5 avss 1.2569086765973e-15
Cconserve767 pm1.t3 avss 1.1382939508293e-15
Cconserve768 pm1.n1 avss 5.1703335919792e-16
Cconserve769 pm1.t4 avss 1.1390671640459e-15
Cconserve770 pm1.n2 avss 4.4819256372808e-16
Cconserve771 pm1.n3 avss 4.2533027170547e-16
Cconserve772 pm1.t7 avss 9.2963138660286e-16
Cconserve773 pm1.t6 avss 9.8136221454814e-16
Cconserve774 pm1.n4 avss 1.6690332302301e-16
Cconserve775 pm1.t11 avss 9.6083101718604e-16
Cconserve776 pm1.t9 avss 1.0880656384432e-15
Cconserve777 pm1.t10 avss 9.5347880953851e-16
Cconserve778 pm1.n5 avss 6.3137918434281e-16
Cconserve779 pm1.n6 avss 4.143181881659e-16
Cconserve780 pm1.t8 avss 9.4492382577623e-16
Cconserve781 pm1.n7 avss 6.2504456347175e-16
Cconserve782 pm1.n8 avss 9.5062842106338e-16
Cconserve783 pm1.t0 avss 1.0806256090476e-15
Cconserve784 pm2 avss 3.8987030979379e-15
Cconserve785 pm2.t2 avss 1.621659037166e-15
Cconserve786 pm2.t4 avss 1.6035493162854e-15
Cconserve787 pm2.t5 avss 1.6039579291212e-15
Cconserve788 pm2.t3 avss 1.7921840698678e-15
Cconserve789 pm2.n0 avss 7.6584124536662e-16
Cconserve790 pm2.n1 avss 5.3630162283978e-16
Cconserve791 pm2.n2 avss 7.3376241367447e-16
Cconserve792 pm2.t0 avss 1.6171043660901e-15
Cconserve793 pm2.n3 avss 4.8169732755537e-16
Cconserve794 pm2.t6 avss 1.365834712958e-15
Cconserve795 pm2.t11 avss 1.4391262352641e-15
Cconserve796 pm2.t10 avss 1.3329195869953e-15
Cconserve797 pm2.n4 avss 5.4981853544648e-16
Cconserve798 pm2.t9 avss 1.3467307008437e-15
Cconserve799 pm2.n5 avss 5.6619846198902e-16
Cconserve800 pm2.n6 avss 4.8053959118741e-16
Cconserve801 pm2.t7 avss 1.343834997881e-15
Cconserve802 pm2.n7 avss 2.8064619193721e-16
Cconserve803 pm2.t8 avss 1.3474416871779e-15
Cconserve804 pm2.n8 avss 1.630607658269e-15
Cconserve805 pm2.t1 avss 1.6034812141461e-15
Cconserve806 psrg_m3_protected avss 1.3684714463848e-15
Cconserve807 psrg_m3_protected.t1 avss 9.5337466352951e-16
Cconserve808 psrg_m3_protected.t3 avss 9.6746255474048e-16
Cconserve809 psrg_m3_protected.n0 avss 1.3743696613552e-16
Cconserve810 psrg_m3_protected.t2 avss 3.0247288765127e-16
Cconserve811 psrg_m3_protected.n1 avss 9.787677308821e-17
Cconserve812 psrg_m3_protected.t0 avss 2.9077470847024e-16
Cconserve813 psrg_mf1_protected avss 2.9443459997464e-15
Cconserve814 psrg_mf1_protected.t0 avss 7.5205569213414e-15
Cconserve815 psrg_mf1_protected.t1 avss 7.8516970789122e-15
Cconserve816 rbit0top avss 5.7396378367731e-15
Cconserve817 rbit0top.t8 avss 1.2616765699979e-15
Cconserve818 rbit0top.t9 avss 1.2565611010769e-15
Cconserve819 rbit0top.n0 avss 4.8499197642155e-16
Cconserve820 rbit0top.t4 avss 1.2278088390812e-15
Cconserve821 rbit0top.t7 avss 1.0370599189684e-15
Cconserve822 rbit0top.t0 avss 3.5446727056499e-16
Cconserve823 rbit0top.n1 avss 2.6065196341474e-15
Cconserve824 rbit0top.n2 avss 9.0412192572015e-16
Cconserve825 rbit0top.t6 avss 1.2369338084571e-15
Cconserve826 rbit0top.n3 avss 1.4850617732894e-16
Cconserve827 rbit0top.t3 avss 1.2340244402231e-15
Cconserve828 rbit0top.n4 avss 1.0666613546412e-16
Cconserve829 rbit0top.t5 avss 1.2351449993022e-15
Cconserve830 rbit0top.n5 avss 9.7474049268405e-17
Cconserve831 rbit0top.n6 avss 4.0502958088663e-16
Cconserve832 rbit0top.t1 avss 1.2334378975801e-15
Cconserve833 rbit0top.n7 avss 1.0462053152025e-16
Cconserve834 rbit0top.t2 avss 1.2163873072177e-15
Cconserve835 rbit1top avss 1.5958182690493e-15
Cconserve836 rbit1top.t4 avss 7.2563904743984e-16
Cconserve837 rbit1top.t12 avss 7.4779971477538e-16
Cconserve838 rbit1top.t13 avss 7.5011464178716e-16
Cconserve839 rbit1top.n0 avss 3.0018984885923e-16
Cconserve840 rbit1top.t5 avss 7.3685600478404e-16
Cconserve841 rbit1top.t6 avss 7.3621126383911e-16
Cconserve842 rbit1top.t7 avss 7.3638012456278e-16
Cconserve843 rbit1top.t8 avss 7.3689131202626e-16
Cconserve844 rbit1top.t10 avss 7.4420758665366e-16
Cconserve845 rbit1top.t0 avss 1.3298242518308e-16
Cconserve846 rbit1top.t11 avss 1.7346755123186e-16
Cconserve847 rbit1top.n1 avss 6.4190869005902e-16
Cconserve848 rbit1top.n2 avss 7.2422368755599e-16
Cconserve849 rbit1top.t2 avss 7.3799965241253e-16
Cconserve850 rbit1top.n3 avss 7.4719335126766e-17
Cconserve851 rbit1top.t3 avss 7.3716762957408e-16
Cconserve852 rbit1top.n4 avss 6.8790788628439e-17
Cconserve853 rbit1top.t1 avss 7.381178549191e-16
Cconserve854 rbit1top.n5 avss 6.4053477780733e-17
Cconserve855 rbit1top.t9 avss 7.3588428807419e-16
Cconserve856 rbit1top.n6 avss 5.8913971391195e-17
Cconserve857 rbit1top.n7 avss 6.1463768318621e-17
Cconserve858 rbit1top.n8 avss 5.7208478082121e-17
Cconserve859 rbit1top.n9 avss 5.8625373063467e-17
Cconserve860 rbit1top.n10 avss 6.0711570549543e-17
Cconserve861 rbit1top.n11 avss 2.556336442725e-16
Cconserve862 rbit2top avss 2.5744914223583e-15
Cconserve863 rbit2top.t3 avss 1.016764067772e-15
Cconserve864 rbit2top.t4 avss 1.0314342290879e-15
Cconserve865 rbit2top.t7 avss 1.0349450555274e-15
Cconserve866 rbit2top.t6 avss 1.8433688902139e-16
Cconserve867 rbit2top.t8 avss 2.8935913733788e-16
Cconserve868 rbit2top.n0 avss 1.136234466061e-15
Cconserve869 rbit2top.n1 avss 8.1046982157628e-16
Cconserve870 rbit2top.t5 avss 1.0343073170607e-15
Cconserve871 rbit2top.n2 avss 1.1220932141219e-16
Cconserve872 rbit2top.n3 avss 8.801226156816e-17
Cconserve873 rbit2top.t0 avss 5.4338582235515e-16
Cconserve874 rbit2top.t1 avss 5.4058891474522e-16
Cconserve875 rbit2top.t2 avss 5.4527074219188e-16
Cconserve876 rbit2top.n4 avss 1.3759914808131e-16
Cconserve877 rbit2top.n5 avss 3.724871493522e-16
Cconserve878 rbit2top.t9 avss 5.5214438750873e-16
Cconserve879 rbit2top.n6 avss 6.9619927720175e-16
Cconserve880 rbit2top.n7 avss 4.1180056978063e-16
Cconserve881 rbit3top avss 6.2042736877933e-15
Cconserve882 rbit3top.t0 avss 1.1610052020014e-15
Cconserve883 rbit3top.t7 avss 8.1552201298103e-16
Cconserve884 rbit3top.t6 avss 2.8480347463001e-16
Cconserve885 rbit3top.t1 avss 9.5585474445248e-16
Cconserve886 rbit3top.n0 avss 2.7662793523134e-15
Cconserve887 rbit3top.t5 avss 5.4114143338012e-16
Cconserve888 rbit3top.t2 avss 8.0633384724567e-16
Cconserve889 rbit3top.n1 avss 4.7313491693449e-16
Cconserve890 rbit3top.t3 avss 8.1208479359577e-16
Cconserve891 rbit3top.n2 avss 1.230724766296e-16
Cconserve892 rbit3top.n3 avss 1.1698707808041e-15
Cconserve893 rbit3top.t4 avss 8.0872544002183e-16
Cconserve894 rbit3top.n4 avss 4.2573317732155e-16
Cconserve895 rbit3top.n5 avss 1.0953346598952e-15
Cconserve896 rbit4top avss 6.5450427061194e-15
Cconserve897 rbit4top.t5 avss 7.8312070367834e-16
Cconserve898 rbit4top.t3 avss 6.5387337034576e-16
Cconserve899 rbit4top.t2 avss 3.2585368817217e-16
Cconserve900 rbit4top.n0 avss 1.3357689852333e-15
Cconserve901 rbit4top.n1 avss 1.3284181733761e-15
Cconserve902 rbit4top.t4 avss 8.3438740733593e-16
Cconserve903 rbit4top.t0 avss 3.308495266855e-16
Cconserve904 rbit4top.n2 avss 2.0654521456285e-15
Cconserve905 rbit4top.n3 avss 1.6230515050582e-15
Cconserve906 rbit4top.t1 avss 1.4480517883669e-15
Cconserve907 rbit5top avss 1.3714854970918e-14
Cconserve908 rbit5top.t0 avss 4.368742150559e-16
Cconserve909 rbit5top.t3 avss 3.671600416016e-16
Cconserve910 rbit5top.n0 avss 3.6304536633934e-16
Cconserve911 rbit5top.t2 avss 1.5320773932087e-15
Cconserve912 rbit5top.t1 avss 3.4195686066752e-16
Cconserve913 rbit5top.n1 avss 3.0702473040391e-15
Cconserve914 rbit5top.n2 avss 2.6913474007155e-15
Cconserve915 rbit5top.t4 avss 3.9835398620964e-16
Cconserve916 rbit5top.t5 avss 8.6448246124453e-16
Cconserve917 rbit6top avss 1.0101813087671e-14
Cconserve918 rbit6top.n0 avss 7.242331128622e-16
Cconserve919 rbit6top.n1 avss 6.6492115636364e-16
Cconserve920 rbit6top.t4 avss 2.0220933679204e-16
Cconserve921 rbit6top.t2 avss 1.0704445642368e-15
Cconserve922 rbit6top.t1 avss 8.5428488833867e-16
Cconserve923 rbit6top.n2 avss 2.7149336147344e-15
Cconserve924 rbit6top.t5 avss 8.1946734599427e-17
Cconserve925 rbit6top.t3 avss 2.3220287274077e-16
Cconserve926 rbit6top.n3 avss 1.1389135405094e-15
Cconserve927 rbit6top.t0 avss 4.0845709115196e-16
Cconserve928 rfix0 avss 9.75415e-15
Cconserve929 rfix1 avss 1.11355e-14
Cconserve930 rfix2 avss 1.11718e-14
Cconserve931 su_state avss 8.6818266065176e-15
Cconserve932 su_state.t2 avss 1.4860336870455e-15
Cconserve933 su_state.n0 avss 4.2633488383158e-15
Cconserve934 su_state.t0 avss 2.224030868121e-15
Cconserve935 v1.t1 avss 6.4384702698556e-16
Cconserve936 v1.t0 avss 6.3609738920918e-16
Cconserve937 v1.n0 avss 3.0661135396567e-16
Cconserve938 v1.n1 avss 7.2438378730696e-16
Cconserve939 v1.n2 avss 4.7487417574585e-16
Cconserve940 v1.n3 avss 4.6651767518352e-16
Cconserve941 v1.n4 avss 4.3559194761229e-16
Cconserve942 v1.n5 avss 2.498555233491e-16
Cconserve943 v1 avss 2.9583711206419e-15
Cconserve944 vaux avss 9.0531145896569e-15
Cconserve945 vaux.t2 avss 6.9428497249799e-16
Cconserve946 vaux.t1 avss 6.9945402039653e-16
Cconserve947 vaux.n0 avss 2.7511038324883e-15
Cconserve948 vaux.t0 avss 5.291425849603e-16
Cconserve949 vq2 avss 6.78808e-15
Cconserve950 vq3.t0 avss 4.9966097345028e-16
Cconserve951 vq3.n0 avss 3.562467417243e-15
Cconserve952 vq3.t2 avss 5.823638697119e-17
Cconserve953 vq3.n1 avss 5.773443171831e-16
Cconserve954 vq3.t1 avss 1.3215833141096e-16
Cconserve955 vq3 avss 1.0950852573741e-14
Cconserve956 vsp avss 4.3112270983969e-16
Cconserve957 vsp.t8 avss 5.7537824347201e-16
Cconserve958 vsp.t11 avss 5.8795548366788e-16
Cconserve959 vsp.n0 avss 1.1217591656046e-16
Cconserve960 vsp.t10 avss 5.8702874827104e-16
Cconserve961 vsp.n1 avss 7.9412709332791e-17
Cconserve962 vsp.t9 avss 5.8797840645155e-16
Cconserve963 vsp.n2 avss 7.7480646137956e-17
Cconserve964 vsp.t14 avss 5.8865626591143e-16
Cconserve965 vsp.n3 avss 7.7547777147268e-17
Cconserve966 vsp.t12 avss 5.7962878250065e-16
Cconserve967 vsp.n4 avss 2.3175834825807e-16
Cconserve968 vsp.t2 avss 8.787915761331e-16
Cconserve969 vsp.t3 avss 9.2948285620132e-16
Cconserve970 vsp.t13 avss 8.9136144829137e-16
Cconserve971 vsp.t1 avss 8.9112730842962e-16
Cconserve972 vsp.t4 avss 9.2815824677367e-16
Cconserve973 vsp.t5 avss 8.8553496788558e-16
Cconserve974 vsp.n5 avss 1.0061792156695e-16
Cconserve975 vsp.t15 avss 8.9112730842962e-16
Cconserve976 vsp.n6 avss 6.7707353587134e-17
Cconserve977 vsp.t7 avss 9.2970635334208e-16
Cconserve978 vsp.n7 avss 6.7727820358266e-17
Cconserve979 vsp.t0 avss 9.2948285620132e-16
Cconserve980 vsp.n8 avss 9.179264985495e-17
Cconserve981 vsp.n9 avss 9.5952316419762e-17
Cconserve982 vsp.n10 avss 6.7727820358266e-17
Cconserve983 vsp.n11 avss 6.7707353587134e-17
Cconserve984 vsp.n12 avss 7.3191629579591e-17
Cconserve985 vsp.n13 avss 1.3111914124914e-16
Cconserve986 vsp.t6 avss 9.0740903420033e-16
Cconserve987 vsu1 avss 6.82494e-15
Cconserve988 vsu2 avss 5.71042e-15
Cconserve989 vx1 avss 2.6396012884691e-16
Cconserve990 vx1.t0 avss 2.3962459992511e-16
Cconserve991 vx1.t8 avss 2.5370559377248e-16
Cconserve992 vx1.n0 avss 1.6306590154379e-16
Cconserve993 vx1.t1 avss 2.3821902078985e-16
Cconserve994 vx1.n1 avss 6.2648361426906e-17
Cconserve995 vx1.t7 avss 2.3821902078985e-16
Cconserve996 vx1.t3 avss 1.493406229079e-16
Cconserve997 vx1.t2 avss 1.4666843839409e-16
Cconserve998 vx1.n2 avss 1.4697518875865e-16
Cconserve999 vx1.t4 avss 1.4564377696505e-16
Cconserve1000 vx1.n3 avss 1.7562538478009e-16
Cconserve1001 vx1.n4 avss 1.1510771426571e-16
Cconserve1002 vx1.n5 avss 1.3856187594286e-16
Cconserve1003 vx1.t10 avss 2.3953027058765e-16
Cconserve1004 vx1.t6 avss 1.512430512252e-16
Cconserve1005 vx1.t5 avss 1.4571218373649e-16
Cconserve1006 vx1.n6 avss 9.411259600399e-17
Cconserve1007 vx1.n7 avss 1.2279735544679e-16
Cconserve1008 vx1.n8 avss 8.3880383139189e-17
Cconserve1009 vx1.t9 avss 2.3326853075146e-16
Cconserve1010 vx2 avss 1.8043600412735e-15
Cconserve1011 vx2.t9 avss 1.3948518162694e-15
Cconserve1012 vx2.t10 avss 1.2646787087202e-15
Cconserve1013 vx2.n0 avss 7.4328155172299e-16
Cconserve1014 vx2.t6 avss 1.2720938286249e-15
Cconserve1015 vx2.t1 avss 8.5324216532827e-16
Cconserve1016 vx2.t4 avss 7.570043637033e-16
Cconserve1017 vx2.n1 avss 5.3239786490804e-16
Cconserve1018 vx2.n2 avss 4.864396099999e-16
Cconserve1019 vx2.t8 avss 1.2813172310338e-15
Cconserve1020 vx2.n3 avss 6.0723443012915e-16
Cconserve1021 vx2.t2 avss 9.1303939597502e-16
Cconserve1022 vx2.t3 avss 7.6189098580239e-16
Cconserve1023 vx2.n4 avss 6.7266560305338e-16
Cconserve1024 vx2.t5 avss 7.5755033336731e-16
Cconserve1025 vx2.n5 avss 6.4694307484083e-16
Cconserve1026 vx2.n6 avss 4.6561919238755e-16
Cconserve1027 vx2.t0 avss 1.2756716723805e-15
Cconserve1028 vx2.n7 avss 6.7689396385544e-16
Cconserve1029 vx2.n8 avss 7.3067391182233e-16
Cconserve1030 vx2.t7 avss 1.211580254802e-15
Cconserve1031 vx3 avss 8.6525406560819e-16
Cconserve1032 vx3.t8 avss 8.7453720853464e-16
Cconserve1033 vx3.t0 avss 8.2217827797213e-16
Cconserve1034 vx3.n0 avss 3.4244649833474e-16
Cconserve1035 vx3.t1 avss 8.2482917276732e-16
Cconserve1036 vx3.t2 avss 3.3373011571327e-15
Cconserve1037 vx3.t4 avss 4.9915246541956e-16
Cconserve1038 vx3.t6 avss 5.8056349914867e-16
Cconserve1039 vx3.t5 avss 4.963036304648e-16
Cconserve1040 vx3.n1 avss 4.736733074117e-16
Cconserve1041 vx3.n2 avss 8.5002770675149e-16
Cconserve1042 vx3.t3 avss 4.963036304648e-16
Cconserve1043 vx3.n3 avss 2.0723332477844e-16
Cconserve1044 vx3.t7 avss 8.2482917276732e-16
Cconserve1045 vx3.n4 avss 3.7183184252947e-16
Cconserve1046 vx3.n5 avss 4.9079638399993e-16
Cconserve1047 vx3.t10 avss 8.490029279507e-16
Cconserve1048 vx3.n6 avss 3.5281204820971e-16
Cconserve1049 vx3.t9 avss 8.0774367975369e-16
Cconserve1050 xf1 avss 2.7805892066186e-15
Cconserve1051 xf1.t9 avss 1.6691197492566e-15
Cconserve1052 xf1.t6 avss 7.6622703558947e-16
Cconserve1053 xf1.t5 avss 7.4151460747139e-16
Cconserve1054 xf1.t7 avss 7.7653729862372e-16
Cconserve1055 xf1.t8 avss 1.7528024714972e-15
Cconserve1056 xf1.n0 avss 8.1434626354121e-16
Cconserve1057 xf1.t3 avss 7.3924288426337e-16
Cconserve1058 xf1.n1 avss 1.543249131847e-16
Cconserve1059 xf1.t11 avss 7.4130283666386e-16
Cconserve1060 xf1.n2 avss 3.0503222092179e-16
Cconserve1061 xf1.t4 avss 7.3929538942226e-16
Cconserve1062 xf1.n3 avss 2.3025962414497e-16
Cconserve1063 xf1.n4 avss 1.5746997220227e-16
Cconserve1064 xf1.n5 avss 3.7325567421293e-16
Cconserve1065 xf1.t2 avss 1.6524091073535e-15
Cconserve1066 xf1.n6 avss 2.7800956581251e-16
Cconserve1067 xf1.t10 avss 1.6715979927563e-15
Cconserve1068 xf1.n7 avss 2.9559879404103e-16
Cconserve1069 xf1.t0 avss 1.6715979927563e-15
Cconserve1070 xf1.n8 avss 2.505283656489e-16
Cconserve1071 xf1.n9 avss 2.333504278317e-16
Cconserve1072 xf1.t1 avss 1.6294976061854e-15
Cconserve1073 xf2 avss 2.4626328699543e-15
Cconserve1074 xf2.t5 avss 1.6173997590216e-15
Cconserve1075 xf2.t9 avss 1.6266622457726e-15
Cconserve1076 xf2.t8 avss 6.7867152275634e-16
Cconserve1077 xf2.t6 avss 6.8410583493132e-16
Cconserve1078 xf2.t7 avss 6.9590550717233e-16
Cconserve1079 xf2.n0 avss 2.5440483687831e-16
Cconserve1080 xf2.t4 avss 7.3984392877908e-16
Cconserve1081 xf2.n1 avss 3.8034586139637e-16
Cconserve1082 xf2.t10 avss 6.7791964559348e-16
Cconserve1083 xf2.n2 avss 1.0528199966443e-16
Cconserve1084 xf2.t11 avss 6.8391066681671e-16
Cconserve1085 xf2.n3 avss 3.2574678146342e-16
Cconserve1086 xf2.n4 avss 2.902357830353e-16
Cconserve1087 xf2.t2 avss 1.6064431490462e-15
Cconserve1088 xf2.n5 avss 2.124500911906e-16
Cconserve1089 xf2.n6 avss 4.147114469551e-16
Cconserve1090 xf2.n7 avss 1.0859665813561e-16
Cconserve1091 xf2.t0 avss 1.619215462383e-15
Cconserve1092 xf2.n8 avss 1.8864598016212e-16
Cconserve1093 xf2.t1 avss 1.619215462383e-15
Cconserve1094 xf2.n9 avss 3.6146254643802e-16
Cconserve1095 xf2.t3 avss 1.5818919600708e-15
Cconserve1096 b0 b0_b 1.57273e-15
Cconserve1097 b0 b1 2.8169e-16
Cconserve1098 b0 b1_b 1.1519e-16
Cconserve1099 b0 b2 2.3544e-16
Cconserve1100 b0 b2_b 6.6587e-16
Cconserve1101 b0 b3 1.162e-16
Cconserve1102 dvdd b0 2.27068e-15
Cconserve1103 b0 dvss 1.53675e-15
Cconserve1104 b0 rbit0top 1.14536e-15
Cconserve1105 b0 rbit1top 9.57e-16
Cconserve1106 b0 rbit2top 5.3646e-16
Cconserve1107 b0 rbit3top 2.6929e-16
Cconserve1108 rbit4top b0 2.7314e-16
Cconserve1109 b0 rbit5top 6.5409e-16
Cconserve1110 b0 rbit6top 3.5839e-16
Cconserve1111 b0_b b2 4.9542e-16
Cconserve1112 b2_b b0_b 3.6389e-16
Cconserve1113 b0_b b3 4.4758e-16
Cconserve1114 b0_b b3_b 1.6655e-16
Cconserve1115 b4 b0_b 2.1404e-16
Cconserve1116 b5 b0_b 1.8986e-16
Cconserve1117 b0_b b6 2.305e-16
Cconserve1118 dvdd b0_b 4.34098e-15
Cconserve1119 b0_b dvss 6.5552e-16
Cconserve1120 rbit0top b0_b 2.17947e-15
Cconserve1121 rbit1top b0_b 2.10537e-15
Cconserve1122 rbit2top b0_b 1.2093e-16
Cconserve1123 rbit4top b0_b 1.0644e-16
Cconserve1124 b0_b rbit5top 1.1709e-16
Cconserve1125 rbit6top b0_b 4.0629e-16
Cconserve1126 b1_b b1 1.99506e-15
Cconserve1127 b2 b1 6.1743e-16
Cconserve1128 b2_b b1 1.6476e-16
Cconserve1129 b3 b1 1.5208e-16
Cconserve1130 b3_b b1 1.9611e-16
Cconserve1131 b4_b b1 2.0282e-16
Cconserve1132 b6_b b1 1.6865e-16
Cconserve1133 dvdd b1 2.00117e-15
Cconserve1134 dvss b1 1.36969e-15
Cconserve1135 rbit0top b1 3.846e-16
Cconserve1136 rbit1top b1 8.303e-16
Cconserve1137 rbit2top b1 9.9261e-16
Cconserve1138 b5_b b1_b 2.518e-16
Cconserve1139 b1_b b6 1.7833e-16
Cconserve1140 b6_b b1_b 2.092e-16
Cconserve1141 dvdd b1_b 1.76233e-15
Cconserve1142 dvss b1_b 5.2319e-16
Cconserve1143 rbit1top b1_b 1.0224e-15
Cconserve1144 rbit2top b1_b 1.01233e-15
Cconserve1145 rbit5top b1_b 1.4972e-16
Cconserve1146 rbit6top b1_b 5.2663e-16
Cconserve1147 b2_b b2 6.365e-16
Cconserve1148 b3 b2 5.2757e-16
Cconserve1149 b4 b2 1.2242e-16
Cconserve1150 b5 b2 9.131e-16
Cconserve1151 dvdd b2 2.86524e-15
Cconserve1152 dvss b2 1.03242e-15
Cconserve1153 rbit0top b2 2.7841e-16
Cconserve1154 rbit1top b2 5.9167e-16
Cconserve1155 rbit2top b2 2.7743e-16
Cconserve1156 rbit3top b2 2.8452e-16
Cconserve1157 rbit4top b2 1.1838e-16
Cconserve1158 rbit5top b2 1.5945e-16
Cconserve1159 rbit6top b2 3.2495e-16
Cconserve1160 vq3 b2 5.3362e-16
Cconserve1161 b2_b b3 8.5836e-16
Cconserve1162 b2_b b3_b 1.2166e-16
Cconserve1163 b4 b2_b 1.5741e-16
Cconserve1164 dvdd b2_b 2.90137e-15
Cconserve1165 b2_b dvss 1.28816e-15
Cconserve1166 b2_b rbit2top 6.2978e-16
Cconserve1167 b2_b rbit3top 1.34734e-15
Cconserve1168 rbit4top b2_b 1.7164e-16
Cconserve1169 b2_b rbit5top 2.5686e-16
Cconserve1170 rbit6top b2_b 2.309e-16
Cconserve1171 vq3 b2_b 1.7063e-16
Cconserve1172 b3 b3_b 3.0195e-16
Cconserve1173 b4 b3 2.21699e-15
Cconserve1174 b4_b b3 1.5984e-16
Cconserve1175 b5 b3 5.4458e-16
Cconserve1176 b5_b b3 1.8047e-16
Cconserve1177 b3 b6 9.0244e-16
Cconserve1178 b6_b b3 1.8423e-16
Cconserve1179 dvdd b3 2.24128e-15
Cconserve1180 dvss b3 1.77121e-15
Cconserve1181 rbit0top b3 4.5793e-16
Cconserve1182 rbit1top b3 3.8141e-16
Cconserve1183 rbit3top b3 3.502e-16
Cconserve1184 rbit4top b3 1.99837e-15
Cconserve1185 rbit5top b3 3.1365e-16
Cconserve1186 rbit6top b3 1.9696e-16
Cconserve1187 vq3 b3 7.4007e-16
Cconserve1188 b4_b b3_b 3.5529e-16
Cconserve1189 b5 b3_b 1.3851e-16
Cconserve1190 b5_b b3_b 1.262e-16
Cconserve1191 b3_b b6 5.6436e-16
Cconserve1192 b6_b b3_b 1.2432e-16
Cconserve1193 dvdd b3_b 1.03536e-15
Cconserve1194 dvss b3_b 5.8031e-16
Cconserve1195 rbit3top b3_b 4.74e-16
Cconserve1196 rbit4top b3_b 3.0008e-16
Cconserve1197 b4_b b4 4.3695e-16
Cconserve1198 b4 b5 4.2193e-16
Cconserve1199 b4 b5_b 2.37219e-15
Cconserve1200 b4 b6 1.2464e-16
Cconserve1201 b6_b b4 2.0318e-16
Cconserve1202 dvdd b4 2.07965e-15
Cconserve1203 b4 dvss 1.18675e-15
Cconserve1204 b4 rbit0top 2.6882e-16
Cconserve1205 b4 rbit1top 3.0293e-16
Cconserve1206 b4 rbit2top 1.416e-16
Cconserve1207 rbit4top b4 1.5644e-16
Cconserve1208 b4 rbit5top 3.222e-16
Cconserve1209 b4 vq3 1.0345e-16
Cconserve1210 b4_b b5 5.3647e-16
Cconserve1211 b4_b b5_b 1.3196e-16
Cconserve1212 b4_b b6 1.4274e-16
Cconserve1213 b4_b b6_b 5.5781e-16
Cconserve1214 b4_b dvdd 1.92628e-15
Cconserve1215 b4_b dvss 5.4131e-16
Cconserve1216 b4_b rbit3top 1.6324e-16
Cconserve1217 rbit4top b4_b 5.2889e-16
Cconserve1218 b4_b rbit5top 6.1845e-16
Cconserve1219 b5 b5_b 7.1797e-16
Cconserve1220 b5 b6 7.2955e-16
Cconserve1221 dvdd b5 1.99811e-15
Cconserve1222 b5 dvss 1.86594e-15
Cconserve1223 b5 rbit0top 2.5231e-16
Cconserve1224 b5 rbit1top 2.6006e-16
Cconserve1225 b5 rbit3top 1.1636e-16
Cconserve1226 b5 rbit5top 1.4245e-16
Cconserve1227 b5 rbit6top 2.4355e-16
Cconserve1228 b5_b b6 1.2009e-16
Cconserve1229 dvdd b5_b 8.0368e-16
Cconserve1230 b5_b dvss 1.27577e-15
Cconserve1231 rbit3top b5_b 1.0459e-16
Cconserve1232 b5_b rbit5top 3.2035e-16
Cconserve1233 rbit6top b5_b 1.8433e-16
Cconserve1234 b6_b b6 4.4031e-16
Cconserve1235 dvdd b6 2.34839e-15
Cconserve1236 dvss b6 1.64038e-15
Cconserve1237 rbit0top b6 2.9145e-16
Cconserve1238 rbit1top b6 3.938e-16
Cconserve1239 rbit3top b6 2.4596e-16
Cconserve1240 rbit4top b6 3.5598e-16
Cconserve1241 rbit5top b6 1.6596e-16
Cconserve1242 rbit6top b6 1.7396e-16
Cconserve1243 vq3 b6 3.4769e-16
Cconserve1244 b6_b dvdd 8.878e-16
Cconserve1245 b6_b dvss 1.21805e-15
Cconserve1246 b6_b rbit3top 1.0116e-16
Cconserve1247 b6_b rbit6top 1.31e-16
Cconserve1248 b6_b vq3 3.6188e-16
Cconserve1249 bgsu1 bgsu2 2.5045e-16
Cconserve1250 vsu bgsu1 5.7239e-16
Cconserve1251 dvdd dvss 5.19427e-15
Cconserve1252 dvdd rbit0top 1.81015e-14
Cconserve1253 dvdd rbit1top 2.53609e-14
Cconserve1254 dvdd rbit2top 1.49668e-14
Cconserve1255 dvdd rbit3top 9.14379e-15
Cconserve1256 rbit4top dvdd 5.19344e-15
Cconserve1257 dvdd rbit5top 3.14552e-15
Cconserve1258 dvdd rbit6top 3.47008e-15
Cconserve1259 dvdd vq3 5.542e-16
Cconserve1260 rbit0top dvss 4.70472e-15
Cconserve1261 rbit1top dvss 6.97599e-15
Cconserve1262 rbit2top dvss 3.44856e-15
Cconserve1263 rbit3top dvss 2.4747e-15
Cconserve1264 rbit4top dvss 2.43979e-15
Cconserve1265 rbit5top dvss 1.32043e-15
Cconserve1266 rbit6top dvss 1.23274e-15
Cconserve1267 vq3 dvss 4.7982e-16
Cconserve1268 iref_gate psrg_m3_feed 1.04746e-15
Cconserve1269 iref_gate v1 4.7074e-16
Cconserve1270 iref_gate v2 6.4906e-16
Cconserve1271 iref_gate vbn 1.1992e-16
Cconserve1272 iref_gate vbn_fold 6.7174e-16
Cconserve1273 iref_gate vbn_i 6.6186e-16
Cconserve1274 vbn_sink iref_gate 2.54328e-15
Cconserve1275 vbp_bias iref_gate 1.2644e-16
Cconserve1276 vbp_i iref_gate 6.10108e-15
Cconserve1277 iref_gate vbp_tail 2.77582e-15
Cconserve1278 vsp iref_gate 7.3451e-16
Cconserve1279 vsu iref_gate 3.80229e-15
Cconserve1280 iref_gate xf1 1.33023e-15
Cconserve1281 xf2 iref_gate 1.57776e-15
Cconserve1282 iref_gate y1 1.0436e-16
Cconserve1283 net3 net4 1.6306e-16
Cconserve1284 net3 v2 5.5684e-16
Cconserve1285 vbn_i net3 1.7037e-16
Cconserve1286 vbn_sink net3 1.6702e-16
Cconserve1287 vbp_bias net3 1.4653e-16
Cconserve1288 vbp_i net3 2.05358e-15
Cconserve1289 vbp_tail net3 1.05691e-15
Cconserve1290 vsp net3 1.4854e-16
Cconserve1291 net4 psrg_vnc 7.1795e-16
Cconserve1292 vaux net4 2.6336e-16
Cconserve1293 vbn_i net4 4.1992e-16
Cconserve1294 vbp_cas net4 2.69442e-15
Cconserve1295 vbp_i net4 5.8849e-16
Cconserve1296 net4 vgn1 3.05824e-15
Cconserve1297 net4 vq3 4.1149e-16
Cconserve1298 net4 vref 1.281e-16
Cconserve1299 y1 net4 8.1469e-16
Cconserve1300 pm2 pm1 6.96945e-15
Cconserve1301 psrg_vnc pm1 1.85879e-15
Cconserve1302 vaux pm1 1.6751e-16
Cconserve1303 vbp_bias pm1 6.745e-16
Cconserve1304 vbp_cas pm1 7.95308e-15
Cconserve1305 vbp_i pm1 1.51803e-15
Cconserve1306 vgn2 pm1 9.1122e-16
Cconserve1307 vq3 pm1 2.9607e-16
Cconserve1308 vsua pm1 2.777e-16
Cconserve1309 y1 pm1 8.3798e-15
Cconserve1310 psrg_vnc pm2 4.8016e-16
Cconserve1311 vaux pm2 1.6405e-16
Cconserve1312 vbp_bias pm2 1.7135e-16
Cconserve1313 vbp_cas pm2 9.66366e-15
Cconserve1314 vbp_i pm2 8.4094e-16
Cconserve1315 pm2 vgn2 1.26867e-15
Cconserve1316 vq3 pm2 1.02779e-15
Cconserve1317 vsua pm2 2.2197e-16
Cconserve1318 y1 pm2 8.97178e-15
Cconserve1319 psrg_m3_protected psrg_m3_feed 4.9036e-16
Cconserve1320 psrg_vnc psrg_m3_feed 1.9522e-15
Cconserve1321 rb_mid psrg_m3_feed 1.0281e-16
Cconserve1322 v1 psrg_m3_feed 7.2526e-16
Cconserve1323 v2 psrg_m3_feed 8.7255e-16
Cconserve1324 vaux psrg_m3_feed 7.8364e-16
Cconserve1325 vbn psrg_m3_feed 2.4799e-16
Cconserve1326 vbn_fold psrg_m3_feed 5.46551e-15
Cconserve1327 vbn_i psrg_m3_feed 1.9341e-16
Cconserve1328 vbn_sink psrg_m3_feed 1.44591e-15
Cconserve1329 vbp_bias psrg_m3_feed 3.0002e-16
Cconserve1330 vbp_cas psrg_m3_feed 9.9915e-16
Cconserve1331 vbp_i psrg_m3_feed 1.83774e-15
Cconserve1332 vcasp psrg_m3_feed 5.42682e-15
Cconserve1333 vgn1 psrg_m3_feed 1.05141e-15
Cconserve1334 vq2 psrg_m3_feed 2.83114e-15
Cconserve1335 vq3 psrg_m3_feed 2.1313e-16
Cconserve1336 vref psrg_m3_feed 7.8711e-16
Cconserve1337 vsp psrg_m3_feed 3.0111e-16
Cconserve1338 vsu psrg_m3_feed 1.26952e-15
Cconserve1339 vsu2 psrg_m3_feed 1.4487e-16
Cconserve1340 vsua psrg_m3_feed 1.1359e-16
Cconserve1341 psrg_m3_feed vx1 4.99211e-15
Cconserve1342 psrg_m3_feed vx2 7.14245e-15
Cconserve1343 vx3 psrg_m3_feed 4.62559e-15
Cconserve1344 xf1 psrg_m3_feed 3.6299e-16
Cconserve1345 xf2 psrg_m3_feed 3.3254e-16
Cconserve1346 y1 psrg_m3_feed 3.6919e-16
Cconserve1347 psrg_m3_protected psrg_vnc 1.29451e-15
Cconserve1348 psrg_m3_protected v2 4.8573e-16
Cconserve1349 vbn_i psrg_m3_protected 1.5324e-16
Cconserve1350 psrg_m3_protected vgn2 1.38012e-15
Cconserve1351 psrg_mf1_protected psrg_vnc 7.7161e-16
Cconserve1352 psrg_mf1_protected vbn_fold 7.3665e-16
Cconserve1353 psrg_mf1_protected y1 3.7904e-16
Cconserve1354 rb_mid psrg_vnc 7.1601e-16
Cconserve1355 v1 psrg_vnc 1.7954e-16
Cconserve1356 psrg_vnc v2 3.2706e-16
Cconserve1357 vaux psrg_vnc 1.036e-16
Cconserve1358 psrg_vnc vbn 3.336e-16
Cconserve1359 vbn_fold psrg_vnc 1.6832e-16
Cconserve1360 vbn_i psrg_vnc 1.20977e-15
Cconserve1361 vbn_sink psrg_vnc 1.69866e-15
Cconserve1362 vbp_cas psrg_vnc 2.86812e-15
Cconserve1363 vbp_i psrg_vnc 9.34187e-15
Cconserve1364 vbp_tail psrg_vnc 1.12479e-15
Cconserve1365 vcasp psrg_vnc 6.292e-16
Cconserve1366 vgn1 psrg_vnc 4.9843e-16
Cconserve1367 psrg_vnc vgn2 7.3289e-16
Cconserve1368 psrg_vnc vq3 7.5791e-16
Cconserve1369 y1 psrg_vnc 1.08148e-15
Cconserve1370 vcasp rb_mid 7.7152e-16
Cconserve1371 rb_mid vq3 1.0871e-16
Cconserve1372 rbit1top rbit0top 1.73003e-14
Cconserve1373 rbit2top rbit0top 1.90102e-15
Cconserve1374 rbit0top rbit3top 1.5601e-16
Cconserve1375 rbit0top rbit5top 1.7686e-16
Cconserve1376 rbit6top rbit0top 1.7868e-16
Cconserve1377 rbit0top rfix0 1.9661e-16
Cconserve1378 rfix1 rbit0top 2.3203e-16
Cconserve1379 rfix2 rbit0top 2.4932e-16
Cconserve1380 vref rbit0top 2.24313e-15
Cconserve1381 rbit2top rbit1top 9.50587e-15
Cconserve1382 rbit1top rbit3top 1.1666e-16
Cconserve1383 vref rbit1top 2.25566e-15
Cconserve1384 rbit2top rbit3top 5.74056e-15
Cconserve1385 rbit4top rbit2top 1.33249e-15
Cconserve1386 rbit2top rbit5top 1.2871e-16
Cconserve1387 rbit6top rbit2top 2.7808e-16
Cconserve1388 rbit2top rfix0 4.3835e-16
Cconserve1389 rfix1 rbit2top 4.7013e-16
Cconserve1390 rfix2 rbit2top 4.7492e-16
Cconserve1391 vref rbit2top 1.94986e-15
Cconserve1392 rbit4top rbit3top 3.7785e-15
Cconserve1393 rbit3top rbit5top 5.14549e-15
Cconserve1394 rbit6top rbit3top 6.6471e-16
Cconserve1395 rbit4top rbit5top 2.55451e-15
Cconserve1396 rbit4top rbit6top 6.1408e-16
Cconserve1397 rbit4top rfix0 1.3622e-16
Cconserve1398 rbit4top vq3 1.4224e-16
Cconserve1399 rbit6top rbit5top 1.10728e-15
Cconserve1400 vq3 rbit5top 1.1707e-16
Cconserve1401 rbit6top rfix0 2.312e-16
Cconserve1402 vq3 rbit6top 3.4956e-15
Cconserve1403 rfix1 rfix0 1.2694e-16
Cconserve1404 vq3 rfix0 2.74037e-15
Cconserve1405 vref rfix0 4.317e-16
Cconserve1406 rfix1 rfix2 1.2712e-16
Cconserve1407 rfix1 vref 4.6182e-16
Cconserve1408 vref rfix2 4.6704e-16
Cconserve1409 su_state vbn 3.0574e-16
Cconserve1410 su_state vgn2 1.2642e-16
Cconserve1411 su_state vsu 1.6289e-16
Cconserve1412 v1 v2 7.8404e-15
Cconserve1413 v1 vbn 1.4603e-16
Cconserve1414 vbn_fold v1 5.3716e-16
Cconserve1415 vbn_i v1 1.73482e-15
Cconserve1416 vbn_sink v1 2.3339e-16
Cconserve1417 vbp_bias v1 1.72122e-15
Cconserve1418 v1 vbp_cas 1.66248e-15
Cconserve1419 vbp_i v1 1.34899e-15
Cconserve1420 vbp_tail v1 1.42346e-15
Cconserve1421 vcasp v1 1.6656e-16
Cconserve1422 v1 vgn1 1.69439e-15
Cconserve1423 vq2 v1 2.2239e-16
Cconserve1424 v1 vq3 6.8781e-16
Cconserve1425 vsp v1 1.04163e-14
Cconserve1426 vsu v1 4.387e-16
Cconserve1427 vsua v1 2.87816e-15
Cconserve1428 v1 xf1 1.02886e-14
Cconserve1429 xf2 v1 1.09173e-15
Cconserve1430 y1 v1 1.8075e-16
Cconserve1431 vbn v2 3.2277e-16
Cconserve1432 vbn_fold v2 2.1234e-16
Cconserve1433 vbn_i v2 9.8248e-16
Cconserve1434 vbn_sink v2 2.3826e-16
Cconserve1435 vbp_bias v2 1.85827e-15
Cconserve1436 vbp_cas v2 3.1921e-15
Cconserve1437 vbp_i v2 4.8824e-16
Cconserve1438 vbp_tail v2 8.7659e-16
Cconserve1439 vcasp v2 3.0909e-16
Cconserve1440 v2 vgn2 1.41491e-15
Cconserve1441 vsp v2 1.08438e-14
Cconserve1442 vsu v2 6.2334e-16
Cconserve1443 vsua v2 5.67754e-15
Cconserve1444 xf1 v2 2.7167e-16
Cconserve1445 xf2 v2 1.0402e-14
Cconserve1446 y1 v2 1.84313e-15
Cconserve1447 vbn_i vaux 1.03639e-15
Cconserve1448 vbn_sink vaux 3.0193e-16
Cconserve1449 vaux vbp_cas 3.00971e-15
Cconserve1450 vbp_i vaux 2.72714e-15
Cconserve1451 vcasp vaux 6.5066e-16
Cconserve1452 vaux vgn2 1.6213e-16
Cconserve1453 y1 vaux 1.621e-16
Cconserve1454 vbn_fold vbn 1.9159e-16
Cconserve1455 vbp_bias vbn 1.3373e-16
Cconserve1456 vbp_cas vbn 1.19828e-15
Cconserve1457 vbp_i vbn 1.35237e-15
Cconserve1458 vbp_tail vbn 1.2319e-16
Cconserve1459 vcasp vbn 4.01634e-15
Cconserve1460 vgn1 vbn 5.3286e-16
Cconserve1461 vbn vgn2 1.0733e-16
Cconserve1462 vsu vbn 6.9666e-16
Cconserve1463 vbn_i vbn_fold 1.89286e-15
Cconserve1464 vbn_sink vbn_fold 1.42754e-15
Cconserve1465 vbp_i vbn_fold 1.17335e-14
Cconserve1466 vbp_tail vbn_fold 2.0027e-16
Cconserve1467 vbn_fold vgn1 1.4647e-16
Cconserve1468 vbn_fold vgn2 9.7834e-16
Cconserve1469 vnx_bias vbn_fold 3.7466e-16
Cconserve1470 vsu vbn_fold 3.6465e-16
Cconserve1471 vbn_fold xf1 9.7203e-16
Cconserve1472 xf2 vbn_fold 1.89587e-15
Cconserve1473 y1 vbn_fold 9.3704e-16
Cconserve1474 vbn_sink vbn_i 8.3284e-16
Cconserve1475 vbp_bias vbn_i 9.9182e-16
Cconserve1476 vbn_i vbp_cas 5.4832e-16
Cconserve1477 vbp_i vbn_i 9.69237e-15
Cconserve1478 vbn_i vbp_tail 4.35253e-15
Cconserve1479 vbn_i vcasp 4.1266e-16
Cconserve1480 vbn_i vgn1 4.93995e-15
Cconserve1481 vbn_i vgn2 5.1005e-16
Cconserve1482 vsp vbn_i 5.6742e-16
Cconserve1483 vsu vbn_i 2.7068e-16
Cconserve1484 vbn_i xf1 2.3103e-16
Cconserve1485 xf2 vbn_i 5.1739e-16
Cconserve1486 vbn_sink vbp_bias 7.885e-16
Cconserve1487 vbn_sink vbp_cas 6.1071e-16
Cconserve1488 vbn_sink vbp_i 1.82491e-14
Cconserve1489 vbn_sink vbp_tail 1.51169e-15
Cconserve1490 vbn_sink vgn2 1.7331e-16
Cconserve1491 vbn_sink vsu 2.45374e-15
Cconserve1492 vbn_sink vsua 1.15008e-15
Cconserve1493 vbn_sink xf1 6.67601e-15
Cconserve1494 vbn_sink xf2 6.9701e-15
Cconserve1495 vbn_sink y1 1.23295e-15
Cconserve1496 vbp_bias vbp_cas 1.4834e-14
Cconserve1497 vbp_bias vbp_i 9.0238e-16
Cconserve1498 vbp_bias vbp_tail 3.0831e-16
Cconserve1499 vbp_bias vcasp 1.35528e-15
Cconserve1500 vbp_bias vgn1 3.4369e-16
Cconserve1501 vbp_bias vgn2 1.3232e-16
Cconserve1502 vbp_bias vq2 5.3956e-16
Cconserve1503 vbp_bias vq3 5.5054e-16
Cconserve1504 vsp vbp_bias 4.8005e-16
Cconserve1505 vbp_bias vsu1 8.9697e-16
Cconserve1506 vbp_bias vsua 4.1567e-16
Cconserve1507 vbp_bias xf1 2.6006e-16
Cconserve1508 vbp_bias xf2 3.2017e-16
Cconserve1509 vbp_bias y1 7.9323e-16
Cconserve1510 vbp_i vbp_cas 2.95803e-15
Cconserve1511 vbp_tail vbp_cas 1.4568e-16
Cconserve1512 vcasp vbp_cas 2.22645e-15
Cconserve1513 vbp_cas vgn1 1.21775e-15
Cconserve1514 vbp_cas vgn2 9.77084e-15
Cconserve1515 vq2 vbp_cas 1.1777e-16
Cconserve1516 vsu vbp_cas 1.2965e-15
Cconserve1517 vsua vbp_cas 3.58038e-15
Cconserve1518 xf2 vbp_cas 1.4767e-16
Cconserve1519 y1 vbp_cas 8.72994e-15
Cconserve1520 vbp_i vbp_tail 2.00872e-15
Cconserve1521 vbp_i vcasp 2.8897e-16
Cconserve1522 vbp_i vgn1 7.1025e-16
Cconserve1523 vbp_i vgn2 1.66359e-15
Cconserve1524 vbp_i vq3 1.93119e-15
Cconserve1525 vbp_i vref 1.6971e-16
Cconserve1526 vbp_i vsu 2.38741e-15
Cconserve1527 vbp_i vsu1 2.1392e-16
Cconserve1528 vbp_i vsu2 2.82303e-15
Cconserve1529 vsua vbp_i 1.30631e-15
Cconserve1530 vbp_i xf1 7.3622e-16
Cconserve1531 vbp_i y1 2.67429e-15
Cconserve1532 vsp vbp_tail 7.87899e-15
Cconserve1533 vsu vbp_tail 1.293e-16
Cconserve1534 vsua vbp_tail 1.2915e-15
Cconserve1535 vbp_tail xf1 4.2214e-16
Cconserve1536 xf2 vbp_tail 5.9954e-16
Cconserve1537 vcasp vgn1 1.20098e-14
Cconserve1538 vnx_bias vcasp 1.4922e-16
Cconserve1539 vcasp vq3 2.9662e-16
Cconserve1540 vcasp vref 4.61112e-15
Cconserve1541 vsu vcasp 1.6003e-16
Cconserve1542 vsu1 vcasp 1.96884e-15
Cconserve1543 vsu2 vcasp 1.3989e-16
Cconserve1544 vsua vcasp 6.6686e-16
Cconserve1545 vcasp vx1 4.40079e-15
Cconserve1546 vcasp vx2 4.74669e-15
Cconserve1547 vcasp vx3 4.7896e-15
Cconserve1548 vref vgn1 1.7203e-16
Cconserve1549 vsu1 vgn1 1.8706e-16
Cconserve1550 vgn1 vx1 1.70214e-15
Cconserve1551 vgn1 vx2 6.5346e-16
Cconserve1552 vx3 vgn1 1.0755e-16
Cconserve1553 xf2 vgn2 1.4172e-16
Cconserve1554 y1 vgn2 1.53651e-15
Cconserve1555 vsu vnx_bias 1.5585e-16
Cconserve1556 vq2 vq3 5.9576e-16
Cconserve1557 vsu vq2 1.8863e-16
Cconserve1558 vsua vq2 1.1273e-15
Cconserve1559 y1 vq3 1.40122e-15
Cconserve1560 vsu1 vref 6.9731e-16
Cconserve1561 vref vx1 5.9719e-16
Cconserve1562 vref vx2 3.4943e-16
Cconserve1563 vref vx3 1.98951e-15
Cconserve1564 vsp vsu 7.0595e-16
Cconserve1565 vsp vsua 1.4888e-16
Cconserve1566 vsp xf1 4.18477e-15
Cconserve1567 vsp xf2 5.00461e-15
Cconserve1568 vsu xf1 2.29109e-15
Cconserve1569 xf2 vsu 1.74246e-15
Cconserve1570 vsu1 vx2 4.737e-16
Cconserve1571 vsu1 vx3 1.8446e-16
Cconserve1572 vsua xf2 1.2641e-16
Cconserve1573 vsua y1 1.43812e-15
Cconserve1574 vx2 vx1 1.13125e-15
Cconserve1575 vx3 vx1 1.91562e-15
Cconserve1576 vx3 vx2 5.3405e-16
Cconserve1577 xf2 xf1 4.06665e-15
Cconserve1578 y1 xf1 3.57794e-15
Cconserve1579 xf2 y1 5.573e-16
.ends Bandgap_Core_Res
