* NGSPICE file created from Bandgap_Core_Res.ext - technology: gf180mcuD

.subckt Bandgap_Core_Res avdd avss vref b0 b1 b2 b3 b4 b5 b6 dvss dvdd net3 net4 v1
+ vq2 vq3
Xpnp_05p00x05p00_0 avss avss vq3 pnp_05p00x05p00
Xpnp_05p00x05p00_1 avss avss vq2 pnp_05p00x05p00
Xpnp_05p00x05p00_2 avss avss vq2 pnp_05p00x05p00
Xpnp_05p00x05p00_4 avss avss vq2 pnp_05p00x05p00
Xpnp_05p00x05p00_3 avss avss vq2 pnp_05p00x05p00
Xpnp_05p00x05p00_5 avss avss v1 pnp_05p00x05p00
Xpnp_05p00x05p00_6 avss avss vq2 pnp_05p00x05p00
Xpnp_05p00x05p00_7 avss avss vq2 pnp_05p00x05p00
Xpnp_05p00x05p00_8 avss avss vq2 pnp_05p00x05p00
Xpnp_05p00x05p00_9 avss avss vq2 pnp_05p00x05p00
Xnwell_0 net3 net4 avss nwell r_length=20.19u r_width=2u
X0 rbit0top b0 rbit1top dvss nfet_03v3 ad=17.6p pd=80.88u as=17.6p ps=80.88u w=40u l=0.28u M=2
X1 avdd avdd avdd avdd pfet_05v0 ad=24.1516p pd=0.11066m as=4.87322n ps=0.02258 w=54.89u l=4u M=29
X2 avss avss avss avss nfet_05v0 ad=3.322p pd=15.98u as=0.92119n ps=4.32012m w=7.55u l=4u M=10
X3 avss avss avss avss nfet_05v0 ad=7.1896p pd=33.56u as=0 ps=0 w=16.34u l=8u M=20
X4 avdd avdd avdd avdd pfet_05v0 ad=7.2248p pd=33.72u as=0 ps=0 w=16.42u l=4u M=34
X5 vbn_sink vbp_i avdd avdd pfet_05v0 ad=8.338p pd=38.78u as=8.338p ps=38.78u w=18.95u l=8u M=17
X6 avdd avdd avdd avdd pfet_05v0 ad=7.37p pd=34.38u as=0 ps=0 w=16.75u l=2u M=22
X7 avdd avdd avdd avdd pfet_05v0 ad=8.3556p pd=38.86u as=0 ps=0 w=18.99u l=8u M=20
X8 vbn_fold vbp_i avdd avdd pfet_05v0 ad=8.3556p pd=38.86u as=8.3556p ps=38.86u w=18.99u l=8u M=12
X9 b3_b b3 dvdd dvdd pfet_03v3 ad=1.32p pd=6.88u as=1.32p ps=6.88u w=3u l=0.5u
X10 vx1 psrg_m3_feed avdd avdd pfet_05v0 ad=7.37p pd=34.38u as=7.37p ps=34.38u w=16.75u l=2u M=6
X11 rbit3top b2_b rbit2top dvdd pfet_03v3 ad=8.8p pd=40.88u as=8.8p ps=40.88u w=20u l=0.28u M=3
X12 pm1 y1 avdd avdd pfet_05v0 ad=9.1344p pd=42.4u as=9.1344p ps=42.4u w=20.76u l=4u M=6
X13 vbn vbn avss avss nfet_05v0 ad=3.322p pd=15.98u as=3.322p ps=15.98u w=7.55u l=4u
X14 avdd avdd avdd avdd pfet_05v0 ad=8.25p pd=38.38u as=0 ps=0 w=18.75u l=8u M=29
X15 avdd avdd avdd avdd pfet_05v0 ad=8.338p pd=38.78u as=0 ps=0 w=18.95u l=8u M=23
X16 vgn2 vbn_fold xf2 avss nfet_05v0 ad=8.1356p pd=37.86u as=8.1356p ps=37.86u w=18.49u l=6u
X17 vbp_cas vbn_i avss avss nfet_05v0 ad=0.286p pd=2.18u as=0.286p ps=2.18u w=0.65u l=8u
X18 vbn_i vbp_i avdd avdd pfet_05v0 ad=8.25p pd=38.38u as=8.25p ps=38.38u w=18.75u l=8u M=5
X19 vgn2 vbp_cas pm2 avdd pfet_05v0 ad=9.7724p pd=45.3u as=9.7724p ps=45.3u w=22.21u l=8u M=6
X20 avdd avdd avdd avdd pfet_05v0 ad=9.1344p pd=42.4u as=0 ps=0 w=20.76u l=4u M=20
X21 vbn_fold vbn_fold vnx_bias avss nfet_05v0 ad=2.0328p pd=10.12u as=2.0328p ps=10.12u w=4.62u l=6u
X22 xf1 vbn_sink avss avss nfet_05v0 ad=7.1896p pd=33.56u as=7.1896p ps=33.56u w=16.34u l=8u M=6
X23 vgn1 aux_gate psrg_m3_feed avdd pfet_05v0 ad=0.88p pd=4.88u as=0.88p ps=4.88u w=2u l=2u
X24 rbit6top b5_b rbit5top dvdd pfet_03v3 ad=3.3p pd=15.88u as=3.3p ps=15.88u w=7.5u l=0.28u
X25 avdd avdd avdd avdd pfet_05v0 ad=9.7724p pd=45.3u as=0 ps=0 w=22.21u l=8u M=20
X26 rbit4top rbit3top avss ppolyf_u_1k r_width=6.6u r_length=16u
X27 avss avss avss avss nfet_05v0 ad=6.424p pd=30.08u as=0 ps=0 w=14.6u l=4u M=14
X28 vx3 psrg_m3_feed avdd avdd pfet_05v0 ad=7.37p pd=34.38u as=7.37p ps=34.38u w=16.75u l=2u M=6
X29 vaux psrg_m3_feed avdd avdd pfet_05v0 ad=4.4p pd=20.88u as=4.4p ps=20.88u w=10u l=2u M=2
X30 vbn aux_gate avdd avdd pfet_05v0 ad=0.22p pd=1.88u as=0.22p ps=1.88u w=0.5u l=8u
X31 rfix2 rfix1 avss ppolyf_u_1k r_width=6.6u r_length=0.128m
X32 vref vcasp vx3 avdd pfet_05v0 ad=7.2248p pd=33.72u as=7.2248p ps=33.72u w=16.42u l=4u M=5
X33 rbit6top rbit5top avss ppolyf_u_1k r_width=6.6u r_length=64u
X34 psrg_vnc psrg_vnc rb_mid avss nfet_05v0 ad=0.3124p pd=2.3u as=0.3124p ps=2.3u w=0.71u l=20u
X35 vx2 psrg_m3_feed avdd avdd pfet_05v0 ad=7.37p pd=34.38u as=7.37p ps=34.38u w=16.75u l=2u M=6
X36 psrg_m3_feed vcasp vx2 avdd pfet_05v0 ad=7.2248p pd=33.72u as=7.2248p ps=33.72u w=16.42u l=4u M=5
X37 b2_b b2 dvdd dvdd pfet_03v3 ad=1.32p pd=6.88u as=1.32p ps=6.88u w=3u l=0.5u
X38 y1 vbp_cas pm1 avdd pfet_05v0 ad=9.7724p pd=45.3u as=9.7724p ps=45.3u w=22.21u l=8u M=6
X39 avss avss avss avss nfet_05v0 ad=5.4164p pd=25.5u as=0 ps=0 w=12.31u l=8u M=10
X40 b5_b b5 dvdd dvdd pfet_03v3 ad=1.32p pd=6.88u as=1.32p ps=6.88u w=3u l=0.5u
X41 avss avss avss avss nfet_05v0 ad=8.1356p pd=37.86u as=0 ps=0 w=18.49u l=6u M=10
X42 vbp_i vbp_i avdd avdd pfet_05v0 ad=8.25p pd=38.38u as=8.25p ps=38.38u w=18.75u l=8u M=5
X43 vbp_bias vbp_bias avdd avdd pfet_03v3 ad=8.3864p pd=39u as=8.3864p ps=39u w=19.06u l=8u M=9
X44 xf2 vbn_sink avss avss nfet_05v0 ad=7.1896p pd=33.56u as=7.1896p ps=33.56u w=16.34u l=8u M=6
X45 vref avss cap_mim_2f0_m4m5_noshield c_width=70.7u c_length=70.7u
X46 rbit1top b0_b rbit0top dvdd pfet_03v3 ad=17.6p pd=80.88u as=17.6p ps=80.88u w=40u l=0.28u M=6
X47 vbn_i iref_gate avdd avdd pfet_05v0 ad=0.22p pd=1.88u as=0.22p ps=1.88u w=0.5u l=8u
X48 vref avss cap_mim_2f0_m4m5_noshield c_width=70.7u c_length=70.7u
X49 iref_gate vbp_i vsu1 avss nfet_05v0 ad=0.22p pd=1.88u as=0.22p ps=1.88u w=0.5u l=50u
X50 rbit0top rfix2 avss ppolyf_u_1k r_width=6.6u r_length=0.128m
X51 vsp vbp_tail avdd avdd pfet_03v3 ad=12.7204p pd=58.7u as=12.7204p ps=58.7u w=28.91u l=6u M=6
X52 rbit4top b3_b rbit3top dvdd pfet_03v3 ad=13.2p pd=60.88u as=13.2p ps=60.88u w=30u l=0.28u
X53 su_state vsu avdd avdd pfet_05v0 ad=0.44p pd=2.88u as=0.44p ps=2.88u w=1u l=8u
X54 rbit5top b4_b rbit4top dvdd pfet_03v3 ad=6.6p pd=30.88u as=6.6p ps=30.88u w=15u l=0.28u
X55 xf1 v1 vsp avdd pfet_05v0 ad=24.1516p pd=0.11066m as=24.1516p ps=0.11066m w=54.89u l=4u M=5
X56 rbit2top b1_b rbit1top dvdd pfet_03v3 ad=17.6p pd=80.88u as=17.6p ps=80.88u w=40u l=0.28u M=3
X57 psrg_m3_feed psrg_vnc psrg_m3_protected avss nfet_05v0 ad=6.424p pd=30.08u as=6.424p ps=30.08u w=14.6u l=4u M=2
X58 rbit4top b4 rbit5top dvss nfet_03v3 ad=2.2p pd=10.88u as=2.2p ps=10.88u w=5u l=0.28u
X59 vbn_sink vbn_sink avss avss nfet_05v0 ad=5.4164p pd=25.5u as=5.4164p ps=25.5u w=12.31u l=8u M=2
X60 vbp_tail vbp_tail avdd avdd pfet_03v3 ad=6.05p pd=28.38u as=6.05p ps=28.38u w=13.75u l=6u M=3
X61 vbp_cas vbp_cas vbp_bias avdd pfet_05v0 ad=8.3292p pd=38.74u as=8.3292p ps=38.74u w=18.93u l=8u M=10
X62 pm2 y1 avdd avdd pfet_05v0 ad=9.1344p pd=42.4u as=9.1344p ps=42.4u w=20.76u l=4u M=6
X63 xf2 v2 vsp avdd pfet_05v0 ad=24.1516p pd=0.11066m as=24.1516p ps=0.11066m w=54.89u l=4u M=5
X64 su_state vbp_tail avdd avdd pfet_05v0 ad=0.44p pd=2.88u as=0.44p ps=2.88u w=1u l=8u
X65 psrg_vnc vbp_i avdd avdd pfet_05v0 ad=7.8056p pd=36.36u as=7.8056p ps=36.36u w=17.74u l=4u M=7
X66 vcasp vcasp avdd avdd pfet_05v0 ad=0.396p pd=2.68u as=0.396p ps=2.68u w=0.9u l=2u
X67 rfix0 vref avss ppolyf_u_1k r_width=6.6u r_length=0.128m
X68 vsu2 vbp_i avss avss nfet_05v0 ad=0.22p pd=1.88u as=0.22p ps=1.88u w=0.5u l=50u
X69 rbit3top rbit2top avss ppolyf_u_1k r_width=6.6u r_length=8u
X70 vref avss cap_mim_2f0_m4m5_noshield c_width=70.7u c_length=70.7u
X71 vref avss cap_mim_2f0_m4m5_noshield c_width=70.7u c_length=70.7u
X72 rfix1 rfix0 avss ppolyf_u_1k r_width=6.6u r_length=0.128m
X73 avss net3 avdd pplus_u r_width=1u r_length=0.23253m
X74 vbn_i vbn_i avss avss nfet_05v0 ad=3.4232p pd=16.44u as=3.4232p ps=16.44u w=7.78u l=8u
X75 y1 psrg_vnc psrg_mf1_protected avss nfet_05v0 ad=8.1356p pd=37.86u as=8.1356p ps=37.86u w=18.49u l=6u
X76 vq2 v2 avss ppolyf_u_1k r_width=4u r_length=42.1u
X77 vbp_i vbn_i net4 avss nfet_05v0 ad=4.0172p pd=19.14u as=4.0172p ps=19.14u w=9.13u l=8u
X78 rbit3top b3 rbit4top dvss nfet_03v3 ad=4.4p pd=20.88u as=4.4p ps=20.88u w=10u l=0.28u
X79 vbp_tail vbn_i avss avss nfet_05v0 ad=6.138p pd=28.78u as=6.138p ps=28.78u w=13.95u l=8u
X80 vsua vsua auxsu1 avss nfet_05v0 ad=0.44p pd=2.88u as=0.44p ps=2.88u w=1u l=2u
X81 vgn2 avss cap_mim_2f0_m4m5_noshield c_width=59u c_length=59u
X82 b3_b b3 dvss dvss nfet_03v3 ad=0.44p pd=2.88u as=0.44p ps=2.88u w=1u l=0.5u
X83 b5_b b5 dvss dvss nfet_03v3 ad=0.44p pd=2.88u as=0.44p ps=2.88u w=1u l=0.5u
X84 b6_b b6 dvdd dvdd pfet_03v3 ad=1.32p pd=6.88u as=1.32p ps=6.88u w=3u l=0.5u
X85 psrg_mf1_protected vbn_fold xf1 avss nfet_05v0 ad=8.1356p pd=37.86u as=8.1356p ps=37.86u w=18.49u l=6u
X86 bgsu1 bgsu1 bgsu2 avss nfet_03v3 ad=0.44p pd=2.88u as=0.44p ps=2.88u w=1u l=2u
X87 vgn1 vcasp vx1 avdd pfet_05v0 ad=7.2248p pd=33.72u as=7.2248p ps=33.72u w=16.42u l=4u M=5
X88 b1_b b1 dvdd dvdd pfet_03v3 ad=1.32p pd=6.88u as=1.32p ps=6.88u w=3u l=0.5u
X89 iref_gate vbp_i avdd avdd pfet_05v0 ad=35.2p pd=0.16088m as=35.2p ps=0.16088m w=80u l=1u M=2
X90 vq3 rbit6top avss ppolyf_u_1k r_width=6.6u r_length=0.128m
X91 vgn1 vgn1 v1 avss nfet_05v0 ad=6.424p pd=30.08u as=6.424p ps=30.08u w=14.6u l=4u M=2
X92 vq3 b6_b rbit6top dvdd pfet_03v3 ad=1.65p pd=8.38u as=1.65p ps=8.38u w=3.75u l=0.28u
X93 psrg_m3_protected vgn2 v2 avss nfet_05v0 ad=6.424p pd=30.08u as=6.424p ps=30.08u w=14.6u l=4u M=2
X94 rbit2top b2 rbit3top dvss nfet_03v3 ad=8.8p pd=40.88u as=8.8p ps=40.88u w=20u l=0.28u
X95 vsu psrg_m3_feed avdd avdd pfet_05v0 ad=0.88p pd=4.88u as=0.88p ps=4.88u w=2u l=2u
X96 vref avss cap_mim_2f0_m4m5_noshield c_width=70.7u c_length=70.7u
X97 rbit5top b5 rbit6top dvss nfet_03v3 ad=1.1p pd=5.88u as=1.1p ps=5.88u w=2.5u l=0.28u
X98 vref avss cap_mim_2f0_m4m5_noshield c_width=70.7u c_length=70.7u
X99 rbit1top rbit0top avss ppolyf_u_1k r_width=6.6u r_length=2u
X100 vref avss cap_mim_2f0_m4m5_noshield c_width=70.7u c_length=70.7u
X101 vref avss cap_mim_2f0_m4m5_noshield c_width=70.7u c_length=70.7u
X102 b4_b b4 dvdd dvdd pfet_03v3 ad=1.32p pd=6.88u as=1.32p ps=6.88u w=3u l=0.5u
X103 vnx_bias vnx_bias avss avss nfet_03v3 ad=0.7128p pd=4.12u as=0.7128p ps=4.12u w=1.62u l=8u
X104 vbn vcasp vaux avdd pfet_05v0 ad=7.04p pd=32.88u as=7.04p ps=32.88u w=16u l=4u
X105 b1_b b1 dvss dvss nfet_03v3 ad=0.44p pd=2.88u as=0.44p ps=2.88u w=1u l=0.5u
X106 rbit1top b1 rbit2top dvss nfet_03v3 ad=17.6p pd=80.88u as=17.6p ps=80.88u w=40u l=0.28u
X107 vsu vsu bgsu1 avss nfet_05v0 ad=0.44p pd=2.88u as=0.44p ps=2.88u w=1u l=2u
X108 b4_b b4 dvss dvss nfet_03v3 ad=0.44p pd=2.88u as=0.44p ps=2.88u w=1u l=0.5u
X109 aux_gate vbn_i avss avss nfet_05v0 ad=0.44p pd=2.88u as=0.44p ps=2.88u w=1u l=8u
X110 rb_mid rb_mid avss avss nfet_05v0 ad=0.2376p pd=1.96u as=0.2376p ps=1.96u w=0.54u l=20u
X111 b0_b b0 dvss dvss nfet_03v3 ad=0.44p pd=2.88u as=0.44p ps=2.88u w=1u l=0.5u
X112 rbit6top b6 vq3 dvss nfet_03v3 ad=0.55p pd=3.38u as=0.55p ps=3.38u w=1.25u l=0.28u
X113 vref avss cap_mim_2f0_m4m5_noshield c_width=70.7u c_length=70.7u
X114 vref avss cap_mim_2f0_m4m5_noshield c_width=70.7u c_length=70.7u
X115 vsua vcasp avdd avdd pfet_05v0 ad=0.88p pd=4.88u as=0.88p ps=4.88u w=2u l=2u
X116 b6_b b6 dvss dvss nfet_03v3 ad=0.44p pd=2.88u as=0.44p ps=2.88u w=1u l=0.5u
X117 vsu1 vbp_i vsu2 avss nfet_05v0 ad=0.22p pd=1.88u as=0.22p ps=1.88u w=0.5u l=50u
X118 bgsu2 bgsu2 avss avss nfet_03v3 ad=0.44p pd=2.88u as=0.44p ps=2.88u w=1u l=2u
X119 vcasp vbn avss avss nfet_05v0 ad=3.322p pd=15.98u as=3.322p ps=15.98u w=7.55u l=4u
X120 b2_b b2 dvss dvss nfet_03v3 ad=0.44p pd=2.88u as=0.44p ps=2.88u w=1u l=0.5u
X121 su_state vgn2 avss avss nfet_05v0 ad=1.76p pd=8.88u as=1.76p ps=8.88u w=4u l=1u
X122 rbit5top rbit4top avss ppolyf_u_1k r_width=6.6u r_length=32u
X123 auxsu1 auxsu1 auxsu2 avss nfet_03v3 ad=0.44p pd=2.88u as=0.44p ps=2.88u w=1u l=2u
X124 b0_b b0 dvdd dvdd pfet_03v3 ad=1.32p pd=6.88u as=1.32p ps=6.88u w=3u l=0.5u
X125 rbit2top rbit1top avss ppolyf_u_1k r_width=6.6u r_length=4u
X126 aux_gate vcasp avdd avdd pfet_05v0 ad=0.22p pd=1.88u as=0.22p ps=1.88u w=0.5u l=10u
X127 auxsu2 auxsu2 avss avss nfet_03v3 ad=0.44p pd=2.88u as=0.44p ps=2.88u w=1u l=2u
C0 v1 vcasp 0.94113f
C1 vbn_fold su_state 0.54084f
C2 rbit6top vref 0.1484f
C3 vgn1 vgn2 5.07749f
C4 dvdd b3_b 0.98607f
C5 rfix1 rfix2 0.12712f
C6 avdd iref_gate 20.4793f
C7 psrg_m3_feed psrg_mf1_protected 0.11778f
C8 vaux vcasp 5.42532f
C9 vq3 b1 0.61141f
C10 b5_b rbit6top 0.17822f
C11 net3 su_state 10.7117f
C12 v2 vnx_bias 0.12642f
C13 xf2 vsp 4.80498f
C14 b5 rbit1top 0.26006f
C15 b5 vref 0.2878f
C16 rfix1 rfix0 0.12694f
C17 rbit2top dvss 3.84354f
C18 vbp_tail vbp_bias 0.96899f
C19 b3 rbit6top 0.27467f
C20 rb_mid vbn_i 1.82048f
C21 vbn_fold net3 0.23215f
C22 b1 rbit0top 0.3846f
C23 b5_b b5 0.71797f
C24 net4 v2 0.11332f
C25 vgn2 pm1 1.18258f
C26 rbit4top dvdd 5.37254f
C27 dvdd rbit5top 3.45499f
C28 aux_gate vbp_bias 1.29161f
C29 vbp_cas vgn2 9.81598f
C30 b2 dvdd 2.80728f
C31 b3 b5 0.54286f
C32 vx2 vref 0.93047f
C33 aux_gate y1 0.37334f
C34 psrg_m3_feed v1 0.2688f
C35 iref_gate pm2 1.462f
C36 vgn1 psrg_vnc 0.42512f
C37 vgn1 avdd 19.8017f
C38 b1_b b1 2.00112f
C39 psrg_m3_feed vaux 1.13504f
C40 rb_mid vbp_i 0.18995f
C41 rbit4top rfix0 0.5693f
C42 vsu1 vnx_bias 0.61064f
C43 b4 b3_b 0.37929f
C44 b1 rbit1top 0.8303f
C45 b1 vref 0.51763f
C46 vbp_tail vsp 7.83306f
C47 vbp_tail vcasp 0.53827f
C48 pm1 avdd 31.763f
C49 v1 v2 18.6242f
C50 rbit6top dvss 0.95852f
C51 vbp_cas avdd 88.6687f
C52 vbp_bias vbp_i 0.35309f
C53 b3 b1 0.14443f
C54 vbp_bias vref 1.13648f
C55 rbit4top b0_b 0.10611f
C56 b6 rbit6top 0.21217f
C57 b0_b rbit5top 0.12174f
C58 vaux v2 0.17419f
C59 b2 b0_b 0.4976f
C60 rbit3top b0 0.26929f
C61 b5 dvss 1.9132f
C62 rbit4top b4 0.15644f
C63 rbit5top b4 0.33512f
C64 xf2 v2 11.5641f
C65 b2 b4 0.12242f
C66 vcasp vbn_i 0.24227f
C67 b5 b6 0.74946f
C68 aux_gate bgsu1 0.11782f
C69 vx3 avdd 25.8418f
C70 vsu2 auxsu1 0.34171f
C71 b0 rbit0top 1.30134f
C72 vgn2 vbn_sink 1.02932f
C73 pm1 pm2 4.91378f
C74 vbp_cas pm2 9.40883f
C75 vbn_i bgsu1 7.29036f
C76 vsua vsu 0.45111f
C77 aux_gate psrg_m3_feed 0.28976f
C78 rbit6top b6_b 0.13315f
C79 vgn1 vx2 0.72762f
C80 vgn2 psrg_vnc 0.25864f
C81 vgn2 avdd 19.8076f
C82 b1_b b0 0.11519f
C83 vcasp vbp_i 0.81571f
C84 vcasp vref 8.70622f
C85 psrg_m3_feed vbn_i 1.96445f
C86 dvss b1 1.55352f
C87 b5 b4_b 0.51793f
C88 rbit1top b0 0.95698f
C89 vbp_tail v2 0.20576f
C90 vbn_sink avdd 41.2053f
C91 vbn_fold vnx_bias 3.59657f
C92 su_state vbn 0.14211f
C93 vgn1 auxsu1 0.11695f
C94 su_state vsu 0.2468f
C95 b3 b0 0.11624f
C96 b2_b b3_b 0.18346f
C97 vq2 su_state 0.14322f
C98 vcasp vsu2 0.28319f
C99 v1 xf1 10.8469f
C100 vgn2 pm2 1.54129f
C101 rbit3top dvdd 9.08123f
C102 psrg_m3_feed vbp_i 0.18956f
C103 vbn_i v2 0.65383f
C104 vq3 dvdd 2.5307f
C105 vbn_fold vsu 1.15965f
C106 psrg_m3_feed vref 2.17415f
C107 psrg_vnc avdd 16.32234f
C108 vgn1 psrg_m3_protected 0.56942f
C109 vsp iref_gate 0.10677f
C110 vx3 vx2 2.72171f
C111 vsu2 bgsu1 0.30458f
C112 xf2 xf1 15.3018f
C113 vbn_fold psrg_mf1_protected 1.13136f
C114 dvdd rbit0top 18.2143f
C115 b4_b b1 0.21295f
C116 vq3 rfix2 0.19915f
C117 rbit4top b2_b 0.17164f
C118 net3 vq2 0.1153f
C119 rbit5top b2_b 0.25686f
C120 b2 b2_b 0.6365f
C121 vq3 rfix0 0.48937f
C122 rbit2top rbit6top 0.27768f
C123 vbp_cas vbp_bias 14.5859f
C124 rfix2 rbit0top 0.24932f
C125 pm1 y1 10.8108f
C126 v2 vbp_i 1.20932f
C127 vbp_cas y1 8.24885f
C128 rfix0 rbit0top 0.20304f
C129 dvdd b1_b 1.71207f
C130 avdd pm2 34.7474f
C131 dvss b0 2.19903f
C132 vgn1 vcasp 5.27291f
C133 dvdd rbit1top 25.2992f
C134 dvdd vref 4.32753f
C135 vbn_fold xf2 1.19048f
C136 vq3 b4 0.12386f
C137 b5_b dvdd 0.80288f
C138 vgn2 auxsu1 0.12252f
C139 b0_b rbit0top 2.37512f
C140 rfix2 vref 0.48703f
C141 v2 vsu2 0.71053f
C142 b3 dvdd 2.20359f
C143 b4 rbit0top 0.35802f
C144 aux_gate xf1 0.47934f
C145 vbp_cas vcasp 3.14978f
C146 vref rfix0 0.48258f
C147 vx2 avdd 26.654f
C148 vsu2 bgsu2 0.27649f
C149 vgn2 psrg_m3_protected 1.66548f
C150 v2 iref_gate 0.45614f
C151 vsu1 vbp_i 0.3328f
C152 vgn2 y1 1.33328f
C153 vgn1 psrg_m3_feed 10.9294f
C154 rbit2top b1 0.99261f
C155 rbit4top b3_b 0.28591f
C156 b5 rbit6top 0.23277f
C157 rb_mid psrg_vnc 0.26276f
C158 rb_mid avdd 0.90172f
C159 vx1 vref 0.7335f
C160 vx3 vcasp 5.64491f
C161 vbp_tail su_state 4.41393f
C162 b0_b rbit1top 2.10468f
C163 b0_b vref 0.46432f
C164 su_state vq3 0.10044f
C165 psrg_vnc auxsu1 0.21772f
C166 auxsu1 avdd 1.24504f
C167 aux_gate su_state 0.64858f
C168 vbn_fold vbp_tail 0.50114f
C169 b4 rbit1top 0.30277f
C170 b4 vref 0.32122f
C171 vbp_cas psrg_m3_feed 5.05719f
C172 rbit4top rbit5top 2.58032f
C173 vbn_fold vq3 2.09264f
C174 aux_gate vbn_fold 9.8337f
C175 vgn1 v2 2.08526f
C176 b5_b b4 2.31201f
C177 vbp_bias avdd 71.3574f
C178 rbit4top b2 0.11838f
C179 net3 vbp_tail 3.21059f
C180 b2 rbit5top 0.15945f
C181 b3 b0_b 0.45596f
C182 psrg_m3_protected psrg_vnc 1.42805f
C183 su_state vbn_i 0.49605f
C184 dvdd dvss 6.13982f
C185 vgn2 vcasp 0.38385f
C186 psrg_vnc y1 0.72307f
C187 avdd y1 50.1922f
C188 b3 b4 2.21325f
C189 dvdd b6 2.30224f
C190 vbn_fold vbn_i 0.27506f
C191 psrg_m3_feed vx3 4.77775f
C192 net3 vbn_i 0.22221f
C193 vbp_cas v2 2.26622f
C194 vbn vsu 0.35311f
C195 rbit3top b2_b 1.34317f
C196 vq3 b2_b 0.16987f
C197 su_state vbp_i 0.19864f
C198 su_state vref 0.16807f
C199 vbn psrg_mf1_protected 0.14469f
C200 rbit2top b0 0.53646f
C201 y1 pm2 8.82479f
C202 vgn2 psrg_m3_feed 0.35919f
C203 vsp avdd 73.6319f
C204 vcasp psrg_vnc 14.1901f
C205 vbn_fold vbp_i 12.8191f
C206 vcasp avdd 46.8557f
C207 dvdd b6_b 0.89872f
C208 vbn_fold vref 0.54296f
C209 dvdd b4_b 2.04749f
C210 v1 vnx_bias 0.13281f
C211 b0_b dvss 1.14456f
C212 net3 vbp_i 0.27883f
C213 vgn1 vx1 3.76652f
C214 net3 vref 0.11361f
C215 dvss b4 1.49472f
C216 psrg_vnc bgsu1 1.53991f
C217 avdd bgsu1 1.40615f
C218 b0_b b6 0.231f
C219 vaux vnx_bias 0.11873f
C220 net4 v1 0.19431f
C221 b6 b4 0.12575f
C222 rb_mid auxsu1 0.15762f
C223 vgn2 v2 3.00028f
C224 vq2 v1 0.4327f
C225 su_state iref_gate 9.44851f
C226 psrg_m3_feed psrg_vnc 8.96492f
C227 psrg_m3_feed avdd 54.7634f
C228 net3 vsu2 0.13418f
C229 vbn_fold iref_gate 1.81815f
C230 rbit6top b0 0.37638f
C231 b3 b2_b 0.86019f
C232 rbit3top b3_b 0.50673f
C233 b6_b b4 0.21254f
C234 vq3 b3_b 0.51249f
C235 b4_b b4 0.44717f
C236 xf1 pm1 0.25267f
C237 vx3 vx1 6.5981f
C238 rfix1 rbit0top 0.23203f
C239 v2 psrg_vnc 0.83259f
C240 dvdd rbit2top 14.9437f
C241 vcasp vx2 5.49619f
C242 v2 avdd 19.3659f
C243 v1 vaux 0.90149f
C244 rbit4top rbit3top 4.12866f
C245 v1 xf2 0.85722f
C246 rbit3top rbit5top 5.75012f
C247 rbit2top rfix2 0.47492f
C248 rbit4top vq3 0.25004f
C249 rbit3top b2 0.28452f
C250 vq3 rbit5top 0.37529f
C251 vq3 b2 0.53362f
C252 vcasp rb_mid 0.41312f
C253 rbit2top rfix0 0.46931f
C254 aux_gate vbn 0.13675f
C255 rbit5top rbit0top 0.19532f
C256 vbp_tail vq2 0.51793f
C257 rfix1 vref 0.48168f
C258 vbn_i vnx_bias 4.3608f
C259 b2 rbit0top 0.28679f
C260 vcasp auxsu1 0.45799f
C261 aux_gate vsu 0.18683f
C262 rb_mid bgsu1 0.10425f
C263 b2_b dvss 1.29017f
C264 b1 b0 0.28169f
C265 vq2 vq3 1.38448f
C266 psrg_m3_feed vx2 5.74429f
C267 net4 vbn_i 0.51306f
C268 vgn2 xf1 1.1941f
C269 auxsu1 bgsu1 4.12461f
C270 b5_b b3_b 0.10598f
C271 vsu1 avdd 0.54885f
C272 rbit2top b0_b 0.12093f
C273 b1_b rbit5top 0.15391f
C274 dvdd rbit6top 3.48836f
C275 rbit2top b4 0.14143f
C276 vbn_i psrg_mf1_protected 0.21759f
C277 vx1 avdd 25.4361f
C278 vbp_tail v1 0.40675f
C279 xf1 vbn_sink 6.56293f
C280 rbit4top vref 0.22388f
C281 rbit5top vref 0.10632f
C282 b5 dvdd 1.97331f
C283 b2 rbit1top 0.59167f
C284 b2 vref 0.27624f
C285 y1 bgsu1 0.1124f
C286 psrg_m3_feed auxsu1 0.40763f
C287 v1 vq3 0.48977f
C288 b5_b rbit5top 0.32349f
C289 rbit6top rfix0 2.51098f
C290 vsua avdd 0.86767f
C291 vgn2 su_state 1.80937f
C292 rbit4top b3 2.00367f
C293 b3 rbit5top 0.31365f
C294 b2 b3 0.52826f
C295 psrg_m3_feed psrg_m3_protected 0.70719f
C296 xf1 avdd 34.0549f
C297 v1 vbn_i 0.39536f
C298 aux_gate xf2 2.5748f
C299 vbn_fold vgn2 2.45922f
C300 rb_mid v2 0.24166f
C301 auxsu2 vsu2 0.3506f
C302 su_state vbn_sink 0.12828f
C303 net3 vgn2 0.12429f
C304 b0_b rbit6top 0.45445f
C305 vcasp bgsu1 1.07063f
C306 vbn_fold vbn_sink 3.89325f
C307 dvss b3_b 0.44394f
C308 dvdd b1 1.9632f
C309 auxsu1 bgsu2 0.2998f
C310 vbp_bias v2 0.40782f
C311 b5 b0_b 0.18986f
C312 b6 b3_b 0.28826f
C313 v1 vbp_i 0.13447f
C314 psrg_m3_protected v2 1.98711f
C315 su_state avdd 5.65378f
C316 b5 b4 0.42193f
C317 psrg_m3_feed vcasp 8.83225f
C318 vaux vbp_i 0.34518f
C319 vbn_fold avdd 40.9953f
C320 vx1 vx2 6.69267f
C321 rbit4top dvss 2.4366f
C322 rbit5top dvss 1.32184f
C323 b2 dvss 1.49362f
C324 vbp_tail vq3 0.54049f
C325 rb_mid vsu1 0.15385f
C326 rbit4top b6 0.35582f
C327 rbit5top b6 0.169f
C328 net3 avdd 2.5941f
C329 psrg_m3_feed bgsu1 12.1311f
C330 rbit3top vq3 1.08791f
C331 rbit2top b2_b 0.62978f
C332 v1 vsu2 0.71014f
C333 b6_b b3_b 0.10274f
C334 vbp_tail vbn_i 1.51389f
C335 b4_b b3_b 0.12044f
C336 rbit3top rbit0top 0.19853f
C337 vsp v2 11.0642f
C338 vq3 rbit0top 0.43158f
C339 vcasp v2 0.49384f
C340 vbn_i vq3 0.25919f
C341 aux_gate vbn_i 0.56758f
C342 v1 iref_gate 0.16482f
C343 vsua auxsu1 0.11093f
C344 rbit4top b4_b 0.52889f
C345 rbit5top b4_b 0.64681f
C346 xf2 iref_gate 5.31953f
C347 vq3 b1_b 0.46662f
C348 vbp_tail vbp_i 2.59405f
C349 dvdd b0 2.25472f
C350 vbp_tail vref 2.93673f
C351 bgsu2 bgsu1 0.30326f
C352 rbit3top vref 0.1028f
C353 vbp_i vq3 0.38823f
C354 rbit3top rbit1top 0.1245f
C355 vq3 vref 35.6054f
C356 vq3 rbit1top 0.74463f
C357 aux_gate vref 0.49479f
C358 vsua y1 0.13441f
C359 psrg_m3_feed v2 0.14733f
C360 rbit6top b2_b 0.25905f
C361 vgn1 v1 2.18705f
C362 b5_b rbit3top 0.10112f
C363 b5_b vq3 0.20329f
C364 rbit1top rbit0top 17.4997f
C365 vref rbit0top 2.59934f
C366 vbn_i vbp_i 7.65063f
C367 vcasp vsu1 0.77783f
C368 rbit3top b3 0.36575f
C369 rbit2top rfix1 0.47013f
C370 vbn_i vref 0.15089f
C371 vq3 b3 0.73433f
C372 vbp_tail vsu2 1.18175f
C373 vx1 vcasp 5.11514f
C374 vgn2 vnx_bias 0.46695f
C375 b3 rbit0top 0.5252f
C376 vbp_cas v1 2.35996f
C377 vbp_tail iref_gate 0.86895f
C378 su_state vbp_bias 1.0293f
C379 b1_b rbit1top 1.0224f
C380 b1_b vref 0.46737f
C381 vcasp vsua 0.38806f
C382 b0_b b0 1.57273f
C383 aux_gate iref_gate 9.00756f
C384 vbn_i vsu2 0.30498f
C385 xf1 vsp 4.97169f
C386 b5_b b1_b 0.24169f
C387 vbp_i vref 0.26276f
C388 rbit1top vref 2.44423f
C389 rbit4top rbit2top 1.33249f
C390 rbit2top rbit5top 0.13796f
C391 b2 rbit2top 0.27743f
C392 vgn2 psrg_mf1_protected 0.10811f
C393 vbn_fold y1 0.16495f
C394 vsua bgsu1 0.13226f
C395 net3 vbp_bias 1.20203f
C396 vbn_i iref_gate 0.44342f
C397 psrg_m3_feed vx1 5.51197f
C398 b2_b b1 0.16487f
C399 psrg_vnc vnx_bias 0.15984f
C400 vnx_bias avdd 0.74378f
C401 b3 vref 0.16929f
C402 b3 rbit1top 0.38125f
C403 rbit3top dvss 2.47236f
C404 vq3 dvss 0.88599f
C405 rbit3top b6 0.22366f
C406 psrg_vnc vbn 14.1477f
C407 b5_b b3 0.1781f
C408 vbn avdd 2.01557f
C409 vbp_i vsu2 1.93283f
C410 vq3 b6 0.52063f
C411 net4 avdd 1.14374f
C412 rbit6top b3_b 0.26035f
C413 su_state vsp 0.31701f
C414 vgn2 v1 0.30453f
C415 dvss rbit0top 7.87695f
C416 vgn1 aux_gate 0.11923f
C417 avdd vsu 3.72251f
C418 v2 vsu1 0.11888f
C419 vbp_i iref_gate 3.93968f
C420 b6 rbit0top 0.35994f
C421 b5 b3_b 0.14928f
C422 vbn_fold vcasp 0.63195f
C423 psrg_vnc psrg_mf1_protected 0.86885f
C424 vgn2 xf2 1.4832f
C425 vgn1 vbn_i 15.2543f
C426 net3 vsp 0.40118f
C427 rbit4top rbit6top 0.59917f
C428 rbit5top rbit6top 1.10162f
C429 b1_b dvss 0.40119f
C430 b2 rbit6top 0.32719f
C431 vbn_fold bgsu1 0.14888f
C432 rbit3top b6_b 0.10124f
C433 rbit3top b4_b 0.16324f
C434 vq3 b6_b 0.44449f
C435 b1_b b6 0.18908f
C436 xf2 vbn_sink 6.71667f
C437 dvdd b0_b 4.14987f
C438 b5 rbit5top 0.18324f
C439 b2 b5 0.9131f
C440 dvss rbit1top 8.40737f
C441 dvss vref 0.17802f
C442 xf1 v2 1.25868f
C443 dvdd b4 2.36894f
C444 v1 psrg_vnc 0.25631f
C445 v1 avdd 20.74693f
C446 b6 rbit1top 0.3938f
C447 b5_b dvss 1.3604f
C448 vgn1 vref 1.04938f
C449 vaux psrg_vnc 1.04986f
C450 vaux avdd 4.17403f
C451 b3 dvss 2.17826f
C452 b5_b b6 0.12061f
C453 b1 b3_b 0.19763f
C454 b2_b b0 0.66587f
C455 xf2 avdd 30.956f
C456 b3 b6 0.90951f
C457 b1_b b4_b 0.13055f
C458 rb_mid vnx_bias 0.13229f
C459 vbp_cas vbp_i 0.41282f
C460 aux_gate vgn2 0.82162f
C461 rb_mid vbn 0.16643f
C462 auxsu2 auxsu1 0.20281f
C463 vbp_tail vbn_sink 2.38604f
C464 b2 b1 0.61748f
C465 vnx_bias auxsu1 8.71994f
C466 b5_b b6_b 0.12883f
C467 vgn2 vbn_i 1.16074f
C468 b0_b b4 0.21404f
C469 b5_b b4_b 0.1403f
C470 xf2 pm2 0.45658f
C471 vq3 vbn_sink 0.19963f
C472 vbn auxsu1 12.9803f
C473 b3 b6_b 0.12306f
C474 vx3 vref 2.39972f
C475 rbit3top rbit2top 5.74144f
C476 b3 b4_b 0.1346f
C477 vq3 rbit2top 0.51692f
C478 vbp_tail avdd 37.7707f
C479 rbit2top rbit0top 1.73035f
C480 b6 dvss 1.76049f
C481 vq3 avdd 16.2509f
C482 vbn_i rbit2top 0.16636f
C483 vbp_cas iref_gate 0.78455f
C484 aux_gate avdd 11.3113f
C485 vgn2 vbp_i 0.21338f
C486 y1 vsu 0.11928f
C487 v1 rb_mid 0.17038f
C488 vbn_i psrg_vnc 1.64743f
C489 dvdd b2_b 2.9187f
C490 vbn_i avdd 17.854f
C491 b1_b rbit2top 1.0123f
C492 vbp_i vbn_sink 18.381f
C493 vaux rb_mid 0.24947f
C494 vcasp vnx_bias 0.79133f
C495 dvss b6_b 1.414f
C496 rbit2top vref 2.42452f
C497 rbit2top rbit1top 9.86141f
C498 rbit3top rbit6top 0.73333f
C499 b4_b dvss 1.03305f
C500 aux_gate pm2 1.75448f
C501 vcasp vbn 2.53988f
C502 vq3 rbit6top 1.81815f
C503 rbit4top b0 0.27314f
C504 rbit5top b0 0.65409f
C505 v1 vbp_bias 1.3071f
C506 vbp_cas vgn1 1.53672f
C507 b2 b0 0.23544f
C508 b6 b6_b 0.46004f
C509 v1 psrg_m3_protected 0.61706f
C510 vnx_bias bgsu1 16.5525f
C511 vbn_fold vsua 0.33308f
C512 b6 b4_b 0.18235f
C513 vbp_i psrg_vnc 6.7663f
C514 vbp_i avdd 0.20616p
C515 rbit3top b5 0.11617f
C516 avdd vref 28.1537f
C517 rbit6top rbit0top 0.1802f
C518 vbn_i pm2 0.17298f
C519 vq3 b5 0.23596f
C520 vbn_fold xf1 4.275f
C521 vgn2 iref_gate 0.13704f
C522 vaux psrg_m3_protected 0.12928f
C523 vbn bgsu1 8.42495f
C524 vcasp psrg_mf1_protected 0.17385f
C525 vbp_cas pm1 9.1631f
C526 bgsu1 vsu 0.17301f
C527 vgn1 vx3 1.01119f
C528 b5 rbit0top 0.31087f
C529 psrg_m3_feed vnx_bias 0.71126f
C530 b0_b b2_b 0.36378f
C531 vbn_sink iref_gate 0.5317f
C532 b1_b rbit6top 0.61487f
C533 psrg_m3_feed vbn 0.16912f
C534 vbp_tail rb_mid 0.61251f
C535 b4_b b6_b 0.39921f
C536 vsu2 avdd 0.63463f
C537 v1 vsp 10.877f
C538 dvss avss 37.7849f
C539 avdd avss 36.39475f
C540 dvdd avss 0.23659p
C541 psrg_mf1_protected avss 6.5414f
C542 pm1 avss 18.2215f
C543 pm2 avss 33.92662f
C544 psrg_m3_protected avss 7.12828f
C545 xf1 avss 0.11497p
C546 xf2 avss 66.06756f
C547 vsp avss 59.12836f
C548 vaux avss 7.34562f
C549 vx3 avss 28.12437f
C550 vx2 avss 8.11736f
C551 vx1 avss 16.94744f
C552 su_state avss 28.21305f
C553 vsu1 avss 6.27575f
C554 vsu2 avss 9.655f
C555 rfix2 avss 11.172f
C556 rfix1 avss 11.1355f
C557 rfix0 avss 9.6286f
C558 b1_b avss 1.65753f
C559 rbit0top avss 23.1951f
C560 rbit1top avss 13.72283f
C561 rbit2top avss 13.25112f
C562 b2_b avss 1.08968f
C563 rbit6top avss 18.74274f
C564 rbit5top avss 23.12094f
C565 b5_b avss 0.96892f
C566 rbit3top avss 24.64168f
C567 rbit4top avss 17.25595f
C568 net4 avss 1.4611f
C569 net3 avss 22.69064f
C570 vq2 avss 8.26443f
C571 v1 avss 16.91943f
C572 vq3 avss 0.13693p
.ends
