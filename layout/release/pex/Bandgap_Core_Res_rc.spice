* NGSPICE file created from Bandgap_Core_Res.ext - technology: gf180mcuD

.subckt Bandgap_Core_Res avdd avss vref b0 b1 b2 b3 b4 b5 b6 dvss dvdd net3 net4 v1
+ vq2 vq3
Xpnp_05p00x05p00_0 avss avss vq3 pnp_05p00x05p00
Xpnp_05p00x05p00_1 avss avss vq2 pnp_05p00x05p00
Xpnp_05p00x05p00_2 avss avss vq2 pnp_05p00x05p00
Xpnp_05p00x05p00_4 avss avss vq2 pnp_05p00x05p00
Xpnp_05p00x05p00_3 avss avss vq2 pnp_05p00x05p00
Xpnp_05p00x05p00_5 avss avss v1 pnp_05p00x05p00
Xpnp_05p00x05p00_6 avss avss vq2 pnp_05p00x05p00
Xpnp_05p00x05p00_7 avss avss vq2 pnp_05p00x05p00
Xpnp_05p00x05p00_8 avss avss vq2 pnp_05p00x05p00
Xpnp_05p00x05p00_9 avss avss vq2 pnp_05p00x05p00
Xnwell_0 net3 net4 avss nwell r_length=20.19u r_width=2u
X0 rbit0top.t1 b0.t2 rbit1top.t3 dvss nfet_03v3 ad=17.6p pd=80.88u as=17.6p ps=80.88u w=40u l=0.28u
X1 avdd.t462 avdd.t461 avdd.t462 avdd pfet_05v0 ad=24.1516p pd=0.11066m as=0 ps=0 w=54.89u l=4u
X2 avss.t119 avss.t117 avss.t118 avss nfet_05v0 ad=3.322p pd=15.98u as=0 ps=0 w=7.55u l=4u
X3 avss.t146 avss.t144 avss.t145 avss nfet_05v0 ad=7.1896p pd=33.56u as=0 ps=0 w=16.34u l=8u
X4 avdd.t225 avdd.t223 avdd.t224 avdd pfet_05v0 ad=7.2248p pd=33.72u as=0 ps=0 w=16.42u l=4u
X5 vbn_sink.t11 vbp_i.t32 avdd.t614 avdd pfet_05v0 ad=8.338p pd=38.78u as=8.338p ps=38.78u w=18.95u l=8u
X6 vbn_sink.t6 vbp_i.t24 avdd.t588 avdd pfet_05v0 ad=8.338p pd=38.78u as=8.338p ps=38.78u w=18.95u l=8u
X7 avdd.t267 avdd.t265 avdd.t266 avdd pfet_05v0 ad=7.37p pd=34.38u as=0 ps=0 w=16.75u l=2u
X8 avdd.t285 avdd.t283 avdd.t284 avdd pfet_05v0 ad=7.37p pd=34.38u as=0 ps=0 w=16.75u l=2u
X9 vbn_sink.t12 vbp_i.t33 avdd.t615 avdd pfet_05v0 ad=8.338p pd=38.78u as=8.338p ps=38.78u w=18.95u l=8u
X10 avdd.t138 avdd.t136 avdd.t137 avdd pfet_05v0 ad=8.3556p pd=38.86u as=0 ps=0 w=18.99u l=8u
X11 vbn_fold.t1 vbp_i.t47 avdd.t570 avdd pfet_05v0 ad=8.3556p pd=38.86u as=8.3556p ps=38.86u w=18.99u l=8u
X12 b3_b.t0 b3.t0 dvdd.t4 dvdd pfet_03v3 ad=1.32p pd=6.88u as=1.32p ps=6.88u w=3u l=0.5u
X13 vx1.t4 psrg_m3_feed.t13 avdd.t563 avdd pfet_05v0 ad=7.37p pd=34.38u as=7.37p ps=34.38u w=16.75u l=2u
X14 rbit3top.t6 b2_b.t3 rbit2top.t2 dvdd pfet_03v3 ad=8.8p pd=40.88u as=8.8p ps=40.88u w=20u l=0.28u
X15 pm1.t2 y1.t13 avdd.t636 avdd pfet_05v0 ad=9.1344p pd=42.4u as=9.1344p ps=42.4u w=20.76u l=4u
X16 vbn.t2 vbn.t1 avss.t1 avss nfet_05v0 ad=3.322p pd=15.98u as=3.322p ps=15.98u w=7.55u l=4u
X17 avdd.t87 avdd.t85 avdd.t86 avdd pfet_05v0 ad=8.25p pd=38.38u as=0 ps=0 w=18.75u l=8u
X18 avdd.t153 avdd.t151 avdd.t152 avdd pfet_05v0 ad=8.338p pd=38.78u as=0 ps=0 w=18.95u l=8u
X19 vgn2.t6 vbn_fold.t14 xf2.t5 avss nfet_05v0 ad=8.1356p pd=37.86u as=8.1356p ps=37.86u w=18.49u l=6u
X20 vbp_cas.t0 vbn_i.t11 avss.t6 avss nfet_05v0 ad=0.286p pd=2.18u as=0.286p ps=2.18u w=0.65u l=8u
X21 vbn_i.t5 vbp_i.t52 avdd.t597 avdd pfet_05v0 ad=8.25p pd=38.38u as=8.25p ps=38.38u w=18.75u l=8u
X22 avdd.t261 avdd.t259 avdd.t260 avdd pfet_05v0 ad=7.2248p pd=33.72u as=0 ps=0 w=16.42u l=4u
X23 avss.t170 avss.t168 avss.t169 avss nfet_05v0 ad=7.1896p pd=33.56u as=0 ps=0 w=16.34u l=8u
X24 vgn2.t0 vbp_cas.t32 pm2.t9 avdd pfet_05v0 ad=9.7724p pd=45.3u as=9.7724p ps=45.3u w=22.21u l=8u
X25 avdd.t386 avdd.t384 avdd.t385 avdd pfet_05v0 ad=7.2248p pd=33.72u as=0 ps=0 w=16.42u l=4u
X26 avdd.t547 avdd.t545 avdd.t546 avdd pfet_05v0 ad=9.1344p pd=42.4u as=0 ps=0 w=20.76u l=4u
X27 avdd.t395 avdd.t393 avdd.t394 avdd pfet_05v0 ad=7.37p pd=34.38u as=0 ps=0 w=16.75u l=2u
X28 avdd.t84 avdd.t82 avdd.t83 avdd pfet_05v0 ad=8.25p pd=38.38u as=0 ps=0 w=18.75u l=8u
X29 avdd.t150 avdd.t148 avdd.t149 avdd pfet_05v0 ad=8.338p pd=38.78u as=0 ps=0 w=18.95u l=8u
X30 avdd.t305 avdd.t304 avdd.t305 avdd pfet_05v0 ad=24.1516p pd=0.11066m as=0 ps=0 w=54.89u l=4u
X31 vbn_fold.t13 vbn_fold.t12 vnx_bias avss nfet_05v0 ad=2.0328p pd=10.12u as=2.0328p ps=10.12u w=4.62u l=6u
X32 xf1.t5 vbn_sink.t23 avss.t210 avss nfet_05v0 ad=7.1896p pd=33.56u as=7.1896p ps=33.56u w=16.34u l=8u
X33 vgn1.t0 aux_gate psrg_m3_feed.t0 avdd pfet_05v0 ad=0.88p pd=4.88u as=0.88p ps=4.88u w=2u l=2u
X34 rbit6top.t0 b5_b.t2 rbit5top.t0 dvdd pfet_03v3 ad=3.3p pd=15.88u as=3.3p ps=15.88u w=7.5u l=0.28u
X35 avdd.t469 avdd.t467 avdd.t468 avdd pfet_05v0 ad=9.7724p pd=45.3u as=0 ps=0 w=22.21u l=8u
X36 avdd.t9 avdd.t7 avdd.t8 avdd pfet_05v0 ad=8.25p pd=38.38u as=0 ps=0 w=18.75u l=8u
X37 rbit4top.t5 rbit3top.t4 avss ppolyf_u_1k r_width=6.6u r_length=16u
X38 avss.t74 avss.t72 avss.t73 avss nfet_05v0 ad=6.424p pd=30.08u as=0 ps=0 w=14.6u l=4u
X39 vx3.t9 psrg_m3_feed.t26 avdd.t652 avdd pfet_05v0 ad=7.37p pd=34.38u as=7.37p ps=34.38u w=16.75u l=2u
X40 avdd.t517 avdd.t515 avdd.t516 avdd pfet_05v0 ad=9.7724p pd=45.3u as=0 ps=0 w=22.21u l=8u
X41 avss.t14 avss.t12 avss.t13 avss nfet_05v0 ad=7.1896p pd=33.56u as=0 ps=0 w=16.34u l=8u
X42 avdd.t329 avdd.t327 avdd.t328 avdd pfet_05v0 ad=7.37p pd=34.38u as=0 ps=0 w=16.75u l=2u
X43 avdd.t6 avdd.t4 avdd.t5 avdd pfet_05v0 ad=8.25p pd=38.38u as=0 ps=0 w=18.75u l=8u
X44 avdd.t270 avdd.t268 avdd.t269 avdd pfet_05v0 ad=7.37p pd=34.38u as=0 ps=0 w=16.75u l=2u
X45 vaux.t2 psrg_m3_feed.t28 avdd.t654 avdd pfet_05v0 ad=4.4p pd=20.88u as=4.4p ps=20.88u w=10u l=2u
X46 vbn.t0 aux_gate avdd.t580 avdd pfet_05v0 ad=0.22p pd=1.88u as=0.22p ps=1.88u w=0.5u l=8u
X47 avdd.t444 avdd.t443 avdd.t444 avdd pfet_05v0 ad=24.1516p pd=0.11066m as=0 ps=0 w=54.89u l=4u
X48 avdd.t301 avdd.t300 avdd.t301 avdd pfet_05v0 ad=24.1516p pd=0.11066m as=0 ps=0 w=54.89u l=4u
X49 rfix2 rfix1 avss ppolyf_u_1k r_width=6.6u r_length=0.128m
X50 avss.t11 avss.t9 avss.t10 avss nfet_05v0 ad=7.1896p pd=33.56u as=0 ps=0 w=16.34u l=8u
X51 avdd.t93 avdd.t91 avdd.t92 avdd pfet_05v0 ad=8.25p pd=38.38u as=0 ps=0 w=18.75u l=8u
X52 avdd.t541 avdd.t539 avdd.t540 avdd pfet_05v0 ad=9.1344p pd=42.4u as=0 ps=0 w=20.76u l=4u
X53 vref.t1 vcasp vx3.t5 avdd pfet_05v0 ad=7.2248p pd=33.72u as=7.2248p ps=33.72u w=16.42u l=4u
X54 avdd.t234 avdd.t232 avdd.t233 avdd pfet_05v0 ad=7.2248p pd=33.72u as=0 ps=0 w=16.42u l=4u
X55 rbit6top.t1 rbit5top.t1 avss ppolyf_u_1k r_width=6.6u r_length=64u
X56 psrg_vnc.t7 psrg_vnc.t6 rb_mid avss nfet_05v0 ad=0.3124p pd=2.3u as=0.3124p ps=2.3u w=0.71u l=20u
X57 avss.t161 avss.t159 avss.t160 avss nfet_05v0 ad=7.1896p pd=33.56u as=0 ps=0 w=16.34u l=8u
X58 avdd.t446 avdd.t445 avdd.t446 avdd pfet_05v0 ad=24.1516p pd=0.11066m as=0 ps=0 w=54.89u l=4u
X59 vx2.t2 psrg_m3_feed.t18 avdd.t629 avdd pfet_05v0 ad=7.37p pd=34.38u as=7.37p ps=34.38u w=16.75u l=2u
X60 avdd.t15 avdd.t13 avdd.t14 avdd pfet_05v0 ad=8.25p pd=38.38u as=0 ps=0 w=18.75u l=8u
X61 avdd.t431 avdd.t429 avdd.t430 avdd pfet_05v0 ad=9.7724p pd=45.3u as=0 ps=0 w=22.21u l=8u
X62 pm1.t4 y1.t9 avdd.t640 avdd pfet_05v0 ad=9.1344p pd=42.4u as=9.1344p ps=42.4u w=20.76u l=4u
X63 avss.t95 avss.t93 avss.t94 avss nfet_05v0 ad=6.424p pd=30.08u as=0 ps=0 w=14.6u l=4u
X64 avdd.t362 avdd.t360 avdd.t361 avdd pfet_05v0 ad=7.37p pd=34.38u as=0 ps=0 w=16.75u l=2u
X65 avss.t122 avss.t120 avss.t121 avss nfet_05v0 ad=3.322p pd=15.98u as=0 ps=0 w=7.55u l=4u
X66 avdd.t135 avdd.t133 avdd.t134 avdd pfet_05v0 ad=8.3556p pd=38.86u as=0 ps=0 w=18.99u l=8u
X67 avdd.t171 avdd.t169 avdd.t170 avdd pfet_05v0 ad=8.338p pd=38.78u as=0 ps=0 w=18.95u l=8u
X68 avdd.t198 avdd.t196 avdd.t197 avdd pfet_05v0 ad=8.338p pd=38.78u as=0 ps=0 w=18.95u l=8u
X69 avdd.t374 avdd.t372 avdd.t373 avdd pfet_05v0 ad=7.2248p pd=33.72u as=0 ps=0 w=16.42u l=4u
X70 psrg_m3_feed.t3 vcasp vx2.t6 avdd pfet_05v0 ad=7.2248p pd=33.72u as=7.2248p ps=33.72u w=16.42u l=4u
X71 pm1.t3 y1.t12 avdd.t635 avdd pfet_05v0 ad=9.1344p pd=42.4u as=9.1344p ps=42.4u w=20.76u l=4u
X72 vx2.t0 psrg_m3_feed.t25 avdd.t602 avdd pfet_05v0 ad=7.37p pd=34.38u as=7.37p ps=34.38u w=16.75u l=2u
X73 avdd.t320 avdd.t318 avdd.t319 avdd pfet_05v0 ad=7.2248p pd=33.72u as=0 ps=0 w=16.42u l=4u
X74 avdd.t132 avdd.t130 avdd.t131 avdd pfet_05v0 ad=8.3556p pd=38.86u as=0 ps=0 w=18.99u l=8u
X75 avdd.t168 avdd.t166 avdd.t167 avdd pfet_05v0 ad=8.338p pd=38.78u as=0 ps=0 w=18.95u l=8u
X76 avdd.t195 avdd.t193 avdd.t194 avdd pfet_05v0 ad=8.338p pd=38.78u as=0 ps=0 w=18.95u l=8u
X77 b2_b.t0 b2.t0 dvdd.t0 dvdd pfet_03v3 ad=1.32p pd=6.88u as=1.32p ps=6.88u w=3u l=0.5u
X78 avdd.t389 avdd.t387 avdd.t388 avdd pfet_05v0 ad=7.37p pd=34.38u as=0 ps=0 w=16.75u l=2u
X79 avdd.t416 avdd.t415 avdd.t416 avdd pfet_05v0 ad=24.1516p pd=0.11066m as=0 ps=0 w=54.89u l=4u
X80 y1.t5 vbp_cas.t26 pm1.t10 avdd pfet_05v0 ad=9.7724p pd=45.3u as=9.7724p ps=45.3u w=22.21u l=8u
X81 avdd.t526 avdd.t524 avdd.t525 avdd pfet_05v0 ad=9.7724p pd=45.3u as=0 ps=0 w=22.21u l=8u
X82 avss.t140 avss.t138 avss.t139 avss nfet_05v0 ad=5.4164p pd=25.5u as=0 ps=0 w=12.31u l=8u
X83 b5_b.t0 b5.t0 dvdd.t1 dvdd pfet_03v3 ad=1.32p pd=6.88u as=1.32p ps=6.88u w=3u l=0.5u
X84 avss.t179 avss.t177 avss.t178 avss nfet_05v0 ad=8.1356p pd=37.86u as=0 ps=0 w=18.49u l=6u
X85 avdd.t295 avdd.t294 avdd.t295 avdd pfet_05v0 ad=24.1516p pd=0.11066m as=0 ps=0 w=54.89u l=4u
X86 vbp_i.t10 vbp_i.t9 avdd.t631 avdd pfet_05v0 ad=8.25p pd=38.38u as=8.25p ps=38.38u w=18.75u l=8u
X87 avss.t32 avss.t30 avss.t31 avss nfet_05v0 ad=7.1896p pd=33.56u as=0 ps=0 w=16.34u l=8u
X88 avss.t137 avss.t135 avss.t136 avss nfet_05v0 ad=5.4164p pd=25.5u as=0 ps=0 w=12.31u l=8u
X89 vbp_bias.t1 vbp_bias.t0 avdd.t0 avdd pfet_03v3 ad=8.3864p pd=39u as=8.3864p ps=39u w=19.06u l=8u
X90 avdd.t81 avdd.t79 avdd.t80 avdd pfet_05v0 ad=8.25p pd=38.38u as=0 ps=0 w=18.75u l=8u
X91 avdd.t484 avdd.t482 avdd.t483 avdd pfet_05v0 ad=9.1344p pd=42.4u as=0 ps=0 w=20.76u l=4u
X92 vbp_bias.t17 vbp_bias.t16 avdd.t633 avdd pfet_03v3 ad=8.3864p pd=39u as=8.3864p ps=39u w=19.06u l=8u
X93 xf2.t10 vbn_sink.t24 avss.t236 avss nfet_05v0 ad=7.1896p pd=33.56u as=7.1896p ps=33.56u w=16.34u l=8u
X94 vref.t6 avss.t222 cap_mim_2f0_m4m5_noshield c_width=70.7u c_length=70.7u
X95 vbn_sink.t2 vbp_i.t28 avdd.t578 avdd pfet_05v0 ad=8.338p pd=38.78u as=8.338p ps=38.78u w=18.95u l=8u
X96 vbn_fold.t5 vbp_i.t41 avdd.t604 avdd pfet_05v0 ad=8.3556p pd=38.86u as=8.3556p ps=38.86u w=18.99u l=8u
X97 rbit1top.t12 b0_b.t3 rbit0top.t4 dvdd pfet_03v3 ad=17.6p pd=80.88u as=17.6p ps=80.88u w=40u l=0.28u
X98 avdd.t550 avdd.t548 avdd.t549 avdd pfet_05v0 ad=9.1344p pd=42.4u as=0 ps=0 w=20.76u l=4u
X99 vbn_i.t2 iref_gate.t3 avdd.t663 avdd pfet_05v0 ad=0.22p pd=1.88u as=0.22p ps=1.88u w=0.5u l=8u
X100 avss.t197 avss.t195 avss.t196 avss nfet_05v0 ad=8.1356p pd=37.86u as=0 ps=0 w=18.49u l=6u
X101 vref.t6 avss.t232 cap_mim_2f0_m4m5_noshield c_width=70.7u c_length=70.7u
X102 avdd.t162 avdd.t160 avdd.t161 avdd pfet_05v0 ad=8.338p pd=38.78u as=0 ps=0 w=18.95u l=8u
X103 avdd.t189 avdd.t187 avdd.t188 avdd pfet_05v0 ad=8.338p pd=38.78u as=0 ps=0 w=18.95u l=8u
X104 avdd.t3 avdd.t1 avdd.t2 avdd pfet_05v0 ad=8.25p pd=38.38u as=0 ps=0 w=18.75u l=8u
X105 iref_gate.t2 vbp_i.t21 vsu1 avss nfet_05v0 ad=0.22p pd=1.88u as=0.22p ps=1.88u w=0.5u l=50u
X106 vgn2.t1 vbp_cas.t29 pm2.t8 avdd pfet_05v0 ad=9.7724p pd=45.3u as=9.7724p ps=45.3u w=22.21u l=8u
X107 vbn_fold.t7 vbp_i.t51 avdd.t613 avdd pfet_05v0 ad=8.3556p pd=38.86u as=8.3556p ps=38.86u w=18.99u l=8u
X108 rbit0top.t3 rfix2 avss ppolyf_u_1k r_width=6.6u r_length=0.128m
X109 avss.t188 avss.t186 avss.t187 avss nfet_05v0 ad=8.1356p pd=37.86u as=0 ps=0 w=18.49u l=6u
X110 vsp.t7 vbp_tail.t12 avdd.t622 avdd pfet_03v3 ad=12.7204p pd=58.7u as=12.7204p ps=58.7u w=28.91u l=6u
X111 avdd.t371 avdd.t369 avdd.t370 avdd pfet_05v0 ad=7.2248p pd=33.72u as=0 ps=0 w=16.42u l=4u
X112 rbit4top.t3 b3_b.t2 rbit3top.t3 dvdd pfet_03v3 ad=13.2p pd=60.88u as=13.2p ps=60.88u w=30u l=0.28u
X113 avdd.t258 avdd.t256 avdd.t257 avdd pfet_05v0 ad=7.2248p pd=33.72u as=0 ps=0 w=16.42u l=4u
X114 su_state.t2 vsu avdd.t641 avdd pfet_05v0 ad=0.44p pd=2.88u as=0.44p ps=2.88u w=1u l=8u
X115 xf1.t3 vbn_sink.t27 avss.t203 avss nfet_05v0 ad=7.1896p pd=33.56u as=7.1896p ps=33.56u w=16.34u l=8u
X116 avdd.t75 avdd.t73 avdd.t74 avdd pfet_05v0 ad=8.3556p pd=38.86u as=0 ps=0 w=18.99u l=8u
X117 rbit5top.t4 b4_b.t2 rbit4top.t2 dvdd pfet_03v3 ad=6.6p pd=30.88u as=6.6p ps=30.88u w=15u l=0.28u
X118 avss.t104 avss.t102 avss.t103 avss nfet_05v0 ad=6.424p pd=30.08u as=0 ps=0 w=14.6u l=4u
X119 avdd.t216 avdd.t214 avdd.t215 avdd pfet_05v0 ad=8.338p pd=38.78u as=0 ps=0 w=18.95u l=8u
X120 vbn_i.t0 vbp_i.t54 avdd.t568 avdd pfet_05v0 ad=8.25p pd=38.38u as=8.25p ps=38.38u w=18.75u l=8u
X121 xf2.t3 vbn_sink.t28 avss.t204 avss nfet_05v0 ad=7.1896p pd=33.56u as=7.1896p ps=33.56u w=16.34u l=8u
X122 avss.t23 avss.t21 avss.t22 avss nfet_05v0 ad=7.1896p pd=33.56u as=0 ps=0 w=16.34u l=8u
X123 avdd.t562 avdd.t560 avdd.t561 avdd pfet_05v0 ad=9.1344p pd=42.4u as=0 ps=0 w=20.76u l=4u
X124 avss.t158 avss.t156 avss.t157 avss nfet_05v0 ad=7.1896p pd=33.56u as=0 ps=0 w=16.34u l=8u
X125 avdd.t380 avdd.t378 avdd.t379 avdd pfet_05v0 ad=7.2248p pd=33.72u as=0 ps=0 w=16.42u l=4u
X126 xf1.t9 v1.t3 vsp.t11 avdd pfet_05v0 ad=24.1516p pd=0.11066m as=24.1516p ps=0.11066m w=54.89u l=4u
X127 avss.t56 avss.t54 avss.t55 avss nfet_05v0 ad=5.4164p pd=25.5u as=0 ps=0 w=12.31u l=8u
X128 rbit2top.t5 b1_b.t4 rbit1top.t6 dvdd pfet_03v3 ad=17.6p pd=80.88u as=17.6p ps=80.88u w=40u l=0.28u
X129 psrg_m3_feed.t2 psrg_vnc.t10 psrg_m3_protected.t1 avss nfet_05v0 ad=6.424p pd=30.08u as=6.424p ps=30.08u w=14.6u l=4u
X130 avdd.t213 avdd.t211 avdd.t212 avdd pfet_05v0 ad=8.338p pd=38.78u as=0 ps=0 w=18.95u l=8u
X131 rbit4top.t1 b4.t2 rbit5top.t3 dvss nfet_03v3 ad=2.2p pd=10.88u as=2.2p ps=10.88u w=5u l=0.28u
X132 avdd.t57 avdd.t55 avdd.t56 avdd pfet_05v0 ad=8.3556p pd=38.86u as=0 ps=0 w=18.99u l=8u
X133 vbn_sink.t18 vbn_sink.t17 avss.t5 avss nfet_05v0 ad=5.4164p pd=25.5u as=5.4164p ps=25.5u w=12.31u l=8u
X134 avdd.t309 avdd.t308 avdd.t309 avdd pfet_05v0 ad=24.1516p pd=0.11066m as=0 ps=0 w=54.89u l=4u
X135 avdd.t249 avdd.t247 avdd.t248 avdd pfet_05v0 ad=7.2248p pd=33.72u as=0 ps=0 w=16.42u l=4u
X136 vbp_tail.t3 vbp_tail.t2 avdd.t659 avdd pfet_03v3 ad=6.05p pd=28.38u as=6.05p ps=28.38u w=13.75u l=6u
X137 avdd.t323 avdd.t321 avdd.t322 avdd pfet_05v0 ad=7.2248p pd=33.72u as=0 ps=0 w=16.42u l=4u
X138 avdd.t448 avdd.t447 avdd.t448 avdd pfet_05v0 ad=24.1516p pd=0.11066m as=0 ps=0 w=54.89u l=4u
X139 avss.t107 avss.t105 avss.t106 avss nfet_05v0 ad=6.424p pd=30.08u as=0 ps=0 w=14.6u l=4u
X140 vbp_cas.t14 vbp_cas.t13 vbp_bias.t22 avdd pfet_05v0 ad=8.3292p pd=38.74u as=8.3292p ps=38.74u w=18.93u l=8u
X141 pm2.t0 y1.t18 avdd.t657 avdd pfet_05v0 ad=9.1344p pd=42.4u as=9.1344p ps=42.4u w=20.76u l=4u
X142 avdd.t273 avdd.t271 avdd.t272 avdd pfet_05v0 ad=7.37p pd=34.38u as=0 ps=0 w=16.75u l=2u
X143 xf2.t8 v2.t5 vsp.t6 avdd pfet_05v0 ad=24.1516p pd=0.11066m as=24.1516p ps=0.11066m w=54.89u l=4u
X144 vaux.t1 psrg_m3_feed.t27 avdd.t653 avdd pfet_05v0 ad=4.4p pd=20.88u as=4.4p ps=20.88u w=10u l=2u
X145 avdd.t520 avdd.t518 avdd.t519 avdd pfet_05v0 ad=9.7724p pd=45.3u as=0 ps=0 w=22.21u l=8u
X146 su_state.t0 vbp_tail.t13 avdd.t623 avdd pfet_05v0 ad=0.44p pd=2.88u as=0.44p ps=2.88u w=1u l=8u
X147 avdd.t442 avdd.t441 avdd.t442 avdd pfet_05v0 ad=24.1516p pd=0.11066m as=0 ps=0 w=54.89u l=4u
X148 avss.t98 avss.t96 avss.t97 avss nfet_05v0 ad=6.424p pd=30.08u as=0 ps=0 w=14.6u l=4u
X149 avdd.t222 avdd.t220 avdd.t221 avdd pfet_05v0 ad=7.2248p pd=33.72u as=0 ps=0 w=16.42u l=4u
X150 avdd.t556 avdd.t554 avdd.t555 avdd pfet_05v0 ad=9.1344p pd=42.4u as=0 ps=0 w=20.76u l=4u
X151 avdd.t192 avdd.t190 avdd.t191 avdd pfet_05v0 ad=8.338p pd=38.78u as=0 ps=0 w=18.95u l=8u
X152 pm2.t3 y1.t11 avdd.t634 avdd pfet_05v0 ad=9.1344p pd=42.4u as=9.1344p ps=42.4u w=20.76u l=4u
X153 avdd.t332 avdd.t330 avdd.t331 avdd pfet_05v0 ad=7.2248p pd=33.72u as=0 ps=0 w=16.42u l=4u
X154 avdd.t368 avdd.t366 avdd.t367 avdd pfet_05v0 ad=7.2248p pd=33.72u as=0 ps=0 w=16.42u l=4u
X155 psrg_vnc.t2 vbp_i.t18 avdd.t605 avdd pfet_05v0 ad=7.8056p pd=36.36u as=7.8056p ps=36.36u w=17.74u l=4u
X156 avdd.t114 avdd.t112 avdd.t113 avdd pfet_05v0 ad=8.25p pd=38.38u as=0 ps=0 w=18.75u l=8u
X157 avdd.t207 avdd.t205 avdd.t206 avdd pfet_05v0 ad=8.338p pd=38.78u as=0 ps=0 w=18.95u l=8u
X158 xf1.t1 vbn_sink.t31 avss.t8 avss nfet_05v0 ad=7.1896p pd=33.56u as=7.1896p ps=33.56u w=16.34u l=8u
X159 vbn_sink.t8 vbp_i.t23 avdd.t590 avdd pfet_05v0 ad=8.338p pd=38.78u as=8.338p ps=38.78u w=18.95u l=8u
X160 vcasp vcasp avdd.t648 avdd pfet_05v0 ad=0.396p pd=2.68u as=0.396p ps=2.68u w=0.9u l=2u
X161 avss.t134 avss.t132 avss.t133 avss nfet_05v0 ad=5.4164p pd=25.5u as=0 ps=0 w=12.31u l=8u
X162 avdd.t78 avdd.t76 avdd.t77 avdd pfet_05v0 ad=8.3556p pd=38.86u as=0 ps=0 w=18.99u l=8u
X163 vx2.t3 psrg_m3_feed.t17 avdd.t628 avdd pfet_05v0 ad=7.37p pd=34.38u as=7.37p ps=34.38u w=16.75u l=2u
X164 vbp_bias.t3 vbp_bias.t2 avdd.t573 avdd pfet_03v3 ad=8.3864p pd=39u as=8.3864p ps=39u w=19.06u l=8u
X165 avdd.t377 avdd.t375 avdd.t376 avdd pfet_05v0 ad=7.2248p pd=33.72u as=0 ps=0 w=16.42u l=4u
X166 rfix0 vref.t5 avss ppolyf_u_1k r_width=6.6u r_length=0.128m
X167 avss.t131 avss.t129 avss.t130 avss nfet_05v0 ad=5.4164p pd=25.5u as=0 ps=0 w=12.31u l=8u
X168 avdd.t350 avdd.t348 avdd.t349 avdd pfet_05v0 ad=7.2248p pd=33.72u as=0 ps=0 w=16.42u l=4u
X169 avdd.t243 avdd.t241 avdd.t242 avdd pfet_05v0 ad=7.2248p pd=33.72u as=0 ps=0 w=16.42u l=4u
X170 vbn_fold.t0 vbp_i.t46 avdd.t569 avdd pfet_05v0 ad=8.3556p pd=38.86u as=8.3556p ps=38.86u w=18.99u l=8u
X171 pm2.t2 y1.t14 avdd.t624 avdd pfet_05v0 ad=9.1344p pd=42.4u as=9.1344p ps=42.4u w=20.76u l=4u
X172 vref.t2 vcasp vx3.t6 avdd pfet_05v0 ad=7.2248p pd=33.72u as=7.2248p ps=33.72u w=16.42u l=4u
X173 avdd.t36 avdd.t34 avdd.t35 avdd pfet_05v0 ad=8.25p pd=38.38u as=0 ps=0 w=18.75u l=8u
X174 y1.t1 vbp_cas.t23 pm1.t7 avdd pfet_05v0 ad=9.7724p pd=45.3u as=9.7724p ps=45.3u w=22.21u l=8u
X175 avdd.t159 avdd.t157 avdd.t158 avdd pfet_05v0 ad=8.338p pd=38.78u as=0 ps=0 w=18.95u l=8u
X176 vsu2 vbp_i.t20 avss.t239 avss nfet_05v0 ad=0.22p pd=1.88u as=0.22p ps=1.88u w=0.5u l=50u
X177 vbn_sink.t20 vbp_i.t35 avdd.t651 avdd pfet_05v0 ad=8.338p pd=38.78u as=8.338p ps=38.78u w=18.95u l=8u
X178 avdd.t511 avdd.t509 avdd.t510 avdd pfet_05v0 ad=9.7724p pd=45.3u as=0 ps=0 w=22.21u l=8u
X179 avdd.t535 avdd.t533 avdd.t534 avdd pfet_05v0 ad=9.1344p pd=42.4u as=0 ps=0 w=20.76u l=4u
X180 vx1.t0 psrg_m3_feed.t24 avdd.t601 avdd pfet_05v0 ad=7.37p pd=34.38u as=7.37p ps=34.38u w=16.75u l=2u
X181 avdd.t303 avdd.t302 avdd.t303 avdd pfet_05v0 ad=24.1516p pd=0.11066m as=0 ps=0 w=54.89u l=4u
X182 avdd.t156 avdd.t154 avdd.t155 avdd pfet_05v0 ad=8.338p pd=38.78u as=0 ps=0 w=18.95u l=8u
X183 vsp.t13 vbp_tail.t9 avdd.t658 avdd pfet_03v3 ad=12.7204p pd=58.7u as=12.7204p ps=58.7u w=28.91u l=6u
X184 rbit3top.t1 rbit2top.t3 avss ppolyf_u_1k r_width=6.6u r_length=8u
X185 avdd.t496 avdd.t494 avdd.t495 avdd pfet_05v0 ad=9.1344p pd=42.4u as=0 ps=0 w=20.76u l=4u
X186 vbn_sink.t7 vbp_i.t25 avdd.t589 avdd pfet_05v0 ad=8.338p pd=38.78u as=8.338p ps=38.78u w=18.95u l=8u
X187 avss.t185 avss.t183 avss.t184 avss nfet_05v0 ad=8.1356p pd=37.86u as=0 ps=0 w=18.49u l=6u
X188 xf1.t6 v1.t5 vsp.t9 avdd pfet_05v0 ad=24.1516p pd=0.11066m as=24.1516p ps=0.11066m w=54.89u l=4u
X189 avdd.t529 avdd.t527 avdd.t528 avdd pfet_05v0 ad=9.7724p pd=45.3u as=0 ps=0 w=22.21u l=8u
X190 vref.t8 avss.t218 cap_mim_2f0_m4m5_noshield c_width=70.7u c_length=70.7u
X191 avdd.t69 avdd.t67 avdd.t68 avdd pfet_05v0 ad=8.25p pd=38.38u as=0 ps=0 w=18.75u l=8u
X192 avss.t20 avss.t18 avss.t19 avss nfet_05v0 ad=7.1896p pd=33.56u as=0 ps=0 w=16.34u l=8u
X193 vref.t8 avss.t228 cap_mim_2f0_m4m5_noshield c_width=70.7u c_length=70.7u
X194 avdd.t299 avdd.t298 avdd.t299 avdd pfet_05v0 ad=24.1516p pd=0.11066m as=0 ps=0 w=54.89u l=4u
X195 vbn_fold.t8 vbp_i.t48 avdd.t616 avdd pfet_05v0 ad=8.3556p pd=38.86u as=8.3556p ps=38.86u w=18.99u l=8u
X196 avss.t200 avss.t198 avss.t199 avss nfet_05v0 ad=8.1356p pd=37.86u as=0 ps=0 w=18.49u l=6u
X197 vbp_cas.t10 vbp_cas.t9 vbp_bias.t27 avdd pfet_05v0 ad=8.3292p pd=38.74u as=8.3292p ps=38.74u w=18.93u l=8u
X198 vbp_i.t6 vbp_i.t5 avdd.t577 avdd pfet_05v0 ad=8.25p pd=38.38u as=8.25p ps=38.38u w=18.75u l=8u
X199 vbn_sink.t16 vbn_sink.t15 avss.t4 avss nfet_05v0 ad=5.4164p pd=25.5u as=5.4164p ps=25.5u w=12.31u l=8u
X200 vbn_fold.t3 vbp_i.t45 avdd.t587 avdd pfet_05v0 ad=8.3556p pd=38.86u as=8.3556p ps=38.86u w=18.99u l=8u
X201 psrg_m3_feed.t5 vcasp vx2.t9 avdd pfet_05v0 ad=7.2248p pd=33.72u as=7.2248p ps=33.72u w=16.42u l=4u
X202 psrg_m3_feed.t7 vcasp vx2.t7 avdd pfet_05v0 ad=7.2248p pd=33.72u as=7.2248p ps=33.72u w=16.42u l=4u
X203 psrg_vnc.t5 vbp_i.t15 avdd.t611 avdd pfet_05v0 ad=7.8056p pd=36.36u as=7.8056p ps=36.36u w=17.74u l=4u
X204 avss.t47 avss.t45 avss.t46 avss nfet_05v0 ad=5.4164p pd=25.5u as=0 ps=0 w=12.31u l=8u
X205 vsp.t1 vbp_tail.t11 avdd.t565 avdd pfet_03v3 ad=12.7204p pd=58.7u as=12.7204p ps=58.7u w=28.91u l=6u
X206 avdd.t120 avdd.t118 avdd.t119 avdd pfet_05v0 ad=8.3556p pd=38.86u as=0 ps=0 w=18.99u l=8u
X207 avdd.t365 avdd.t363 avdd.t364 avdd pfet_05v0 ad=7.37p pd=34.38u as=0 ps=0 w=16.75u l=2u
X208 vbp_tail.t1 vbp_tail.t0 avdd.t591 avdd pfet_03v3 ad=6.05p pd=28.38u as=6.05p ps=28.38u w=13.75u l=6u
X209 vbp_bias.t7 vbp_bias.t6 avdd.t637 avdd pfet_03v3 ad=8.3864p pd=39u as=8.3864p ps=39u w=19.06u l=8u
X210 avdd.t450 avdd.t449 avdd.t450 avdd pfet_05v0 ad=24.1516p pd=0.11066m as=0 ps=0 w=54.89u l=4u
X211 vbp_cas.t4 vbp_cas.t3 vbp_bias.t26 avdd pfet_05v0 ad=8.3292p pd=38.74u as=8.3292p ps=38.74u w=18.93u l=8u
X212 psrg_m3_feed.t6 vcasp vx2.t10 avdd pfet_05v0 ad=7.2248p pd=33.72u as=7.2248p ps=33.72u w=16.42u l=4u
X213 avdd.t410 avdd.t408 avdd.t409 avdd pfet_05v0 ad=7.37p pd=34.38u as=0 ps=0 w=16.75u l=2u
X214 rfix1 rfix0 avss ppolyf_u_1k r_width=6.6u r_length=0.128m
X215 avss.t101 avss.t99 avss.t100 avss nfet_05v0 ad=6.424p pd=30.08u as=0 ps=0 w=14.6u l=4u
X216 vbp_cas.t2 vbp_cas.t1 vbp_bias.t25 avdd pfet_05v0 ad=8.3292p pd=38.74u as=8.3292p ps=38.74u w=18.93u l=8u
X217 vbp_cas.t16 vbp_cas.t15 vbp_bias.t18 avdd pfet_05v0 ad=8.3292p pd=38.74u as=8.3292p ps=38.74u w=18.93u l=8u
X218 avdd.t111 avdd.t109 avdd.t110 avdd pfet_05v0 ad=8.25p pd=38.38u as=0 ps=0 w=18.75u l=8u
X219 avdd.t204 avdd.t202 avdd.t203 avdd pfet_05v0 ad=8.338p pd=38.78u as=0 ps=0 w=18.95u l=8u
X220 xf2.t1 vbn_sink.t32 avss.t3 avss nfet_05v0 ad=7.1896p pd=33.56u as=7.1896p ps=33.56u w=16.34u l=8u
X221 avdd.t307 avdd.t306 avdd.t307 avdd pfet_05v0 ad=24.1516p pd=0.11066m as=0 ps=0 w=54.89u l=4u
X222 avdd.t246 avdd.t244 avdd.t245 avdd pfet_05v0 ad=7.2248p pd=33.72u as=0 ps=0 w=16.42u l=4u
X223 avdd.t559 avdd.t557 avdd.t558 avdd pfet_05v0 ad=9.1344p pd=42.4u as=0 ps=0 w=20.76u l=4u
X224 avss.t201 net3.t0 avdd pplus_u r_width=1u r_length=0.23253m
X225 vbn_i.t4 vbn_i.t3 avss.t211 avss nfet_05v0 ad=3.4232p pd=16.44u as=3.4232p ps=16.44u w=7.78u l=8u
X226 psrg_m3_feed.t4 vcasp vx2.t8 avdd pfet_05v0 ad=7.2248p pd=33.72u as=7.2248p ps=33.72u w=16.42u l=4u
X227 y1.t2 psrg_vnc.t9 psrg_mf1_protected.t1 avss nfet_05v0 ad=8.1356p pd=37.86u as=8.1356p ps=37.86u w=18.49u l=6u
X228 avdd.t335 avdd.t333 avdd.t334 avdd pfet_05v0 ad=7.2248p pd=33.72u as=0 ps=0 w=16.42u l=4u
X229 avdd.t487 avdd.t485 avdd.t486 avdd pfet_05v0 ad=9.1344p pd=42.4u as=0 ps=0 w=20.76u l=4u
X230 pm2.t4 y1.t10 avdd.t639 avdd pfet_05v0 ad=9.1344p pd=42.4u as=9.1344p ps=42.4u w=20.76u l=4u
X231 avdd.t505 avdd.t503 avdd.t504 avdd pfet_05v0 ad=9.1344p pd=42.4u as=0 ps=0 w=20.76u l=4u
X232 vq2.t0 v2.t2 avss ppolyf_u_1k r_width=4u r_length=42.1u
X233 avdd.t201 avdd.t199 avdd.t200 avdd pfet_05v0 ad=8.338p pd=38.78u as=0 ps=0 w=18.95u l=8u
X234 xf2.t7 v2.t3 vsp.t5 avdd pfet_05v0 ad=24.1516p pd=0.11066m as=24.1516p ps=0.11066m w=54.89u l=4u
X235 vbp_i.t0 vbn_i.t10 net4.t0 avss nfet_05v0 ad=4.0172p pd=19.14u as=4.0172p ps=19.14u w=9.13u l=8u
X236 avss.t50 avss.t48 avss.t49 avss nfet_05v0 ad=7.1896p pd=33.56u as=0 ps=0 w=16.34u l=8u
X237 psrg_vnc.t1 vbp_i.t17 avdd.t583 avdd pfet_05v0 ad=7.8056p pd=36.36u as=7.8056p ps=36.36u w=17.74u l=4u
X238 avdd.t45 avdd.t43 avdd.t44 avdd pfet_05v0 ad=8.3556p pd=38.86u as=0 ps=0 w=18.99u l=8u
X239 avdd.t33 avdd.t31 avdd.t32 avdd pfet_05v0 ad=8.25p pd=38.38u as=0 ps=0 w=18.75u l=8u
X240 rbit3top.t2 b3.t2 rbit4top.t0 dvss nfet_03v3 ad=4.4p pd=20.88u as=4.4p ps=20.88u w=10u l=0.28u
X241 avdd.t458 avdd.t457 avdd.t458 avdd pfet_05v0 ad=24.1516p pd=0.11066m as=0 ps=0 w=54.89u l=4u
X242 avdd.t293 avdd.t292 avdd.t293 avdd pfet_05v0 ad=24.1516p pd=0.11066m as=0 ps=0 w=54.89u l=4u
X243 avdd.t72 avdd.t70 avdd.t71 avdd pfet_05v0 ad=8.25p pd=38.38u as=0 ps=0 w=18.75u l=8u
X244 avss.t77 avss.t75 avss.t76 avss nfet_05v0 ad=6.424p pd=30.08u as=0 ps=0 w=14.6u l=4u
X245 avdd.t42 avdd.t40 avdd.t41 avdd pfet_05v0 ad=8.3556p pd=38.86u as=0 ps=0 w=18.99u l=8u
X246 avdd.t276 avdd.t274 avdd.t275 avdd pfet_05v0 ad=7.37p pd=34.38u as=0 ps=0 w=16.75u l=2u
X247 avdd.t353 avdd.t351 avdd.t352 avdd pfet_05v0 ad=7.2248p pd=33.72u as=0 ps=0 w=16.42u l=4u
X248 vbp_tail.t6 vbn_i.t9 avss.t2 avss nfet_05v0 ad=6.138p pd=28.78u as=6.138p ps=28.78u w=13.95u l=8u
X249 vbp_bias.t5 vbp_bias.t4 avdd.t667 avdd pfet_03v3 ad=8.3864p pd=39u as=8.3864p ps=39u w=19.06u l=8u
X250 avdd.t452 avdd.t451 avdd.t452 avdd pfet_05v0 ad=24.1516p pd=0.11066m as=0 ps=0 w=54.89u l=4u
X251 avdd.t481 avdd.t479 avdd.t480 avdd pfet_05v0 ad=9.1344p pd=42.4u as=0 ps=0 w=20.76u l=4u
X252 vsua vsua auxsu1 avss nfet_05v0 ad=0.44p pd=2.88u as=0.44p ps=2.88u w=1u l=2u
X253 avdd.t538 avdd.t536 avdd.t537 avdd pfet_05v0 ad=9.1344p pd=42.4u as=0 ps=0 w=20.76u l=4u
X254 vgn2.t7 avss.t234 cap_mim_2f0_m4m5_noshield c_width=59u c_length=59u
X255 vbn_sink.t9 vbp_i.t26 avdd.t608 avdd pfet_05v0 ad=8.338p pd=38.78u as=8.338p ps=38.78u w=18.95u l=8u
X256 avdd.t123 avdd.t121 avdd.t122 avdd pfet_05v0 ad=8.3556p pd=38.86u as=0 ps=0 w=18.99u l=8u
X257 rbit1top.t8 b0_b.t7 rbit0top.t8 dvdd pfet_03v3 ad=17.6p pd=80.88u as=17.6p ps=80.88u w=40u l=0.28u
X258 rbit1top.t11 b0_b.t4 rbit0top.t7 dvdd pfet_03v3 ad=17.6p pd=80.88u as=17.6p ps=80.88u w=40u l=0.28u
X259 b3_b.t1 b3.t1 dvss.t4 dvss nfet_03v3 ad=0.44p pd=2.88u as=0.44p ps=2.88u w=1u l=0.5u
X260 avdd.t102 avdd.t100 avdd.t101 avdd pfet_05v0 ad=8.25p pd=38.38u as=0 ps=0 w=18.75u l=8u
X261 vbn_sink.t10 vbp_i.t27 avdd.t609 avdd pfet_05v0 ad=8.338p pd=38.78u as=8.338p ps=38.78u w=18.95u l=8u
X262 vbn_fold.t4 vbp_i.t40 avdd.t603 avdd pfet_05v0 ad=8.3556p pd=38.86u as=8.3556p ps=38.86u w=18.99u l=8u
X263 vbn_fold.t9 vbp_i.t49 avdd.t617 avdd pfet_05v0 ad=8.3556p pd=38.86u as=8.3556p ps=38.86u w=18.99u l=8u
X264 vx1.t5 psrg_m3_feed.t10 avdd.t576 avdd pfet_05v0 ad=7.37p pd=34.38u as=7.37p ps=34.38u w=16.75u l=2u
X265 b5_b.t1 b5.t2 dvss.t1 dvss nfet_03v3 ad=0.44p pd=2.88u as=0.44p ps=2.88u w=1u l=0.5u
X266 avss.t89 avss.t87 avss.t88 avss nfet_05v0 ad=3.322p pd=15.98u as=0 ps=0 w=7.55u l=4u
X267 vbn_fold.t6 vbp_i.t50 avdd.t612 avdd pfet_05v0 ad=8.3556p pd=38.86u as=8.3556p ps=38.86u w=18.99u l=8u
X268 avss.t191 avss.t189 avss.t190 avss nfet_05v0 ad=8.1356p pd=37.86u as=0 ps=0 w=18.49u l=6u
X269 avdd.t24 avdd.t22 avdd.t23 avdd pfet_05v0 ad=8.25p pd=38.38u as=0 ps=0 w=18.75u l=8u
X270 avss.t182 avss.t180 avss.t181 avss nfet_05v0 ad=8.1356p pd=37.86u as=0 ps=0 w=18.49u l=6u
X271 vbn_sink.t13 vbp_i.t30 avdd.t618 avdd pfet_05v0 ad=8.338p pd=38.78u as=8.338p ps=38.78u w=18.95u l=8u
X272 avdd.t502 avdd.t500 avdd.t501 avdd pfet_05v0 ad=9.7724p pd=45.3u as=0 ps=0 w=22.21u l=8u
X273 vbp_i.t8 vbp_i.t7 avdd.t581 avdd pfet_05v0 ad=8.25p pd=38.38u as=8.25p ps=38.38u w=18.75u l=8u
X274 vbn_sink.t5 vbp_i.t39 avdd.t585 avdd pfet_05v0 ad=8.338p pd=38.78u as=8.338p ps=38.78u w=18.95u l=8u
X275 avss.t53 avss.t51 avss.t52 avss nfet_05v0 ad=7.1896p pd=33.56u as=0 ps=0 w=16.34u l=8u
X276 avdd.t493 avdd.t491 avdd.t492 avdd pfet_05v0 ad=9.1344p pd=42.4u as=0 ps=0 w=20.76u l=4u
X277 xf2.t0 v2.t4 vsp.t0 avdd pfet_05v0 ad=24.1516p pd=0.11066m as=24.1516p ps=0.11066m w=54.89u l=4u
X278 avdd.t404 avdd.t402 avdd.t403 avdd pfet_05v0 ad=7.37p pd=34.38u as=0 ps=0 w=16.75u l=2u
X279 b6_b.t0 b6.t0 dvdd.t3 dvdd pfet_03v3 ad=1.32p pd=6.88u as=1.32p ps=6.88u w=3u l=0.5u
X280 psrg_mf1_protected.t0 vbn_fold.t15 xf1.t2 avss nfet_05v0 ad=8.1356p pd=37.86u as=8.1356p ps=37.86u w=18.49u l=6u
X281 pm1.t5 y1.t8 avdd.t596 avdd pfet_05v0 ad=9.1344p pd=42.4u as=9.1344p ps=42.4u w=20.76u l=4u
X282 bgsu1 bgsu1 bgsu2 avss nfet_03v3 ad=0.44p pd=2.88u as=0.44p ps=2.88u w=1u l=2u
X283 psrg_m3_feed.t1 psrg_vnc.t11 psrg_m3_protected.t2 avss nfet_05v0 ad=6.424p pd=30.08u as=6.424p ps=30.08u w=14.6u l=4u
X284 vx1.t1 psrg_m3_feed.t23 avdd.t600 avdd pfet_05v0 ad=7.37p pd=34.38u as=7.37p ps=34.38u w=16.75u l=2u
X285 vgn1.t7 vcasp vx1.t9 avdd pfet_05v0 ad=7.2248p pd=33.72u as=7.2248p ps=33.72u w=16.42u l=4u
X286 avdd.t514 avdd.t512 avdd.t513 avdd pfet_05v0 ad=9.7724p pd=45.3u as=0 ps=0 w=22.21u l=8u
X287 vbp_bias.t9 vbp_bias.t8 avdd.t620 avdd pfet_03v3 ad=8.3864p pd=39u as=8.3864p ps=39u w=19.06u l=8u
X288 avdd.t231 avdd.t229 avdd.t230 avdd pfet_05v0 ad=7.2248p pd=33.72u as=0 ps=0 w=16.42u l=4u
X289 avdd.t174 avdd.t172 avdd.t173 avdd pfet_05v0 ad=8.338p pd=38.78u as=0 ps=0 w=18.95u l=8u
X290 avss.t92 avss.t90 avss.t91 avss nfet_05v0 ad=3.322p pd=15.98u as=0 ps=0 w=7.55u l=4u
X291 psrg_vnc.t4 vbp_i.t14 avdd.t610 avdd pfet_05v0 ad=7.8056p pd=36.36u as=7.8056p ps=36.36u w=17.74u l=4u
X292 avdd.t63 avdd.t61 avdd.t62 avdd pfet_05v0 ad=8.3556p pd=38.86u as=0 ps=0 w=18.99u l=8u
X293 avss.t59 avss.t57 avss.t58 avss nfet_05v0 ad=6.424p pd=30.08u as=0 ps=0 w=14.6u l=4u
X294 vbn_fold.t10 vbp_i.t42 avdd.t642 avdd pfet_05v0 ad=8.3556p pd=38.86u as=8.3556p ps=38.86u w=18.99u l=8u
X295 avdd.t341 avdd.t339 avdd.t340 avdd pfet_05v0 ad=7.2248p pd=33.72u as=0 ps=0 w=16.42u l=4u
X296 b1_b.t0 b1.t2 dvdd.t6 dvdd pfet_03v3 ad=1.32p pd=6.88u as=1.32p ps=6.88u w=3u l=0.5u
X297 iref_gate.t1 vbp_i.t12 avdd.t644 avdd pfet_05v0 ad=35.2p pd=0.16088m as=35.2p ps=0.16088m w=80u l=1u
X298 vbp_cas.t8 vbp_cas.t7 vbp_bias.t24 avdd pfet_05v0 ad=8.3292p pd=38.74u as=8.3292p ps=38.74u w=18.93u l=8u
X299 vq3.t1 rbit6top.t4 avss ppolyf_u_1k r_width=6.6u r_length=0.128m
X300 avss.t83 avss.t81 avss.t82 avss nfet_05v0 ad=3.322p pd=15.98u as=0 ps=0 w=7.55u l=4u
X301 vgn1.t4 vgn1.t3 v1.t1 avss nfet_05v0 ad=6.424p pd=30.08u as=6.424p ps=30.08u w=14.6u l=4u
X302 avdd.t60 avdd.t58 avdd.t59 avdd pfet_05v0 ad=8.3556p pd=38.86u as=0 ps=0 w=18.99u l=8u
X303 avdd.t414 avdd.t413 avdd.t414 avdd pfet_05v0 ad=24.1516p pd=0.11066m as=0 ps=0 w=54.89u l=4u
X304 vq3.t0 b6_b.t2 rbit6top.t5 dvdd pfet_03v3 ad=1.65p pd=8.38u as=1.65p ps=8.38u w=3.75u l=0.28u
X305 avdd.t356 avdd.t354 avdd.t355 avdd pfet_05v0 ad=7.2248p pd=33.72u as=0 ps=0 w=16.42u l=4u
X306 vbp_cas.t6 vbp_cas.t5 vbp_bias.t23 avdd pfet_05v0 ad=8.3292p pd=38.74u as=8.3292p ps=38.74u w=18.93u l=8u
X307 avdd.t219 avdd.t217 avdd.t218 avdd pfet_05v0 ad=7.2248p pd=33.72u as=0 ps=0 w=16.42u l=4u
X308 rbit3top.t5 b2_b.t4 rbit2top.t9 dvdd pfet_03v3 ad=8.8p pd=40.88u as=8.8p ps=40.88u w=20u l=0.28u
X309 avdd.t359 avdd.t357 avdd.t358 avdd pfet_05v0 ad=7.2248p pd=33.72u as=0 ps=0 w=16.42u l=4u
X310 avss.t173 avss.t171 avss.t172 avss nfet_05v0 ad=8.1356p pd=37.86u as=0 ps=0 w=18.49u l=6u
X311 vref.t4 vcasp vx3.t7 avdd pfet_05v0 ad=7.2248p pd=33.72u as=7.2248p ps=33.72u w=16.42u l=4u
X312 vbp_cas.t12 vbp_cas.t11 vbp_bias.t21 avdd pfet_05v0 ad=8.3292p pd=38.74u as=8.3292p ps=38.74u w=18.93u l=8u
X313 psrg_vnc.t0 vbp_i.t16 avdd.t582 avdd pfet_05v0 ad=7.8056p pd=36.36u as=7.8056p ps=36.36u w=17.74u l=4u
X314 psrg_m3_protected.t3 vgn2.t8 v2.t1 avss nfet_05v0 ad=6.424p pd=30.08u as=6.424p ps=30.08u w=14.6u l=4u
X315 vx3.t2 psrg_m3_feed.t11 avdd.t599 avdd pfet_05v0 ad=7.37p pd=34.38u as=7.37p ps=34.38u w=16.75u l=2u
X316 xf2.t4 vbn_sink.t29 avss.t205 avss nfet_05v0 ad=7.1896p pd=33.56u as=7.1896p ps=33.56u w=16.34u l=8u
X317 vx3.t10 psrg_m3_feed.t16 avdd.t666 avdd pfet_05v0 ad=7.37p pd=34.38u as=7.37p ps=34.38u w=16.75u l=2u
X318 avdd.t460 avdd.t459 avdd.t460 avdd pfet_05v0 ad=24.1516p pd=0.11066m as=0 ps=0 w=54.89u l=4u
X319 avdd.t289 avdd.t288 avdd.t289 avdd pfet_05v0 ad=24.1516p pd=0.11066m as=0 ps=0 w=54.89u l=4u
X320 psrg_m3_protected.t0 vgn2.t9 v2.t0 avss nfet_05v0 ad=6.424p pd=30.08u as=6.424p ps=30.08u w=14.6u l=4u
X321 vgn1.t9 vcasp vx1.t6 avdd pfet_05v0 ad=7.2248p pd=33.72u as=7.2248p ps=33.72u w=16.42u l=4u
X322 avdd.t54 avdd.t52 avdd.t53 avdd pfet_05v0 ad=8.3556p pd=38.86u as=0 ps=0 w=18.99u l=8u
X323 avdd.t401 avdd.t399 avdd.t400 avdd pfet_05v0 ad=7.37p pd=34.38u as=0 ps=0 w=16.75u l=2u
X324 vgn1.t8 vcasp vx1.t10 avdd pfet_05v0 ad=7.2248p pd=33.72u as=7.2248p ps=33.72u w=16.42u l=4u
X325 avdd.t317 avdd.t315 avdd.t316 avdd pfet_05v0 ad=7.2248p pd=33.72u as=0 ps=0 w=16.42u l=4u
X326 avdd.t454 avdd.t453 avdd.t454 avdd pfet_05v0 ad=24.1516p pd=0.11066m as=0 ps=0 w=54.89u l=4u
X327 rbit2top.t0 b2.t2 rbit3top.t0 dvss nfet_03v3 ad=8.8p pd=40.88u as=8.8p ps=40.88u w=20u l=0.28u
X328 xf1.t10 v1.t2 vsp.t12 avdd pfet_05v0 ad=24.1516p pd=0.11066m as=24.1516p ps=0.11066m w=54.89u l=4u
X329 avdd.t99 avdd.t97 avdd.t98 avdd pfet_05v0 ad=8.25p pd=38.38u as=0 ps=0 w=18.75u l=8u
X330 avdd.t180 avdd.t178 avdd.t179 avdd pfet_05v0 ad=8.338p pd=38.78u as=0 ps=0 w=18.95u l=8u
X331 vx2.t5 psrg_m3_feed.t9 avdd.t564 avdd pfet_05v0 ad=7.37p pd=34.38u as=7.37p ps=34.38u w=16.75u l=2u
X332 vsu psrg_m3_feed.t8 avdd.t649 avdd pfet_05v0 ad=0.88p pd=4.88u as=0.88p ps=4.88u w=2u l=2u
X333 avdd.t96 avdd.t94 avdd.t95 avdd pfet_05v0 ad=8.25p pd=38.38u as=0 ps=0 w=18.75u l=8u
X334 vref.t7 avss.t220 cap_mim_2f0_m4m5_noshield c_width=70.7u c_length=70.7u
X335 avdd.t177 avdd.t175 avdd.t176 avdd pfet_05v0 ad=8.338p pd=38.78u as=0 ps=0 w=18.95u l=8u
X336 rbit5top.t2 b5.t1 rbit6top.t2 dvss nfet_03v3 ad=1.1p pd=5.88u as=1.1p ps=5.88u w=2.5u l=0.28u
X337 avdd.t440 avdd.t438 avdd.t439 avdd pfet_05v0 ad=9.7724p pd=45.3u as=0 ps=0 w=22.21u l=8u
X338 xf2.t6 v2.t6 vsp.t4 avdd pfet_05v0 ad=24.1516p pd=0.11066m as=24.1516p ps=0.11066m w=54.89u l=4u
X339 avss.t68 avss.t66 avss.t67 avss nfet_05v0 ad=6.424p pd=30.08u as=0 ps=0 w=14.6u l=4u
X340 avdd.t21 avdd.t19 avdd.t20 avdd pfet_05v0 ad=8.25p pd=38.38u as=0 ps=0 w=18.75u l=8u
X341 vref.t7 avss.t230 cap_mim_2f0_m4m5_noshield c_width=70.7u c_length=70.7u
X342 avdd.t407 avdd.t405 avdd.t406 avdd pfet_05v0 ad=7.37p pd=34.38u as=0 ps=0 w=16.75u l=2u
X343 vbp_bias.t13 vbp_bias.t12 avdd.t655 avdd pfet_03v3 ad=8.3864p pd=39u as=8.3864p ps=39u w=19.06u l=8u
X344 rbit1top.t0 rbit0top.t0 avss ppolyf_u_1k r_width=6.6u r_length=2u
X345 vgn1.t6 vcasp vx1.t7 avdd pfet_05v0 ad=7.2248p pd=33.72u as=7.2248p ps=33.72u w=16.42u l=4u
X346 vref.t10 avss.t214 cap_mim_2f0_m4m5_noshield c_width=70.7u c_length=70.7u
X347 vbn_i.t6 vbp_i.t53 avdd.t598 avdd pfet_05v0 ad=8.25p pd=38.38u as=8.25p ps=38.38u w=18.75u l=8u
X348 avdd.t18 avdd.t16 avdd.t17 avdd pfet_05v0 ad=8.25p pd=38.38u as=0 ps=0 w=18.75u l=8u
X349 avdd.t297 avdd.t296 avdd.t297 avdd pfet_05v0 ad=24.1516p pd=0.11066m as=0 ps=0 w=54.89u l=4u
X350 vbn_i.t7 vbp_i.t55 avdd.t607 avdd pfet_05v0 ad=8.25p pd=38.38u as=8.25p ps=38.38u w=18.75u l=8u
X351 avdd.t141 avdd.t139 avdd.t140 avdd pfet_05v0 ad=8.3556p pd=38.86u as=0 ps=0 w=18.99u l=8u
X352 vref.t10 avss.t224 cap_mim_2f0_m4m5_noshield c_width=70.7u c_length=70.7u
X353 avss.t110 avss.t108 avss.t109 avss nfet_05v0 ad=6.424p pd=30.08u as=0 ps=0 w=14.6u l=4u
X354 avdd.t344 avdd.t342 avdd.t343 avdd pfet_05v0 ad=7.37p pd=34.38u as=0 ps=0 w=16.75u l=2u
X355 b4_b.t0 b4.t0 dvdd.t5 dvdd pfet_03v3 ad=1.32p pd=6.88u as=1.32p ps=6.88u w=3u l=0.5u
X356 vnx_bias vnx_bias avss.t206 avss nfet_03v3 ad=0.7128p pd=4.12u as=0.7128p ps=4.12u w=1.62u l=8u
X357 vbn.t3 vcasp vaux.t0 avdd pfet_05v0 ad=7.04p pd=32.88u as=7.04p ps=32.88u w=16u l=4u
X358 vx1.t3 psrg_m3_feed.t15 avdd.t665 avdd pfet_05v0 ad=7.37p pd=34.38u as=7.37p ps=34.38u w=16.75u l=2u
X359 rbit2top.t7 b1_b.t2 rbit1top.t4 dvdd pfet_03v3 ad=17.6p pd=80.88u as=17.6p ps=80.88u w=40u l=0.28u
X360 vbn_fold.t11 vbp_i.t43 avdd.t643 avdd pfet_05v0 ad=8.3556p pd=38.86u as=8.3556p ps=38.86u w=18.99u l=8u
X361 pm2.t5 y1.t7 avdd.t638 avdd pfet_05v0 ad=9.1344p pd=42.4u as=9.1344p ps=42.4u w=20.76u l=4u
X362 avss.t71 avss.t69 avss.t70 avss nfet_05v0 ad=6.424p pd=30.08u as=0 ps=0 w=14.6u l=4u
X363 avdd.t252 avdd.t250 avdd.t251 avdd pfet_05v0 ad=7.2248p pd=33.72u as=0 ps=0 w=16.42u l=4u
X364 vbn_sink.t0 vbp_i.t36 avdd.t571 avdd pfet_05v0 ad=8.338p pd=38.78u as=8.338p ps=38.78u w=18.95u l=8u
X365 vbn_fold.t2 vbp_i.t44 avdd.t586 avdd pfet_05v0 ad=8.3556p pd=38.86u as=8.3556p ps=38.86u w=18.99u l=8u
X366 avss.t194 avss.t192 avss.t193 avss nfet_05v0 ad=8.1356p pd=37.86u as=0 ps=0 w=18.49u l=6u
X367 b1_b.t1 b1.t1 dvss.t6 dvss nfet_03v3 ad=0.44p pd=2.88u as=0.44p ps=2.88u w=1u l=0.5u
X368 avss.t62 avss.t60 avss.t61 avss nfet_05v0 ad=6.424p pd=30.08u as=0 ps=0 w=14.6u l=4u
X369 vbp_bias.t11 vbp_bias.t10 avdd.t621 avdd pfet_03v3 ad=8.3864p pd=39u as=8.3864p ps=39u w=19.06u l=8u
X370 xf2.t9 vbn_sink.t21 avss.t208 avss nfet_05v0 ad=7.1896p pd=33.56u as=7.1896p ps=33.56u w=16.34u l=8u
X371 rbit1top.t7 b1.t0 rbit2top.t8 dvss nfet_03v3 ad=17.6p pd=80.88u as=17.6p ps=80.88u w=40u l=0.28u
X372 pm1.t1 y1.t16 avdd.t626 avdd pfet_05v0 ad=9.1344p pd=42.4u as=9.1344p ps=42.4u w=20.76u l=4u
X373 vsu vsu bgsu1 avss nfet_05v0 ad=0.44p pd=2.88u as=0.44p ps=2.88u w=1u l=2u
X374 vgn2.t3 vbp_cas.t25 pm2.t10 avdd pfet_05v0 ad=9.7724p pd=45.3u as=9.7724p ps=45.3u w=22.21u l=8u
X375 avss.t86 avss.t84 avss.t85 avss nfet_05v0 ad=3.322p pd=15.98u as=0 ps=0 w=7.55u l=4u
X376 avdd.t523 avdd.t521 avdd.t522 avdd pfet_05v0 ad=9.7724p pd=45.3u as=0 ps=0 w=22.21u l=8u
X377 xf1.t4 vbn_sink.t22 avss.t209 avss nfet_05v0 ad=7.1896p pd=33.56u as=7.1896p ps=33.56u w=16.34u l=8u
X378 b4_b.t1 b4.t1 dvss.t5 dvss nfet_03v3 ad=0.44p pd=2.88u as=0.44p ps=2.88u w=1u l=0.5u
X379 vbn_sink.t19 vbp_i.t34 avdd.t650 avdd pfet_05v0 ad=8.338p pd=38.78u as=8.338p ps=38.78u w=18.95u l=8u
X380 vbp_cas.t20 vbp_cas.t19 vbp_bias.t20 avdd pfet_05v0 ad=8.3292p pd=38.74u as=8.3292p ps=38.74u w=18.93u l=8u
X381 avdd.t117 avdd.t115 avdd.t116 avdd pfet_05v0 ad=8.25p pd=38.38u as=0 ps=0 w=18.75u l=8u
X382 xf1.t0 vbn_sink.t30 avss.t7 avss nfet_05v0 ad=7.1896p pd=33.56u as=7.1896p ps=33.56u w=16.34u l=8u
X383 avdd.t472 avdd.t470 avdd.t471 avdd pfet_05v0 ad=9.7724p pd=45.3u as=0 ps=0 w=22.21u l=8u
X384 vsp.t3 vbp_tail.t7 avdd.t592 avdd pfet_03v3 ad=12.7204p pd=58.7u as=12.7204p ps=58.7u w=28.91u l=6u
X385 avdd.t183 avdd.t181 avdd.t182 avdd pfet_05v0 ad=8.338p pd=38.78u as=0 ps=0 w=18.95u l=8u
X386 vbp_cas.t18 vbp_cas.t17 vbp_bias.t19 avdd pfet_05v0 ad=8.3292p pd=38.74u as=8.3292p ps=38.74u w=18.93u l=8u
X387 aux_gate vbn_i.t8 avss.t213 avss nfet_05v0 ad=0.44p pd=2.88u as=0.44p ps=2.88u w=1u l=8u
X388 avdd.t51 avdd.t49 avdd.t50 avdd pfet_05v0 ad=8.3556p pd=38.86u as=0 ps=0 w=18.99u l=8u
X389 avdd.t39 avdd.t37 avdd.t38 avdd pfet_05v0 ad=8.25p pd=38.38u as=0 ps=0 w=18.75u l=8u
X390 avdd.t338 avdd.t336 avdd.t337 avdd pfet_05v0 ad=7.2248p pd=33.72u as=0 ps=0 w=16.42u l=4u
X391 avdd.t279 avdd.t277 avdd.t278 avdd pfet_05v0 ad=7.37p pd=34.38u as=0 ps=0 w=16.75u l=2u
X392 avdd.t291 avdd.t290 avdd.t291 avdd pfet_05v0 ad=24.1516p pd=0.11066m as=0 ps=0 w=54.89u l=4u
X393 avss.t167 avss.t165 avss.t166 avss nfet_05v0 ad=7.1896p pd=33.56u as=0 ps=0 w=16.34u l=8u
X394 avdd.t48 avdd.t46 avdd.t47 avdd pfet_05v0 ad=8.3556p pd=38.86u as=0 ps=0 w=18.99u l=8u
X395 vgn1.t2 vgn1.t1 v1.t0 avss nfet_05v0 ad=6.424p pd=30.08u as=6.424p ps=30.08u w=14.6u l=4u
X396 rb_mid rb_mid avss.t207 avss nfet_05v0 ad=0.2376p pd=1.96u as=0.2376p ps=1.96u w=0.54u l=20u
X397 avdd.t478 avdd.t476 avdd.t477 avdd pfet_05v0 ad=9.1344p pd=42.4u as=0 ps=0 w=20.76u l=4u
X398 avdd.t456 avdd.t455 avdd.t456 avdd pfet_05v0 ad=24.1516p pd=0.11066m as=0 ps=0 w=54.89u l=4u
X399 avss.t164 avss.t162 avss.t163 avss nfet_05v0 ad=7.1896p pd=33.56u as=0 ps=0 w=16.34u l=8u
X400 avdd.t437 avdd.t435 avdd.t436 avdd pfet_05v0 ad=9.7724p pd=45.3u as=0 ps=0 w=22.21u l=8u
X401 rbit1top.t10 b0_b.t5 rbit0top.t6 dvdd pfet_03v3 ad=17.6p pd=80.88u as=17.6p ps=80.88u w=40u l=0.28u
X402 vref.t3 vcasp vx3.t8 avdd pfet_05v0 ad=7.2248p pd=33.72u as=7.2248p ps=33.72u w=16.42u l=4u
X403 xf2.t11 vbn_sink.t25 avss.t237 avss nfet_05v0 ad=7.1896p pd=33.56u as=7.1896p ps=33.56u w=16.34u l=8u
X404 avdd.t287 avdd.t286 avdd.t287 avdd pfet_05v0 ad=24.1516p pd=0.11066m as=0 ps=0 w=54.89u l=4u
X405 avdd.t108 avdd.t106 avdd.t107 avdd pfet_05v0 ad=8.25p pd=38.38u as=0 ps=0 w=18.75u l=8u
X406 avdd.t434 avdd.t432 avdd.t433 avdd pfet_05v0 ad=9.7724p pd=45.3u as=0 ps=0 w=22.21u l=8u
X407 b0_b.t1 b0.t0 dvss.t2 dvss nfet_03v3 ad=0.44p pd=2.88u as=0.44p ps=2.88u w=1u l=0.5u
X408 y1.t0 vbp_cas.t22 pm1.t6 avdd pfet_05v0 ad=9.7724p pd=45.3u as=9.7724p ps=45.3u w=22.21u l=8u
X409 vbp_tail.t5 vbp_tail.t4 avdd.t661 avdd pfet_03v3 ad=6.05p pd=28.38u as=6.05p ps=28.38u w=13.75u l=6u
X410 rbit6top.t3 b6.t1 vq3.t2 dvss nfet_03v3 ad=0.55p pd=3.38u as=0.55p ps=3.38u w=1.25u l=0.28u
X411 xf2.t2 v2.t7 vsp.t2 avdd pfet_05v0 ad=24.1516p pd=0.11066m as=24.1516p ps=0.11066m w=54.89u l=4u
X412 vbp_i.t2 vbp_i.t1 avdd.t632 avdd pfet_05v0 ad=8.25p pd=38.38u as=8.25p ps=38.38u w=18.75u l=8u
X413 avdd.t464 avdd.t463 avdd.t464 avdd pfet_05v0 ad=24.1516p pd=0.11066m as=0 ps=0 w=54.89u l=4u
X414 vbp_bias.t15 vbp_bias.t14 avdd.t656 avdd pfet_03v3 ad=8.3864p pd=39u as=8.3864p ps=39u w=19.06u l=8u
X415 vbn_i.t1 vbp_i.t56 avdd.t575 avdd pfet_05v0 ad=8.25p pd=38.38u as=8.25p ps=38.38u w=18.75u l=8u
X416 vref.t9 avss.t216 cap_mim_2f0_m4m5_noshield c_width=70.7u c_length=70.7u
X417 avdd.t30 avdd.t28 avdd.t29 avdd pfet_05v0 ad=8.25p pd=38.38u as=0 ps=0 w=18.75u l=8u
X418 avss.t44 avss.t42 avss.t43 avss nfet_05v0 ad=5.4164p pd=25.5u as=0 ps=0 w=12.31u l=8u
X419 avdd.t186 avdd.t184 avdd.t185 avdd pfet_05v0 ad=8.338p pd=38.78u as=0 ps=0 w=18.95u l=8u
X420 vbn_sink.t1 vbp_i.t37 avdd.t572 avdd pfet_05v0 ad=8.338p pd=38.78u as=8.338p ps=38.78u w=18.95u l=8u
X421 vx3.t0 psrg_m3_feed.t12 avdd.t567 avdd pfet_05v0 ad=7.37p pd=34.38u as=7.37p ps=34.38u w=16.75u l=2u
X422 vx2.t1 psrg_m3_feed.t22 avdd.t595 avdd pfet_05v0 ad=7.37p pd=34.38u as=7.37p ps=34.38u w=16.75u l=2u
X423 avdd.t264 avdd.t262 avdd.t263 avdd pfet_05v0 ad=7.37p pd=34.38u as=0 ps=0 w=16.75u l=2u
X424 avdd.t490 avdd.t488 avdd.t489 avdd pfet_05v0 ad=9.1344p pd=42.4u as=0 ps=0 w=20.76u l=4u
X425 vref.t9 avss.t226 cap_mim_2f0_m4m5_noshield c_width=70.7u c_length=70.7u
X426 iref_gate.t0 vbp_i.t11 avdd.t566 avdd pfet_05v0 ad=35.2p pd=0.16088m as=35.2p ps=0.16088m w=80u l=1u
X427 avss.t41 avss.t39 avss.t40 avss nfet_05v0 ad=5.4164p pd=25.5u as=0 ps=0 w=12.31u l=8u
X428 avdd.t282 avdd.t280 avdd.t281 avdd pfet_05v0 ad=7.37p pd=34.38u as=0 ps=0 w=16.75u l=2u
X429 vsua vcasp avdd.t647 avdd pfet_05v0 ad=0.88p pd=4.88u as=0.88p ps=4.88u w=2u l=2u
X430 avdd.t228 avdd.t226 avdd.t227 avdd pfet_05v0 ad=7.2248p pd=33.72u as=0 ps=0 w=16.42u l=4u
X431 vbn_sink.t3 vbp_i.t29 avdd.t579 avdd pfet_05v0 ad=8.338p pd=38.78u as=8.338p ps=38.78u w=18.95u l=8u
X432 vbn_sink.t4 vbp_i.t38 avdd.t584 avdd pfet_05v0 ad=8.338p pd=38.78u as=8.338p ps=38.78u w=18.95u l=8u
X433 avss.t155 avss.t153 avss.t154 avss nfet_05v0 ad=7.1896p pd=33.56u as=0 ps=0 w=16.34u l=8u
X434 psrg_vnc.t8 vbp_i.t13 avdd.t645 avdd pfet_05v0 ad=7.8056p pd=36.36u as=7.8056p ps=36.36u w=17.74u l=4u
X435 b6_b.t1 b6.t2 dvss.t3 dvss nfet_03v3 ad=0.44p pd=2.88u as=0.44p ps=2.88u w=1u l=0.5u
X436 avdd.t428 avdd.t426 avdd.t427 avdd pfet_05v0 ad=9.7724p pd=45.3u as=0 ps=0 w=22.21u l=8u
X437 vsu1 vbp_i.t22 vsu2 avss nfet_05v0 ad=0.22p pd=1.88u as=0.22p ps=1.88u w=0.5u l=50u
X438 avdd.t398 avdd.t396 avdd.t397 avdd pfet_05v0 ad=7.37p pd=34.38u as=0 ps=0 w=16.75u l=2u
X439 avss.t65 avss.t63 avss.t64 avss nfet_05v0 ad=6.424p pd=30.08u as=0 ps=0 w=14.6u l=4u
X440 vbp_i.t4 vbp_i.t3 avdd.t574 avdd pfet_05v0 ad=8.25p pd=38.38u as=8.25p ps=38.38u w=18.75u l=8u
X441 avdd.t425 avdd.t423 avdd.t424 avdd pfet_05v0 ad=9.7724p pd=45.3u as=0 ps=0 w=22.21u l=8u
X442 bgsu2 bgsu2 avss.t240 avss nfet_03v3 ad=0.44p pd=2.88u as=0.44p ps=2.88u w=1u l=2u
X443 y1.t6 vbp_cas.t27 pm1.t11 avdd pfet_05v0 ad=9.7724p pd=45.3u as=9.7724p ps=45.3u w=22.21u l=8u
X444 xf1.t8 v1.t4 vsp.t10 avdd pfet_05v0 ad=24.1516p pd=0.11066m as=24.1516p ps=0.11066m w=54.89u l=4u
X445 vcasp vbn.t4 avss.t212 avss nfet_05v0 ad=3.322p pd=15.98u as=3.322p ps=15.98u w=7.55u l=4u
X446 b2_b.t1 b2.t1 dvss.t0 dvss nfet_03v3 ad=0.44p pd=2.88u as=0.44p ps=2.88u w=1u l=0.5u
X447 avdd.t165 avdd.t163 avdd.t164 avdd pfet_05v0 ad=8.338p pd=38.78u as=0 ps=0 w=18.95u l=8u
X448 avdd.t129 avdd.t127 avdd.t128 avdd pfet_05v0 ad=8.3556p pd=38.86u as=0 ps=0 w=18.99u l=8u
X449 vx1.t2 psrg_m3_feed.t20 avdd.t593 avdd pfet_05v0 ad=7.37p pd=34.38u as=7.37p ps=34.38u w=16.75u l=2u
X450 su_state.t1 vgn2.t10 avss.t202 avss nfet_05v0 ad=1.76p pd=8.88u as=1.76p ps=8.88u w=4u l=1u
X451 vgn2.t2 vbp_cas.t28 pm2.t11 avdd pfet_05v0 ad=9.7724p pd=45.3u as=9.7724p ps=45.3u w=22.21u l=8u
X452 avdd.t347 avdd.t345 avdd.t346 avdd pfet_05v0 ad=7.37p pd=34.38u as=0 ps=0 w=16.75u l=2u
X453 vref.t0 vcasp vx3.t4 avdd pfet_05v0 ad=7.2248p pd=33.72u as=7.2248p ps=33.72u w=16.42u l=4u
X454 rbit3top.t7 b2_b.t2 rbit2top.t4 dvdd pfet_03v3 ad=8.8p pd=40.88u as=8.8p ps=40.88u w=20u l=0.28u
X455 rbit5top.t5 rbit4top.t4 avss ppolyf_u_1k r_width=6.6u r_length=32u
X456 avdd.t508 avdd.t506 avdd.t507 avdd pfet_05v0 ad=9.1344p pd=42.4u as=0 ps=0 w=20.76u l=4u
X457 auxsu1 auxsu1 auxsu2 avss nfet_03v3 ad=0.44p pd=2.88u as=0.44p ps=2.88u w=1u l=2u
X458 vgn1.t5 vcasp vx1.t8 avdd pfet_05v0 ad=7.2248p pd=33.72u as=7.2248p ps=33.72u w=16.42u l=4u
X459 vsp.t14 vbp_tail.t8 avdd.t660 avdd pfet_03v3 ad=12.7204p pd=58.7u as=12.7204p ps=58.7u w=28.91u l=6u
X460 avdd.t126 avdd.t124 avdd.t125 avdd pfet_05v0 ad=8.3556p pd=38.86u as=0 ps=0 w=18.99u l=8u
X461 vbn_sink.t14 vbp_i.t31 avdd.t619 avdd pfet_05v0 ad=8.338p pd=38.78u as=8.338p ps=38.78u w=18.95u l=8u
X462 avss.t29 avss.t27 avss.t28 avss nfet_05v0 ad=7.1896p pd=33.56u as=0 ps=0 w=16.34u l=8u
X463 b0_b.t0 b0.t1 dvdd.t2 dvdd pfet_03v3 ad=1.32p pd=6.88u as=1.32p ps=6.88u w=3u l=0.5u
X464 avdd.t383 avdd.t381 avdd.t382 avdd pfet_05v0 ad=7.2248p pd=33.72u as=0 ps=0 w=16.42u l=4u
X465 avss.t116 avss.t114 avss.t115 avss nfet_05v0 ad=3.322p pd=15.98u as=0 ps=0 w=7.55u l=4u
X466 rbit2top.t1 rbit1top.t1 avss ppolyf_u_1k r_width=6.6u r_length=4u
X467 avdd.t326 avdd.t324 avdd.t325 avdd pfet_05v0 ad=7.37p pd=34.38u as=0 ps=0 w=16.75u l=2u
X468 aux_gate vcasp avdd.t646 avdd pfet_05v0 ad=0.22p pd=1.88u as=0.22p ps=1.88u w=0.5u l=10u
X469 avss.t26 avss.t24 avss.t25 avss nfet_05v0 ad=7.1896p pd=33.56u as=0 ps=0 w=16.34u l=8u
X470 vx3.t1 psrg_m3_feed.t21 avdd.t594 avdd pfet_05v0 ad=7.37p pd=34.38u as=7.37p ps=34.38u w=16.75u l=2u
X471 avdd.t240 avdd.t238 avdd.t239 avdd pfet_05v0 ad=7.2248p pd=33.72u as=0 ps=0 w=16.42u l=4u
X472 avdd.t553 avdd.t551 avdd.t552 avdd pfet_05v0 ad=9.1344p pd=42.4u as=0 ps=0 w=20.76u l=4u
X473 avss.t113 avss.t111 avss.t112 avss nfet_05v0 ad=3.322p pd=15.98u as=0 ps=0 w=7.55u l=4u
X474 avdd.t314 avdd.t312 avdd.t313 avdd pfet_05v0 ad=7.2248p pd=33.72u as=0 ps=0 w=16.42u l=4u
X475 xf1.t11 vbn_sink.t26 avss.t238 avss nfet_05v0 ad=7.1896p pd=33.56u as=7.1896p ps=33.56u w=16.34u l=8u
X476 vgn2.t4 vbp_cas.t24 pm2.t7 avdd pfet_05v0 ad=9.7724p pd=45.3u as=9.7724p ps=45.3u w=22.21u l=8u
X477 avdd.t532 avdd.t530 avdd.t531 avdd pfet_05v0 ad=9.7724p pd=45.3u as=0 ps=0 w=22.21u l=8u
X478 avdd.t105 avdd.t103 avdd.t104 avdd pfet_05v0 ad=8.25p pd=38.38u as=0 ps=0 w=18.75u l=8u
X479 avdd.t544 avdd.t542 avdd.t543 avdd pfet_05v0 ad=9.1344p pd=42.4u as=0 ps=0 w=20.76u l=4u
X480 rbit1top.t13 b0_b.t2 rbit0top.t5 dvdd pfet_03v3 ad=17.6p pd=80.88u as=17.6p ps=80.88u w=40u l=0.28u
X481 y1.t3 vbp_cas.t30 pm1.t8 avdd pfet_05v0 ad=9.7724p pd=45.3u as=9.7724p ps=45.3u w=22.21u l=8u
X482 avss.t143 avss.t141 avss.t142 avss nfet_05v0 ad=7.1896p pd=33.56u as=0 ps=0 w=16.34u l=8u
X483 vsp.t15 vbp_tail.t10 avdd.t662 avdd pfet_03v3 ad=12.7204p pd=58.7u as=12.7204p ps=58.7u w=28.91u l=6u
X484 avdd.t90 avdd.t88 avdd.t89 avdd pfet_05v0 ad=8.25p pd=38.38u as=0 ps=0 w=18.75u l=8u
X485 vx2.t4 psrg_m3_feed.t14 avdd.t664 avdd pfet_05v0 ad=7.37p pd=34.38u as=7.37p ps=34.38u w=16.75u l=2u
X486 y1.t4 vbp_cas.t31 pm1.t9 avdd pfet_05v0 ad=9.7724p pd=45.3u as=9.7724p ps=45.3u w=22.21u l=8u
X487 avdd.t66 avdd.t64 avdd.t65 avdd pfet_05v0 ad=8.25p pd=38.38u as=0 ps=0 w=18.75u l=8u
X488 avdd.t475 avdd.t473 avdd.t474 avdd pfet_05v0 ad=9.1344p pd=42.4u as=0 ps=0 w=20.76u l=4u
X489 xf1.t7 v1.t6 vsp.t8 avdd pfet_05v0 ad=24.1516p pd=0.11066m as=24.1516p ps=0.11066m w=54.89u l=4u
X490 avss.t176 avss.t174 avss.t175 avss nfet_05v0 ad=8.1356p pd=37.86u as=0 ps=0 w=18.49u l=6u
X491 vx3.t3 psrg_m3_feed.t19 avdd.t630 avdd pfet_05v0 ad=7.37p pd=34.38u as=7.37p ps=34.38u w=16.75u l=2u
X492 avdd.t27 avdd.t25 avdd.t26 avdd pfet_05v0 ad=8.25p pd=38.38u as=0 ps=0 w=18.75u l=8u
X493 avdd.t237 avdd.t235 avdd.t236 avdd pfet_05v0 ad=7.2248p pd=33.72u as=0 ps=0 w=16.42u l=4u
X494 avdd.t392 avdd.t390 avdd.t391 avdd pfet_05v0 ad=7.37p pd=34.38u as=0 ps=0 w=16.75u l=2u
X495 avdd.t255 avdd.t253 avdd.t254 avdd pfet_05v0 ad=7.2248p pd=33.72u as=0 ps=0 w=16.42u l=4u
X496 auxsu2 auxsu2 avss.t0 avss nfet_03v3 ad=0.44p pd=2.88u as=0.44p ps=2.88u w=1u l=2u
X497 avdd.t12 avdd.t10 avdd.t11 avdd pfet_05v0 ad=8.25p pd=38.38u as=0 ps=0 w=18.75u l=8u
X498 rbit1top.t9 b0_b.t6 rbit0top.t9 dvdd pfet_03v3 ad=17.6p pd=80.88u as=17.6p ps=80.88u w=40u l=0.28u
X499 avss.t125 avss.t123 avss.t124 avss nfet_05v0 ad=3.322p pd=15.98u as=0 ps=0 w=7.55u l=4u
X500 avdd.t466 avdd.t465 avdd.t466 avdd pfet_05v0 ad=24.1516p pd=0.11066m as=0 ps=0 w=54.89u l=4u
X501 avss.t38 avss.t36 avss.t37 avss nfet_05v0 ad=5.4164p pd=25.5u as=0 ps=0 w=12.31u l=8u
X502 avdd.t147 avdd.t145 avdd.t146 avdd pfet_05v0 ad=8.3556p pd=38.86u as=0 ps=0 w=18.99u l=8u
X503 pm2.t1 y1.t15 avdd.t625 avdd pfet_05v0 ad=9.1344p pd=42.4u as=9.1344p ps=42.4u w=20.76u l=4u
X504 avdd.t210 avdd.t208 avdd.t209 avdd pfet_05v0 ad=8.338p pd=38.78u as=0 ps=0 w=18.95u l=8u
X505 avss.t17 avss.t15 avss.t16 avss nfet_05v0 ad=7.1896p pd=33.56u as=0 ps=0 w=16.34u l=8u
X506 avss.t152 avss.t150 avss.t151 avss nfet_05v0 ad=7.1896p pd=33.56u as=0 ps=0 w=16.34u l=8u
X507 avdd.t499 avdd.t497 avdd.t498 avdd pfet_05v0 ad=9.7724p pd=45.3u as=0 ps=0 w=22.21u l=8u
X508 rbit2top.t6 b1_b.t3 rbit1top.t5 dvdd pfet_03v3 ad=17.6p pd=80.88u as=17.6p ps=80.88u w=40u l=0.28u
X509 avdd.t412 avdd.t411 avdd.t412 avdd pfet_05v0 ad=24.1516p pd=0.11066m as=0 ps=0 w=54.89u l=4u
X510 avss.t35 avss.t33 avss.t34 avss nfet_05v0 ad=5.4164p pd=25.5u as=0 ps=0 w=12.31u l=8u
X511 avdd.t144 avdd.t142 avdd.t143 avdd pfet_05v0 ad=8.3556p pd=38.86u as=0 ps=0 w=18.99u l=8u
X512 avss.t149 avss.t147 avss.t148 avss nfet_05v0 ad=7.1896p pd=33.56u as=0 ps=0 w=16.34u l=8u
X513 avdd.t422 avdd.t420 avdd.t421 avdd pfet_05v0 ad=9.7724p pd=45.3u as=0 ps=0 w=22.21u l=8u
X514 avdd.t311 avdd.t310 avdd.t311 avdd pfet_05v0 ad=24.1516p pd=0.11066m as=0 ps=0 w=54.89u l=4u
X515 avss.t128 avss.t126 avss.t127 avss nfet_05v0 ad=3.322p pd=15.98u as=0 ps=0 w=7.55u l=4u
X516 vgn2.t5 vbp_cas.t21 pm2.t6 avdd pfet_05v0 ad=9.7724p pd=45.3u as=9.7724p ps=45.3u w=22.21u l=8u
X517 pm1.t0 y1.t17 avdd.t627 avdd pfet_05v0 ad=9.1344p pd=42.4u as=9.1344p ps=42.4u w=20.76u l=4u
X518 avdd.t419 avdd.t417 avdd.t418 avdd pfet_05v0 ad=9.7724p pd=45.3u as=0 ps=0 w=22.21u l=8u
X519 psrg_vnc.t3 vbp_i.t19 avdd.t606 avdd pfet_05v0 ad=7.8056p pd=36.36u as=7.8056p ps=36.36u w=17.74u l=4u
X520 avss.t80 avss.t78 avss.t79 avss nfet_05v0 ad=6.424p pd=30.08u as=0 ps=0 w=14.6u l=4u
X521 rbit0top.t2 b0.t3 rbit1top.t2 dvss nfet_03v3 ad=17.6p pd=80.88u as=17.6p ps=80.88u w=40u l=0.28u
R0 v1.n4 v1.t2 67.301
R1 v1.n1 v1.t6 65.546
R2 v1.n7 v1.t5 65.501
R3 v1.n4 v1.t3 65.4526
R4 v1.n5 v1.t4 65.4526
R5 v1.n1 v1.n0 46.7105
R6 v1.n2 v1.n0 18.0905
R7 v1.n3 v1.t1 15.379
R8 v1.n2 v1.t0 13.8293
R9 v1.n10 v1.n0 12.5555
R10 v1 v1.n10 10.3505
R11 v1.n5 v1.n4 7.6505
R12 v1.n9 v1.n8 4.3205
R13 v1.n1 v1.n7 3.8705
R14 v1.n9 v1.n3 2.50901
R15 v1.n10 v1.n9 1.9375
R16 v1.n8 v1.n1 1.1705
R17 v1.n8 v1.n6 0.699338
R18 v1.n6 v1.n5 0.555141
R19 v1.n7 v1.n6 0.480177
R20 v1.n3 v1.n2 0.233095
R21 net4 net4.t0 29.5063
R22 vq2 vq2.t0 48.3193
R23 net3 net3.t0 140.775
R24 vref.n8 vref.n2 94.7008
R25 vref.n9 vref.n8 30.3305
R26 vref.n20 vref.t8 26.4086
R27 vref.n0 vref.n23 26.2393
R28 vref.n23 vref.n22 25.4255
R29 vref.n20 vref.n19 25.4132
R30 vref.n10 vref.n9 21.9584
R31 vref.n1 vref.n6 23.1069
R32 vref.n21 vref.n4 17.2918
R33 vref.n13 vref.n12 14.8505
R34 vref.n12 vref.t3 13.8364
R35 vref.t10 vref.n18 10.148
R36 vref.n8 vref.t5 10.0775
R37 vref.n10 vref.t1 9.28143
R38 vref.n15 vref.t2 9.27752
R39 vref.n13 vref.t4 9.27361
R40 vref.n15 vref.n14 9.2705
R41 vref.n22 vref.n21 9.09275
R42 vref.n23 vref.n5 9.07925
R43 vref.n3 vref.n20 9.04959
R44 vref.n6 vref.t7 9.0005
R45 vref.n21 vref.t8 9.0005
R46 vref.t9 vref.n4 9.0005
R47 vref.n2 vref.t10 6.00456
R48 vref.n19 vref.n2 10.435
R49 vref.n19 vref.n4 8.2985
R50 vref.n22 vref.n6 8.21525
R51 vref.n17 vref.n10 7.6505
R52 vref.n9 vref.t0 4.78535
R53 vref.t6 vref.n1 0.216539
R54 vref.n14 vref.n13 4.5005
R55 vref.n16 vref.n15 4.5005
R56 vref.n12 vref.n11 2.0495
R57 vref.n17 vref.n16 1.4405
R58 vref vref.n1 0.962795
R59 vref.n16 vref.n7 1.1255
R60 vref.n18 vref.n17 1.1255
R61 vref.n14 vref.n11 1.1255
R62 vref.n3 vref.t10 0.94092
R63 vref.n0 vref.t7 0.891923
R64 vref.t8 vref.n5 0.8835
R65 vref.n11 vref.n7 0.4325
R66 vref.t8 vref.t9 0.254749
R67 vref.t6 vref.n0 0.145476
R68 vref.n18 vref.n7 0.1445
R69 vref.n5 vref.t7 0.138968
R70 vref.t9 vref.n3 0.138893
R71 b1.n1 b1.t0 553.995
R72 b1.n0 b1.t2 52.3518
R73 b1.n0 b1.t1 34.9128
R74 b1 b1.n1 34.0655
R75 b1.n1 b1.n0 8.7305
R76 b2.n0 b2.t2 299.99
R77 b2.n1 b2.t0 44.8554
R78 b2.n0 b2.t1 30.7964
R79 b2 b2.n1 27.8105
R80 b2.n1 b2.n0 23.4005
R81 vq3 vq3.n0 46.2005
R82 vq3.n2 vq3.n1 28.2605
R83 vq3.n0 vq3.t0 22.347
R84 vq3 vq3.n2 14.9345
R85 vq3.n2 vq3.t1 14.5632
R86 vq3.n1 vq3.t2 13.5475
R87 vq3.n1 vq3.n0 4.5005
R88 b6 b6.n1 46.0805
R89 b6.n1 b6.t0 44.9115
R90 b6.n0 b6.t2 44.5322
R91 b6.n0 b6.t1 42.8627
R92 b6.n1 b6.n0 11.8355
R93 b5.n0 b5.t1 63.7544
R94 b5.n0 b5.t2 49.1564
R95 b5.n1 b5.t0 45.1489
R96 b5 b5.n1 37.0805
R97 b5.n1 b5.n0 6.2105
R98 b0.n0 b0.t3 557.883
R99 b0.n0 b0.t2 547.923
R100 b0.n1 b0.t1 44.9587
R101 b0 b0.n2 44.2355
R102 b0.n2 b0.t0 37.0514
R103 b0.n1 b0.n0 19.4405
R104 b0.n2 b0.n1 8.9555
R105 b4.n0 b4.t2 109.124
R106 b4.n1 b4.t0 49.3969
R107 b4 b4.n1 41.0855
R108 b4.n0 b4.t1 35.1074
R109 b4.n1 b4.n0 25.2455
R110 b3.n0 b3.t2 178.858
R111 b3.n1 b3.t0 44.8894
R112 b3 b3.n1 38.0705
R113 b3.n0 b3.t1 37.0593
R114 b3.n1 b3.n0 17.2355
R115 dvss dvss.n5 36.9527
R116 dvss.n2 dvss.t4 25.4907
R117 dvss.n0 dvss.t3 25.0538
R118 dvss.n1 dvss.t5 18.8163
R119 dvss.n1 dvss.n0 15.1205
R120 dvss.n5 dvss.n4 14.9766
R121 dvss.n4 dvss.t0 14.0112
R122 dvss.n0 dvss.t1 13.838
R123 dvss.n3 dvss.t6 13.7961
R124 dvss.n4 dvss.n3 10.3955
R125 dvss.n5 dvss.t2 9.2885
R126 dvss.n2 dvss.n1 4.8155
R127 dvss.n3 dvss.n2 0.9455
R128 avdd.n256 avdd.n115 56.0255
R129 avdd.n877 avdd.t310 52.1245
R130 avdd.n879 avdd.t308 52.1245
R131 avdd.n881 avdd.t306 52.1245
R132 avdd.n883 avdd.t304 52.1245
R133 avdd.n885 avdd.t302 52.1245
R134 avdd.n887 avdd.t300 52.1245
R135 avdd.n889 avdd.t298 52.1245
R136 avdd.n891 avdd.t296 52.1245
R137 avdd.n893 avdd.t294 52.1245
R138 avdd.n895 avdd.t292 52.1245
R139 avdd.n897 avdd.t290 52.1245
R140 avdd.n899 avdd.t288 52.1245
R141 avdd.n901 avdd.t286 52.1245
R142 avdd.n245 avdd.t413 52.1245
R143 avdd.n202 avdd.t415 52.1245
R144 avdd.n247 avdd.t411 52.1245
R145 avdd.n242 avdd.t443 52.1245
R146 avdd.n241 avdd.t445 52.1245
R147 avdd.n240 avdd.t447 52.1245
R148 avdd.n239 avdd.t449 52.1245
R149 avdd.n238 avdd.t451 52.1245
R150 avdd.n237 avdd.t453 52.1245
R151 avdd.n236 avdd.t455 52.1245
R152 avdd.n235 avdd.t457 52.1245
R153 avdd.n234 avdd.t459 52.1245
R154 avdd.n233 avdd.t461 52.1245
R155 avdd.n232 avdd.t463 52.1245
R156 avdd.n231 avdd.t465 52.1245
R157 avdd.n250 avdd.t441 51.8176
R158 avdd.n278 avdd.n275 46.3505
R159 avdd.n279 avdd.n278 40.5005
R160 avdd.n556 avdd.n481 38.336
R161 avdd.n447 avdd.t262 34.1748
R162 avdd.n428 avdd.t283 34.1748
R163 avdd.n431 avdd.t280 34.1748
R164 avdd.n434 avdd.t277 34.1748
R165 avdd.n437 avdd.t274 34.1748
R166 avdd.n440 avdd.t271 34.1748
R167 avdd.n443 avdd.t268 34.1748
R168 avdd.n414 avdd.t265 34.1748
R169 avdd.n453 avdd.t408 34.1748
R170 avdd.n455 avdd.t405 34.1748
R171 avdd.n458 avdd.t402 34.1748
R172 avdd.n461 avdd.t399 34.1748
R173 avdd.n464 avdd.t396 34.1748
R174 avdd.n467 avdd.t393 34.1748
R175 avdd.n470 avdd.t390 34.1748
R176 avdd.n473 avdd.t387 34.1748
R177 avdd.n554 avdd.t360 34.1748
R178 avdd.n481 avdd.t363 34.1748
R179 avdd.n534 avdd.t342 34.1748
R180 avdd.n495 avdd.t345 34.1748
R181 avdd.n511 avdd.t327 34.1748
R182 avdd.n514 avdd.t324 34.1748
R183 avdd.n201 avdd.n200 34.1547
R184 avdd.n512 avdd.n511 34.0085
R185 avdd.n536 avdd.n495 33.9927
R186 avdd.n597 avdd.n594 32.9116
R187 avdd.n359 avdd.t577 30.8341
R188 avdd.n878 avdd.n876 29.1066
R189 avdd.n246 avdd.n203 27.0672
R190 avdd.n429 avdd.n426 26.7755
R191 avdd.n804 avdd.t650 25.6018
R192 avdd.n280 avdd.t641 24.0425
R193 avdd.n648 avdd.n606 23.6705
R194 avdd.n248 avdd.n246 23.3323
R195 avdd.n869 avdd.n868 22.8065
R196 avdd.n259 avdd.n258 22.5905
R197 avdd.n418 avdd.t646 22.4102
R198 avdd.n903 avdd.n902 22.2755
R199 avdd.n303 avdd.n302 22.0505
R200 avdd.n155 avdd.n138 21.986
R201 avdd.n821 avdd.t590 21.2629
R202 avdd.n358 avdd.t574 21.2414
R203 avdd.n861 avdd.t579 21.2292
R204 avdd.n812 avdd.t571 21.228
R205 avdd.n778 avdd.t603 21.2278
R206 avdd.n342 avdd.t569 21.2278
R207 avdd.n772 avdd.t616 21.2278
R208 avdd.n855 avdd.t578 21.0905
R209 avdd.n120 avdd.t494 20.7944
R210 avdd.n301 avdd.t536 20.7944
R211 avdd.n154 avdd.t506 20.7944
R212 avdd.n125 avdd.t488 20.7944
R213 avdd.n127 avdd.t485 20.7944
R214 avdd.n129 avdd.t482 20.7944
R215 avdd.n131 avdd.t479 20.7944
R216 avdd.n134 avdd.t476 20.7944
R217 avdd.n319 avdd.t473 20.7944
R218 avdd.n173 avdd.t542 20.7944
R219 avdd.n158 avdd.t560 20.7944
R220 avdd.n161 avdd.t557 20.7944
R221 avdd.n165 avdd.t554 20.7944
R222 avdd.n167 avdd.t551 20.7944
R223 avdd.n169 avdd.t548 20.7944
R224 avdd.n171 avdd.t545 20.7944
R225 avdd.n287 avdd.t539 20.7944
R226 avdd.n122 avdd.t491 20.7944
R227 avdd.n305 avdd.t533 20.674
R228 avdd.n316 avdd.t503 20.674
R229 avdd.n99 avdd.t584 20.418
R230 avdd.n769 avdd.t612 20.4178
R231 avdd.n903 avdd.t633 20.0552
R232 avdd.n243 avdd.t644 19.6327
R233 avdd.n281 avdd.t648 18.206
R234 avdd.n684 avdd.t623 18.006
R235 avdd.n280 avdd.t580 17.8718
R236 avdd.n279 avdd.t663 17.8522
R237 avdd.n281 avdd.n280 17.7305
R238 avdd.n283 avdd.n282 16.8652
R239 avdd.n681 avdd.t384 16.8102
R240 avdd.n573 avdd.t381 16.8102
R241 avdd.n677 avdd.t378 16.8102
R242 avdd.n575 avdd.t375 16.8102
R243 avdd.n577 avdd.t372 16.8102
R244 avdd.n579 avdd.t369 16.8102
R245 avdd.n671 avdd.t366 16.8102
R246 avdd.n581 avdd.t357 16.8102
R247 avdd.n584 avdd.t354 16.8102
R248 avdd.n587 avdd.t351 16.8102
R249 avdd.n667 avdd.t348 16.8102
R250 avdd.n590 avdd.t339 16.8102
R251 avdd.n593 avdd.t336 16.8102
R252 avdd.n596 avdd.t333 16.8102
R253 avdd.n663 avdd.t330 16.8102
R254 avdd.n630 avdd.t217 16.8102
R255 avdd.n628 avdd.t220 16.8102
R256 avdd.n626 avdd.t223 16.8102
R257 avdd.n624 avdd.t226 16.8102
R258 avdd.n621 avdd.t229 16.8102
R259 avdd.n618 avdd.t232 16.8102
R260 avdd.n608 avdd.t235 16.8102
R261 avdd.n636 avdd.t244 16.8102
R262 avdd.n640 avdd.t241 16.8102
R263 avdd.n643 avdd.t238 16.8102
R264 avdd.n599 avdd.t259 16.8102
R265 avdd.n602 avdd.t256 16.8102
R266 avdd.n605 avdd.t253 16.8102
R267 avdd.n646 avdd.t250 16.8102
R268 avdd.n650 avdd.t312 16.8102
R269 avdd.n659 avdd.t315 16.8102
R270 avdd.n656 avdd.t318 16.8102
R271 avdd.n653 avdd.t321 16.8102
R272 avdd.n612 avdd.t247 16.7137
R273 avdd.n818 avdd.t619 16.5942
R274 avdd.n456 avdd.n453 16.3872
R275 avdd.n709 avdd.t631 16.3364
R276 avdd.n708 avdd.t597 16.2991
R277 avdd.n710 avdd.t581 16.2991
R278 avdd.n811 avdd.t651 16.0773
R279 avdd.n859 avdd.t589 16.0429
R280 avdd.n775 avdd.t642 16.0078
R281 avdd.n284 avdd.t649 15.8521
R282 avdd.n244 avdd.n243 15.7955
R283 avdd.n252 avdd.t645 15.7386
R284 avdd.n761 avdd.t632 15.7064
R285 avdd.n426 avdd.n425 15.4347
R286 avdd.n713 avdd.n712 14.7781
R287 avdd.n715 avdd.t568 14.6341
R288 avdd.n845 avdd.t667 14.4932
R289 avdd.n657 avdd.n654 14.4782
R290 avdd.n683 avdd.t653 14.3338
R291 avdd.n421 avdd.t591 14.1251
R292 avdd.n410 avdd.t654 14.0188
R293 avdd.n804 avdd.t615 13.9392
R294 avdd.n770 avdd.t613 13.9249
R295 avdd.n702 avdd.t587 13.9249
R296 avdd.n814 avdd.t585 13.9173
R297 avdd.n760 avdd.t575 13.9141
R298 avdd.n416 avdd.t661 13.8808
R299 avdd.n914 avdd.t0 13.8677
R300 avdd.n420 avdd.t659 13.8664
R301 avdd.n638 avdd.n637 13.8155
R302 avdd.n257 avdd.t605 13.8021
R303 avdd.n252 avdd.t610 13.8021
R304 avdd.n254 avdd.t582 13.8021
R305 avdd.n911 avdd.t637 13.7777
R306 avdd.n253 avdd.t611 13.7586
R307 avdd.n905 avdd.t655 13.7532
R308 avdd.n872 avdd.t662 13.7364
R309 avdd.n869 avdd.t592 13.7094
R310 avdd.n874 avdd.t622 13.6895
R311 avdd.n870 avdd.t660 13.6877
R312 avdd.n871 avdd.t658 13.6795
R313 avdd.n913 avdd.n113 13.3205
R314 avdd.n684 avdd.n683 12.9155
R315 avdd.n416 avdd.n113 12.9155
R316 avdd.n588 avdd.n585 12.1662
R317 avdd.n246 avdd.n245 12.1643
R318 avdd.n775 avdd.n774 12.1505
R319 avdd.n703 avdd.t586 12.0928
R320 avdd.n907 avdd.n906 11.9705
R321 avdd.n860 avdd.n859 11.9705
R322 avdd.n817 avdd.n816 11.9705
R323 avdd.n820 avdd.n107 11.8145
R324 avdd.n226 avdd.n223 11.6105
R325 avdd.n660 avdd.n657 11.2925
R326 avdd.n914 avdd.n913 11.0705
R327 avdd.n205 avdd.t530 11.0479
R328 avdd.n207 avdd.t527 11.0479
R329 avdd.n210 avdd.t524 11.0479
R330 avdd.n213 avdd.t521 11.0479
R331 avdd.n216 avdd.t518 11.0479
R332 avdd.n219 avdd.t515 11.0479
R333 avdd.n222 avdd.t512 11.0479
R334 avdd.n225 avdd.t509 11.0479
R335 avdd.n200 avdd.t500 11.0479
R336 avdd.n228 avdd.t497 11.0479
R337 avdd.n177 avdd.t438 11.0479
R338 avdd.n179 avdd.t435 11.0479
R339 avdd.n182 avdd.t432 11.0479
R340 avdd.n185 avdd.t429 11.0479
R341 avdd.n188 avdd.t426 11.0479
R342 avdd.n191 avdd.t423 11.0479
R343 avdd.n194 avdd.t420 11.0479
R344 avdd.n197 avdd.t417 11.0479
R345 avdd.n175 avdd.t467 11.0479
R346 avdd.n277 avdd.t470 11.0479
R347 avdd.n282 avdd.n151 10.9655
R348 avdd.n343 avdd.n341 10.9355
R349 avdd.n780 avdd.n779 10.9355
R350 avdd.n865 avdd.n862 10.9145
R351 avdd.n832 avdd.n822 10.9033
R352 avdd.n843 avdd.n112 10.8005
R353 avdd.n678 avdd.n675 10.7105
R354 avdd.n459 avdd.n458 10.5072
R355 avdd.n468 avdd.n467 10.5072
R356 avdd.n471 avdd.n470 10.5072
R357 avdd.n474 avdd.n473 10.5072
R358 avdd.n432 avdd.n431 10.4952
R359 avdd.n435 avdd.n434 10.4952
R360 avdd.n438 avdd.n437 10.4952
R361 avdd.n441 avdd.n440 10.4952
R362 avdd.n444 avdd.n443 10.4952
R363 avdd.n585 avdd.n582 10.3222
R364 avdd.n139 avdd.t636 10.1244
R365 avdd.n146 avdd.t638 10.1244
R366 avdd.n483 avdd.t564 10.0857
R367 avdd.n496 avdd.t665 10.0857
R368 avdd.n505 avdd.t594 10.0857
R369 avdd.n773 avdd.n771 10.0805
R370 avdd.n483 avdd.t576 9.79773
R371 avdd.n484 avdd.t599 9.79773
R372 avdd.n485 avdd.t567 9.79773
R373 avdd.n486 avdd.t563 9.79773
R374 avdd.n487 avdd.t664 9.79773
R375 avdd.n496 avdd.t666 9.79773
R376 avdd.n497 avdd.t628 9.79773
R377 avdd.n498 avdd.t629 9.79773
R378 avdd.n499 avdd.t630 9.79773
R379 avdd.n500 avdd.t593 9.79773
R380 avdd.n505 avdd.t595 9.79773
R381 avdd.n506 avdd.t600 9.79773
R382 avdd.n507 avdd.t601 9.79773
R383 avdd.n508 avdd.t602 9.79773
R384 avdd.n509 avdd.t652 9.79773
R385 avdd.n139 avdd.t624 9.74635
R386 avdd.n140 avdd.t625 9.74635
R387 avdd.n141 avdd.t626 9.74635
R388 avdd.n142 avdd.t627 9.74635
R389 avdd.n143 avdd.t657 9.74635
R390 avdd.n146 avdd.t596 9.74635
R391 avdd.n147 avdd.t640 9.74635
R392 avdd.n148 avdd.t639 9.74635
R393 avdd.n149 avdd.t634 9.74635
R394 avdd.n150 avdd.t635 9.74635
R395 avdd.n257 avdd.n256 9.6755
R396 avdd.n782 avdd.t145 9.56798
R397 avdd.n335 avdd.t142 9.56798
R398 avdd.n739 avdd.t61 9.56798
R399 avdd.n353 avdd.t118 9.56798
R400 avdd.n351 avdd.t40 9.56798
R401 avdd.n345 avdd.t73 9.56798
R402 avdd.n348 avdd.t43 9.56798
R403 avdd.n749 avdd.t46 9.56798
R404 avdd.n747 avdd.t49 9.56798
R405 avdd.n745 avdd.t52 9.56798
R406 avdd.n743 avdd.t55 9.56798
R407 avdd.n741 avdd.t58 9.56798
R408 avdd.n338 avdd.t121 9.56798
R409 avdd.n340 avdd.t76 9.56798
R410 avdd.n93 avdd.t127 9.56798
R411 avdd.n798 avdd.t133 9.56798
R412 avdd.n788 avdd.t136 9.56798
R413 avdd.n785 avdd.t139 9.56798
R414 avdd.n356 avdd.t124 9.56798
R415 avdd.n89 avdd.t130 9.55923
R416 avdd.n328 avdd.t169 9.5496
R417 avdd.n834 avdd.t214 9.5496
R418 avdd.n806 avdd.t178 9.5496
R419 avdd.n809 avdd.t175 9.5496
R420 avdd.n106 avdd.t181 9.5496
R421 avdd.n332 avdd.t163 9.5496
R422 avdd.n790 avdd.t160 9.5496
R423 avdd.n792 avdd.t157 9.5496
R424 avdd.n95 avdd.t154 9.5496
R425 avdd.n98 avdd.t151 9.5496
R426 avdd.n101 avdd.t148 9.5496
R427 avdd.n103 avdd.t172 9.5496
R428 avdd.n864 avdd.t184 9.5496
R429 avdd.n831 avdd.t190 9.5496
R430 avdd.n109 avdd.t187 9.5496
R431 avdd.n824 avdd.t193 9.5496
R432 avdd.n829 avdd.t196 9.5496
R433 avdd.n826 avdd.t199 9.5496
R434 avdd.n842 avdd.t202 9.5496
R435 avdd.n840 avdd.t205 9.5496
R436 avdd.n838 avdd.t208 9.5496
R437 avdd.n836 avdd.t211 9.5496
R438 avdd.n330 avdd.t166 9.5496
R439 avdd.n855 avdd.t609 9.47292
R440 avdd.n405 avdd.t79 9.45768
R441 avdd.n403 avdd.t82 9.45768
R442 avdd.n401 avdd.t85 9.45768
R443 avdd.n399 avdd.t88 9.45768
R444 avdd.n397 avdd.t91 9.45768
R445 avdd.n395 avdd.t94 9.45768
R446 avdd.n393 avdd.t97 9.45768
R447 avdd.n391 avdd.t100 9.45768
R448 avdd.n389 avdd.t103 9.45768
R449 avdd.n387 avdd.t106 9.45768
R450 avdd.n385 avdd.t109 9.45768
R451 avdd.n364 avdd.t37 9.45768
R452 avdd.n712 avdd.t67 9.45768
R453 avdd.n757 avdd.t1 9.45768
R454 avdd.n764 avdd.t64 9.45768
R455 avdd.n361 avdd.t4 9.45768
R456 avdd.n725 avdd.t7 9.45768
R457 avdd.n723 avdd.t10 9.45768
R458 avdd.n721 avdd.t13 9.45768
R459 avdd.n719 avdd.t16 9.45768
R460 avdd.n717 avdd.t19 9.45768
R461 avdd.n374 avdd.t22 9.45768
R462 avdd.n372 avdd.t25 9.45768
R463 avdd.n370 avdd.t28 9.45768
R464 avdd.n368 avdd.t31 9.45768
R465 avdd.n366 avdd.t34 9.45768
R466 avdd.n378 avdd.t70 9.45768
R467 avdd.n381 avdd.t112 9.44903
R468 avdd.n697 avdd.t115 9.44903
R469 avdd.n844 avdd.t573 9.44874
R470 avdd.n714 avdd.t598 9.31644
R471 avdd.n907 avdd.t620 9.31374
R472 avdd.n256 avdd.t606 9.30213
R473 avdd.n821 avdd.t588 9.30055
R474 avdd.n858 avdd.t608 9.30055
R475 avdd.n358 avdd.t607 9.27907
R476 avdd.n906 avdd.t621 9.27324
R477 avdd.n861 avdd.t618 9.2668
R478 avdd.n819 avdd.t614 9.2668
R479 avdd.n255 avdd.t583 9.25863
R480 avdd.n904 avdd.t656 9.24726
R481 avdd.n778 avdd.t604 9.24493
R482 avdd.n342 avdd.t570 9.24493
R483 avdd.n772 avdd.t617 9.24493
R484 avdd.n776 avdd.t643 9.24493
R485 avdd.n812 avdd.t572 9.2373
R486 avdd.n873 avdd.t565 9.17845
R487 avdd.n243 avdd.t566 9.11234
R488 avdd.n876 avdd.n875 9.01768
R489 avdd.n285 avdd.n283 8.91078
R490 avdd.n856 avdd.n854 8.9105
R491 avdd.n208 avdd.n205 8.45972
R492 avdd.n180 avdd.n177 8.43347
R493 avdd.n449 avdd.n448 8.42728
R494 avdd.n816 avdd.n815 8.2805
R495 avdd.n701 avdd.n86 8.2805
R496 avdd.n847 avdd.n846 8.24
R497 avdd.n811 avdd.n810 8.1455
R498 avdd.n631 avdd.n630 7.5715
R499 avdd.n906 avdd.n905 7.4705
R500 avdd.n905 avdd.n904 7.3805
R501 avdd.n731 avdd.n715 7.2275
R502 avdd.n760 avdd.n759 7.1555
R503 avdd.n765 avdd.n762 7.13825
R504 avdd.n288 avdd.n285 7.06476
R505 avdd.n822 avdd.n821 7.0205
R506 avdd.n858 avdd.n857 7.0205
R507 avdd.n862 avdd.n861 7.0205
R508 avdd.n820 avdd.n819 7.0205
R509 avdd.n714 avdd.n713 7.0205
R510 avdd.n359 avdd.n358 7.0205
R511 avdd.n873 avdd.n872 6.8855
R512 avdd.n875 avdd.n874 6.8405
R513 avdd.n813 avdd.n812 6.8405
R514 avdd.n779 avdd.n778 6.8405
R515 avdd.n777 avdd.n776 6.8405
R516 avdd.n343 avdd.n342 6.8405
R517 avdd.n773 avdd.n772 6.8405
R518 avdd.n856 avdd.n855 6.7955
R519 avdd.n255 avdd.n254 6.7505
R520 avdd.n283 avdd.t647 6.74714
R521 avdd.n815 avdd.n814 6.6605
R522 avdd.n771 avdd.n770 6.6605
R523 avdd.n702 avdd.n701 6.6605
R524 avdd.n845 avdd.n844 6.6155
R525 avdd.n844 avdd.n843 6.6155
R526 avdd.n417 avdd.n416 6.5705
R527 avdd.n715 avdd.n714 6.5705
R528 avdd.n878 avdd.n877 6.08935
R529 avdd.n880 avdd.n879 6.08935
R530 avdd.n882 avdd.n881 6.08935
R531 avdd.n884 avdd.n883 6.08935
R532 avdd.n886 avdd.n885 6.08935
R533 avdd.n888 avdd.n887 6.08935
R534 avdd.n890 avdd.n889 6.08935
R535 avdd.n892 avdd.n891 6.08935
R536 avdd.n894 avdd.n893 6.08935
R537 avdd.n896 avdd.n895 6.08935
R538 avdd.n898 avdd.n897 6.08935
R539 avdd.n900 avdd.n899 6.08935
R540 avdd.n902 avdd.n901 6.08935
R541 avdd.n203 avdd.n202 6.08935
R542 avdd.n248 avdd.n247 6.08935
R543 avdd.n260 avdd.n242 6.08935
R544 avdd.n261 avdd.n241 6.08935
R545 avdd.n262 avdd.n240 6.08935
R546 avdd.n263 avdd.n239 6.08935
R547 avdd.n264 avdd.n238 6.08935
R548 avdd.n265 avdd.n237 6.08935
R549 avdd.n266 avdd.n236 6.08935
R550 avdd.n267 avdd.n235 6.08935
R551 avdd.n268 avdd.n234 6.08935
R552 avdd.n269 avdd.n233 6.08935
R553 avdd.n270 avdd.n232 6.08935
R554 avdd.n271 avdd.n231 6.08935
R555 avdd.n258 avdd.n255 6.0305
R556 avdd.n462 avdd.n461 6.00121
R557 avdd.n448 avdd.n447 5.99522
R558 avdd.n429 avdd.n428 5.99522
R559 avdd.n445 avdd.n414 5.99522
R560 avdd.n456 avdd.n455 5.99372
R561 avdd.n465 avdd.n464 5.99372
R562 avdd.n555 avdd.n554 5.98097
R563 avdd.n535 avdd.n534 5.97872
R564 avdd.n515 avdd.n514 5.97872
R565 avdd.n445 avdd.n444 5.9405
R566 avdd.n432 avdd.n429 5.9405
R567 avdd.n468 avdd.n465 5.9405
R568 avdd.n459 avdd.n456 5.9405
R569 avdd.n644 avdd.n643 5.905
R570 avdd.n26 avdd.n120 6.62567
R571 avdd.n302 avdd.n301 5.90495
R572 avdd.n155 avdd.n154 5.90495
R573 avdd.n325 avdd.n125 5.90495
R574 avdd.n324 avdd.n127 5.90495
R575 avdd.n323 avdd.n129 5.90495
R576 avdd.n132 avdd.n131 5.90495
R577 avdd.n321 avdd.n134 5.90495
R578 avdd.n320 avdd.n319 5.90495
R579 avdd.n290 avdd.n173 5.90495
R580 avdd.n159 avdd.n158 5.90495
R581 avdd.n162 avdd.n161 5.90495
R582 avdd.n295 avdd.n165 5.90495
R583 avdd.n294 avdd.n167 5.90495
R584 avdd.n293 avdd.n169 5.90495
R585 avdd.n291 avdd.n171 5.90495
R586 avdd.n288 avdd.n287 5.90495
R587 avdd.n123 avdd.n122 5.90495
R588 avdd.n37 avdd.n681 5.881
R589 avdd.n679 avdd.n573 5.881
R590 avdd.n678 avdd.n677 5.881
R591 avdd.n675 avdd.n575 5.881
R592 avdd.n674 avdd.n577 5.881
R593 avdd.n673 avdd.n579 5.881
R594 avdd.n672 avdd.n671 5.881
R595 avdd.n582 avdd.n581 5.881
R596 avdd.n585 avdd.n584 5.881
R597 avdd.n588 avdd.n587 5.881
R598 avdd.n668 avdd.n667 5.881
R599 avdd.n591 avdd.n590 5.881
R600 avdd.n594 avdd.n593 5.881
R601 avdd.n597 avdd.n596 5.881
R602 avdd.n664 avdd.n663 5.881
R603 avdd.n631 avdd.n628 5.881
R604 avdd.n632 avdd.n626 5.881
R605 avdd.n633 avdd.n624 5.881
R606 avdd.n622 avdd.n621 5.881
R607 avdd.n619 avdd.n618 5.881
R608 avdd.n609 avdd.n608 5.881
R609 avdd.n637 avdd.n636 5.881
R610 avdd.n641 avdd.n640 5.881
R611 avdd.n600 avdd.n599 5.881
R612 avdd.n603 avdd.n602 5.881
R613 avdd.n606 avdd.n605 5.881
R614 avdd.n647 avdd.n646 5.881
R615 avdd.n651 avdd.n650 5.881
R616 avdd.n660 avdd.n659 5.881
R617 avdd.n657 avdd.n656 5.881
R618 avdd.n654 avdd.n653 5.881
R619 avdd.n198 avdd.n197 5.86847
R620 avdd.n208 avdd.n207 5.84972
R621 avdd.n211 avdd.n210 5.84972
R622 avdd.n214 avdd.n213 5.84972
R623 avdd.n217 avdd.n216 5.84972
R624 avdd.n220 avdd.n219 5.84972
R625 avdd.n223 avdd.n222 5.84972
R626 avdd.n226 avdd.n225 5.84972
R627 avdd.n229 avdd.n228 5.84972
R628 avdd.n180 avdd.n179 5.84972
R629 avdd.n183 avdd.n182 5.84972
R630 avdd.n186 avdd.n185 5.84972
R631 avdd.n189 avdd.n188 5.84972
R632 avdd.n192 avdd.n191 5.84972
R633 avdd.n195 avdd.n194 5.84972
R634 avdd.n275 avdd.n175 5.84972
R635 avdd.n278 avdd.n277 5.84972
R636 avdd.n783 avdd.n782 5.84099
R637 avdd.n336 avdd.n335 5.84099
R638 avdd.n755 avdd.n739 5.84099
R639 avdd.n354 avdd.n353 5.84099
R640 avdd.n767 avdd.n351 5.84099
R641 avdd.n346 avdd.n345 5.84099
R642 avdd.n349 avdd.n348 5.84099
R643 avdd.n750 avdd.n749 5.84099
R644 avdd.n751 avdd.n747 5.84099
R645 avdd.n752 avdd.n745 5.84099
R646 avdd.n753 avdd.n743 5.84099
R647 avdd.n754 avdd.n741 5.84099
R648 avdd.n780 avdd.n338 5.84099
R649 avdd.n341 avdd.n340 5.84099
R650 avdd.n921 avdd.n93 5.84099
R651 avdd.n799 avdd.n798 5.84099
R652 avdd.n796 avdd.n788 5.84099
R653 avdd.n786 avdd.n785 5.84099
R654 avdd.n357 avdd.n356 5.84099
R655 avdd.n802 avdd.n328 5.84088
R656 avdd.n15 avdd.n834 6.85311
R657 avdd.n807 avdd.n806 5.84088
R658 avdd.n810 avdd.n809 5.84088
R659 avdd.n107 avdd.n106 5.84088
R660 avdd.n333 avdd.n332 5.84088
R661 avdd.n794 avdd.n790 5.84088
R662 avdd.n793 avdd.n792 5.84088
R663 avdd.n96 avdd.n95 5.84088
R664 avdd.n919 avdd.n98 5.84088
R665 avdd.n36 avdd.n101 5.84088
R666 avdd.n104 avdd.n103 5.84088
R667 avdd.n865 avdd.n864 5.84088
R668 avdd.n832 avdd.n831 5.84088
R669 avdd.n110 avdd.n109 5.84088
R670 avdd.n853 avdd.n824 5.84088
R671 avdd.n852 avdd.n829 5.84088
R672 avdd.n827 avdd.n826 5.84088
R673 avdd.n848 avdd.n842 5.84088
R674 avdd.n849 avdd.n840 5.84088
R675 avdd.n850 avdd.n838 5.84088
R676 avdd.n851 avdd.n836 5.84088
R677 avdd.n801 avdd.n330 5.84088
R678 avdd.n406 avdd.n405 5.84034
R679 avdd.n407 avdd.n403 5.84034
R680 avdd.n408 avdd.n401 5.84034
R681 avdd.n409 avdd.n399 5.84034
R682 avdd.n686 avdd.n397 5.84034
R683 avdd.n687 avdd.n395 5.84034
R684 avdd.n688 avdd.n393 5.84034
R685 avdd.n689 avdd.n391 5.84034
R686 avdd.n690 avdd.n389 5.84034
R687 avdd.n691 avdd.n387 5.84034
R688 avdd.n692 avdd.n385 5.84034
R689 avdd.n737 avdd.n364 5.84034
R690 avdd.n758 avdd.n757 5.84034
R691 avdd.n765 avdd.n764 5.84034
R692 avdd.n362 avdd.n361 5.84034
R693 avdd.n726 avdd.n725 5.84034
R694 avdd.n727 avdd.n723 5.84034
R695 avdd.n728 avdd.n721 5.84034
R696 avdd.n729 avdd.n719 5.84034
R697 avdd.n730 avdd.n717 5.84034
R698 avdd.n732 avdd.n374 5.84034
R699 avdd.n733 avdd.n372 5.84034
R700 avdd.n734 avdd.n370 5.84034
R701 avdd.n735 avdd.n368 5.84034
R702 avdd.n736 avdd.n366 5.84034
R703 avdd.n379 avdd.n378 5.84034
R704 avdd.n908 avdd.n907 5.7605
R705 avdd.n425 avdd.n424 5.65557
R706 avdd.n857 avdd.n822 5.5805
R707 avdd.n813 avdd.n811 5.5805
R708 avdd.n779 avdd.n777 5.5805
R709 avdd.n282 avdd.n281 5.4905
R710 avdd.n859 avdd.n858 5.2205
R711 avdd.n814 avdd.n99 5.2205
R712 avdd.n776 avdd.n775 5.2205
R713 avdd.n770 avdd.n769 5.2205
R714 avdd.n249 avdd.n248 5.10463
R715 avdd.n320 avdd.n317 5.10463
R716 avdd.n304 avdd.n138 5.07913
R717 avdd.n51 avdd.n37 5.05955
R718 avdd.n259 avdd.n251 5.04078
R719 avdd.n5 avdd.n18 2.11747
R720 avdd.n323 avdd.n5 5.00907
R721 avdd.n420 avdd.n417 4.9955
R722 avdd.n616 avdd.n615 4.99282
R723 avdd.n298 avdd.n159 4.97047
R724 avdd.n296 avdd.n295 4.97047
R725 avdd.n26 avdd.n123 0.735379
R726 avdd.n324 avdd.n18 0.723596
R727 avdd.n294 avdd.n163 4.88523
R728 avdd.n297 avdd.n162 4.88523
R729 avdd.n37 avdd.n571 4.8302
R730 avdd.n26 avdd.n5 2.07198
R731 avdd.n302 avdd.n299 4.81386
R732 avdd.n156 avdd.n155 4.78967
R733 avdd.n610 avdd.n412 4.78705
R734 avdd.n916 avdd.n110 4.77437
R735 avdd.n917 avdd.n107 4.77293
R736 avdd.n866 avdd.n865 4.77293
R737 avdd.n766 avdd.n354 4.77206
R738 avdd.n85 avdd.n780 4.77206
R739 avdd.n807 avdd.n803 4.77148
R740 avdd.n13 avdd.n104 4.77148
R741 avdd.n341 avdd.n84 4.77023
R742 avdd.n58 avdd.n346 4.77023
R743 avdd.n8 avdd.n765 4.76473
R744 avdd.n862 avdd.n860 4.6805
R745 avdd.n774 avdd.n343 4.6805
R746 avdd.n762 avdd.n359 4.6805
R747 avdd.n307 avdd.n306 4.6686
R748 avdd.n315 avdd.n314 4.6686
R749 avdd.n819 avdd.n818 4.6355
R750 avdd.n91 avdd.n90 4.59487
R751 avdd.n383 avdd.n382 4.59381
R752 avdd.n699 avdd.n698 4.59381
R753 avdd.n694 avdd.n693 4.5455
R754 avdd.n700 avdd.n695 4.5455
R755 avdd.n614 avdd.n411 4.5455
R756 avdd.n613 avdd.n612 4.50652
R757 avdd.n250 avdd.n249 4.50652
R758 avdd.n305 avdd.n304 4.50652
R759 avdd.n317 avdd.n316 4.50652
R760 avdd.n0 avdd.n15 1.88773
R761 avdd.n21 avdd.n49 0.104423
R762 avdd.n82 avdd.n783 4.7831
R763 avdd.n96 avdd.n39 4.76289
R764 avdd.n72 avdd.n73 0.00607768
R765 avdd.n70 avdd.n407 4.77428
R766 avdd.n53 avdd.n408 4.76506
R767 avdd.n687 avdd.n75 4.77319
R768 avdd.n74 avdd.n688 4.77428
R769 avdd.n33 avdd.n11 1.87611
R770 avdd.n9 avdd.n729 4.77418
R771 avdd.n733 avdd.n47 4.77444
R772 avdd.n83 avdd.n349 4.77746
R773 avdd.n24 avdd.n31 0.0325748
R774 avdd.n14 avdd.n25 1.88762
R775 avdd.n852 avdd.n25 1.01277
R776 avdd.n848 avdd.n77 4.78666
R777 avdd.n0 avdd.n850 4.7867
R778 avdd.n16 avdd.n336 4.5005
R779 avdd.n1 avdd.n802 4.77905
R780 avdd.n288 avdd.n27 4.5005
R781 avdd.n303 avdd.n145 4.5005
R782 avdd.n313 avdd.n312 4.5005
R783 avdd.n137 avdd.n136 4.5005
R784 avdd.n314 avdd.n313 4.5005
R785 avdd.n309 avdd.n308 4.5005
R786 avdd.n307 avdd.n303 4.5005
R787 avdd.n36 avdd.n1 4.76247
R788 avdd.n43 avdd.n357 4.5005
R789 avdd.n21 avdd.n786 4.5005
R790 avdd.n796 avdd.n795 4.5005
R791 avdd.n800 avdd.n799 4.5005
R792 avdd.n34 avdd.n31 2.24726
R793 avdd.n34 avdd.n91 4.5005
R794 avdd.n24 avdd.n922 4.5005
R795 avdd.n922 avdd.n88 4.5005
R796 avdd.n67 avdd.n755 4.77737
R797 avdd.n703 avdd.n702 4.5005
R798 avdd.n379 avdd.n376 4.5005
R799 avdd.n707 avdd.n706 4.5005
R800 avdd.n66 avdd.n65 0.00684989
R801 avdd.n693 avdd.n54 4.77319
R802 avdd.n693 avdd.n383 4.5005
R803 avdd.n700 avdd.n699 4.5005
R804 avdd.n686 avdd.n685 4.5005
R805 avdd.n512 avdd.n504 4.5005
R806 avdd.n537 avdd.n536 4.5005
R807 avdd.n556 avdd.n555 4.5005
R808 avdd.n615 avdd.n614 4.5005
R809 avdd.n11 avdd.n8 0.073463
R810 avdd.n736 avdd.n76 4.77418
R811 avdd.n921 avdd.n920 4.5005
R812 avdd.n0 avdd.n832 4.78182
R813 avdd.n638 avdd.n634 4.487
R814 avdd.n705 avdd.n704 4.2755
R815 avdd.n462 avdd.n459 3.72782
R816 avdd.n708 avdd.n707 3.6005
R817 avdd.n606 avdd.n603 3.58817
R818 avdd.n644 avdd.n641 3.54317
R819 avdd.n271 avdd.n230 3.2255
R820 avdd.n769 avdd.n768 3.14825
R821 avdd.n918 avdd.n99 3.11
R822 avdd.n20 avdd.n3 0.780168
R823 avdd.n857 avdd.n856 2.8805
R824 avdd.n713 avdd.n710 2.8805
R825 avdd.n709 avdd.n708 2.8805
R826 avdd.n273 avdd.n272 2.8505
R827 avdd.n913 avdd.n912 2.8355
R828 avdd.n710 avdd.n709 2.7005
R829 avdd.n802 avdd.n801 2.6105
R830 avdd.n223 avdd.n220 2.6105
R831 avdd.n220 avdd.n217 2.6105
R832 avdd.n217 avdd.n214 2.6105
R833 avdd.n214 avdd.n211 2.6105
R834 avdd.n211 avdd.n208 2.6105
R835 avdd.n851 avdd.n850 2.6105
R836 avdd.n850 avdd.n849 2.6105
R837 avdd.n849 avdd.n848 2.6105
R838 avdd.n852 avdd.n827 2.6105
R839 avdd.n810 avdd.n807 2.6105
R840 avdd.n919 avdd.n96 2.6105
R841 avdd.n793 avdd.n96 2.6105
R842 avdd.n12 avdd.n793 1.02526
R843 avdd.n794 avdd.n333 2.6105
R844 avdd.n17 avdd.n333 1.02532
R845 avdd.n786 avdd.n336 2.6105
R846 avdd.n796 avdd.n786 2.6105
R847 avdd.n799 avdd.n796 2.6105
R848 avdd.n755 avdd.n754 2.6105
R849 avdd.n754 avdd.n7 1.02606
R850 avdd.n753 avdd.n752 2.6105
R851 avdd.n32 avdd.n751 1.02602
R852 avdd.n751 avdd.n750 2.6105
R853 avdd.n750 avdd.n349 2.6105
R854 avdd.n693 avdd.n692 2.6105
R855 avdd.n692 avdd.n57 1.0258
R856 avdd.n691 avdd.n690 2.6105
R857 avdd.n690 avdd.n689 2.6105
R858 avdd.n689 avdd.n688 2.6105
R859 avdd.n688 avdd.n687 2.6105
R860 avdd.n687 avdd.n686 2.6105
R861 avdd.n686 avdd.n409 2.6105
R862 avdd.n409 avdd.n408 2.6105
R863 avdd.n408 avdd.n407 2.6105
R864 avdd.n407 avdd.n406 2.6105
R865 avdd.n736 avdd.n735 2.6105
R866 avdd.n735 avdd.n734 2.6105
R867 avdd.n734 avdd.n733 2.6105
R868 avdd.n733 avdd.n732 2.6105
R869 avdd.n730 avdd.n729 2.6105
R870 avdd.n729 avdd.n728 2.6105
R871 avdd.n728 avdd.n727 2.6105
R872 avdd.n727 avdd.n726 2.6105
R873 avdd.n33 avdd.n362 1.02577
R874 avdd.n762 avdd.n761 2.6105
R875 avdd.n34 avdd.n921 2.6105
R876 avdd.n195 avdd.n192 2.6105
R877 avdd.n192 avdd.n189 2.6105
R878 avdd.n189 avdd.n186 2.6105
R879 avdd.n186 avdd.n183 2.6105
R880 avdd.n183 avdd.n180 2.6105
R881 avdd.n848 avdd.n847 2.5955
R882 avdd.n799 avdd.n34 2.5955
R883 avdd.n731 avdd.n730 2.5955
R884 avdd.n768 avdd.n767 2.5955
R885 avdd.n737 avdd.n736 2.5895
R886 avdd.n918 avdd.n36 2.588
R887 avdd.n783 avdd.n336 2.582
R888 avdd.n853 avdd.n25 1.01301
R889 avdd.n921 avdd.n35 2.5655
R890 avdd.n198 avdd.n195 2.5655
R891 avdd.n872 avdd.n871 2.5205
R892 avdd.n871 avdd.n870 2.5205
R893 avdd.n870 avdd.n869 2.5205
R894 avdd.n695 avdd.n694 2.5205
R895 avdd.n521 avdd.n450 2.30653
R896 avdd.n491 avdd.n50 2.30578
R897 avdd.n478 avdd.n451 2.30503
R898 avdd.n306 avdd.n152 2.27975
R899 avdd.n315 avdd.n135 2.27975
R900 avdd.n582 avdd.n451 2.2577
R901 avdd.n591 avdd.n50 2.25733
R902 avdd.n654 avdd.n450 2.25696
R903 avdd.n600 avdd.n449 2.25658
R904 avdd.n253 avdd.n252 2.1605
R905 avdd.n5 avdd.n322 2.14315
R906 avdd.n292 avdd.n163 2.12658
R907 avdd.n411 avdd.n410 2.0705
R908 avdd.n818 avdd.n817 1.9805
R909 avdd.n254 avdd.n253 1.9805
R910 avdd.n641 avdd.n638 1.9355
R911 avdd.n843 avdd.n117 1.87488
R912 avdd.n816 avdd.n813 1.8005
R913 avdd.n777 avdd.n86 1.8005
R914 avdd.n381 avdd.n380 1.77212
R915 avdd.n697 avdd.n696 1.77212
R916 avdd.n815 avdd.n104 1.7555
R917 avdd.n771 avdd.n346 1.7555
R918 avdd.n701 avdd.n354 1.7555
R919 avdd.n759 avdd.n758 1.7345
R920 avdd.n271 avdd.n270 1.7105
R921 avdd.n270 avdd.n269 1.7105
R922 avdd.n269 avdd.n268 1.7105
R923 avdd.n268 avdd.n267 1.7105
R924 avdd.n267 avdd.n266 1.7105
R925 avdd.n266 avdd.n265 1.7105
R926 avdd.n265 avdd.n264 1.7105
R927 avdd.n264 avdd.n263 1.7105
R928 avdd.n263 avdd.n262 1.7105
R929 avdd.n262 avdd.n261 1.7105
R930 avdd.n261 avdd.n260 1.7105
R931 avdd.n260 avdd.n259 1.7105
R932 avdd.n900 avdd.n898 1.7105
R933 avdd.n898 avdd.n896 1.7105
R934 avdd.n896 avdd.n894 1.7105
R935 avdd.n894 avdd.n892 1.7105
R936 avdd.n892 avdd.n890 1.7105
R937 avdd.n890 avdd.n888 1.7105
R938 avdd.n888 avdd.n886 1.7105
R939 avdd.n886 avdd.n884 1.7105
R940 avdd.n884 avdd.n882 1.7105
R941 avdd.n882 avdd.n880 1.7105
R942 avdd.n880 avdd.n878 1.7105
R943 avdd.n674 avdd.n673 1.7105
R944 avdd.n675 avdd.n674 1.7105
R945 avdd.n679 avdd.n678 1.7105
R946 avdd.n594 avdd.n591 1.7105
R947 avdd.n622 avdd.n619 1.7105
R948 avdd.n633 avdd.n632 1.7105
R949 avdd.n632 avdd.n631 1.7105
R950 avdd.n603 avdd.n600 1.7105
R951 avdd.n323 avdd.n132 1.7105
R952 avdd.n324 avdd.n323 1.7105
R953 avdd.n325 avdd.n18 0.737092
R954 avdd.n325 avdd.n123 1.7105
R955 avdd.n294 avdd.n293 1.7105
R956 avdd.n295 avdd.n294 1.7105
R957 avdd.n295 avdd.n162 1.7105
R958 avdd.n162 avdd.n159 1.7105
R959 avdd.n634 avdd.n622 1.6955
R960 avdd.n291 avdd.n290 1.6955
R961 avdd.n637 avdd.n412 1.6895
R962 avdd.n673 avdd.n672 1.682
R963 avdd.n902 avdd.n900 1.6805
R964 avdd.n321 avdd.n320 1.673
R965 avdd.n661 avdd.n660 1.6655
R966 avdd.n669 avdd.n588 1.6655
R967 avdd.n665 avdd.n597 1.6655
R968 avdd.n619 avdd.n616 1.6655
R969 avdd.n280 avdd.n279 1.6205
R970 avdd.n89 avdd.n88 1.57786
R971 avdd.n425 avdd.n417 1.5755
R972 avdd.n290 avdd.n289 1.53275
R973 avdd.n115 avdd.n114 1.4855
R974 avdd.n846 avdd.n14 1.4779
R975 avdd.n444 avdd.n441 1.4405
R976 avdd.n441 avdd.n438 1.4405
R977 avdd.n438 avdd.n435 1.4405
R978 avdd.n435 avdd.n432 1.4405
R979 avdd.n471 avdd.n468 1.4405
R980 avdd.n611 avdd.n610 1.43481
R981 avdd.n251 avdd.t442 1.38724
R982 avdd.n312 avdd.n144 1.3415
R983 avdd.n272 avdd.n271 1.34105
R984 avdd.n422 avdd.n420 1.3055
R985 avdd.n517 avdd.n516 1.26769
R986 avdd.n426 avdd.n415 1.2655
R987 avdd.n910 avdd.n115 1.2495
R988 avdd.n465 avdd.n462 1.22379
R989 avdd.n911 avdd.n910 1.2215
R990 avdd.n672 avdd.n669 1.22082
R991 avdd.n668 avdd.n665 1.21932
R992 avdd.n664 avdd.n661 1.21782
R993 avdd.n651 avdd.n648 1.21632
R994 avdd.n904 avdd.n903 1.2155
R995 avdd.n474 avdd.n471 1.2155
R996 avdd.n647 avdd.n644 1.21482
R997 avdd.n448 avdd.n445 1.1705
R998 avdd.n421 avdd.n415 1.1575
R999 avdd.n30 avdd.n28 0.352506
R1000 avdd.n78 avdd.n925 0.562391
R1001 avdd.n78 avdd.n79 0.275792
R1002 avdd.n78 avdd.n22 0.0928722
R1003 avdd.n923 avdd.n23 0.557407
R1004 avdd.n23 avdd.n24 0.0131871
R1005 avdd.n78 avdd.n80 0.00641158
R1006 avdd.n80 avdd.n31 0.560794
R1007 avdd.n42 avdd.n923 0.017059
R1008 avdd.n311 avdd.n310 1.1255
R1009 avdd.n909 avdd.n908 1.1255
R1010 avdd.n874 avdd.n118 1.1255
R1011 avdd.n116 avdd.n112 1.1255
R1012 avdd.n915 avdd.n914 1.1255
R1013 avdd.n916 avdd.n14 0.0526204
R1014 avdd.n59 avdd.n60 0.00388536
R1015 avdd.n56 avdd.n55 0.0200107
R1016 avdd.n75 avdd.n74 0.0336916
R1017 avdd.n52 avdd.n75 0.0338463
R1018 avdd.n4 avdd.n3 0.0724996
R1019 avdd.n19 avdd.n3 0.101254
R1020 avdd.n3 avdd.n684 1.1255
R1021 avdd.n570 avdd.n569 1.1255
R1022 avdd.n568 avdd.n475 1.1255
R1023 avdd.n567 avdd.n566 1.1255
R1024 avdd.n565 avdd.n476 1.1255
R1025 avdd.n564 avdd.n563 1.1255
R1026 avdd.n562 avdd.n477 1.1255
R1027 avdd.n561 avdd.n560 1.1255
R1028 avdd.n559 avdd.n558 1.1255
R1029 avdd.n557 avdd.n479 1.1255
R1030 avdd.n547 avdd.n482 1.1255
R1031 avdd.n548 avdd.n489 1.1255
R1032 avdd.n550 avdd.n549 1.1255
R1033 avdd.n546 avdd.n488 1.1255
R1034 avdd.n545 avdd.n544 1.1255
R1035 avdd.n543 avdd.n490 1.1255
R1036 avdd.n542 avdd.n541 1.1255
R1037 avdd.n540 avdd.n539 1.1255
R1038 avdd.n538 avdd.n492 1.1255
R1039 avdd.n527 avdd.n493 1.1255
R1040 avdd.n528 avdd.n526 1.1255
R1041 avdd.n530 avdd.n529 1.1255
R1042 avdd.n525 avdd.n62 1.1255
R1043 avdd.n61 avdd.n501 1.1255
R1044 avdd.n524 avdd.n523 1.1255
R1045 avdd.n522 avdd.n502 1.1255
R1046 avdd.n518 avdd.n503 1.1255
R1047 avdd.n520 avdd.n519 1.1255
R1048 avdd.n532 avdd.n531 1.1255
R1049 avdd.n552 avdd.n551 1.1255
R1050 avdd.n423 avdd.n422 1.1255
R1051 avdd.n419 avdd.n418 1.1255
R1052 avdd.n9 avdd.n71 0.0325257
R1053 avdd.n68 avdd.n71 0.0294607
R1054 avdd.n68 avdd.n47 0.0371646
R1055 avdd.n854 avdd.n853 1.06944
R1056 avdd.n912 avdd.n114 1.0355
R1057 avdd.n230 avdd.n229 1.01368
R1058 avdd.n273 avdd.n201 1.00092
R1059 avdd.n868 avdd.n326 0.99554
R1060 avdd.n274 avdd.n198 0.994925
R1061 avdd.n913 avdd.n112 0.9905
R1062 avdd.n704 avdd.n703 0.9455
R1063 avdd.n30 avdd.n29 0.917973
R1064 avdd.n860 avdd.n820 0.9005
R1065 avdd.n817 avdd.n804 0.9005
R1066 avdd.n774 avdd.n773 0.9005
R1067 avdd.n761 avdd.n760 0.9005
R1068 avdd.n925 avdd.n86 0.889362
R1069 avdd.n759 avdd.n362 0.8555
R1070 avdd.n683 avdd.n20 0.995702
R1071 avdd.n614 avdd.n412 0.802625
R1072 avdd.n322 avdd.n321 0.738833
R1073 avdd.n293 avdd.n292 0.734588
R1074 avdd.n272 avdd.n203 0.725787
R1075 avdd.n292 avdd.n291 0.725009
R1076 avdd.n322 avdd.n132 0.722303
R1077 avdd.n685 avdd.n4 1.86703
R1078 avdd.n284 avdd.n30 0.709529
R1079 avdd.n27 avdd.n145 0.658245
R1080 avdd.n571 avdd.n570 0.57112
R1081 avdd.n73 avdd.n44 0.0873526
R1082 avdd.n46 avdd.n45 0.0220617
R1083 avdd.n924 avdd.n923 0.55683
R1084 avdd.n923 avdd.n87 0.55683
R1085 avdd.n22 avdd.n23 0.0286412
R1086 avdd.n40 avdd.n42 0.0252896
R1087 avdd.n49 avdd.n41 0.0306574
R1088 avdd.n85 avdd.n82 0.0536693
R1089 avdd.n17 avdd.n801 1.02523
R1090 avdd.n1 avdd.n12 1.86935
R1091 avdd.n795 avdd.n1 0.16889
R1092 avdd.n866 avdd.n0 0.099872
R1093 avdd.n48 avdd.n77 0.0374752
R1094 avdd.n83 avdd.n60 0.0366384
R1095 avdd.n84 avdd.n67 0.0757364
R1096 avdd.n52 avdd.n53 0.0210344
R1097 avdd.n64 avdd.n47 0.0283618
R1098 avdd.n251 avdd.n244 0.551312
R1099 avdd.n422 avdd.n421 0.5405
R1100 avdd.n867 avdd.n0 0.5061
R1101 avdd.n613 avdd.n610 0.501038
R1102 avdd.n258 avdd.n257 0.4955
R1103 avdd.n876 avdd.n118 0.489009
R1104 avdd.n868 avdd.n867 0.4805
R1105 avdd.n705 avdd.n700 0.464188
R1106 avdd.n706 avdd.n705 0.461
R1107 avdd.n908 avdd.n114 0.4505
R1108 avdd.n312 avdd.n311 0.442245
R1109 avdd.n424 avdd.n419 0.426447
R1110 avdd.n535 avdd.n532 0.413375
R1111 avdd.n555 avdd.n552 0.411125
R1112 avdd.n249 avdd.n244 0.409662
R1113 avdd.t442 avdd.n250 0.404702
R1114 avdd.n14 avdd.n915 0.4025
R1115 avdd.n143 avdd.n142 0.3785
R1116 avdd.n142 avdd.n141 0.3785
R1117 avdd.n141 avdd.n140 0.3785
R1118 avdd.n140 avdd.n139 0.3785
R1119 avdd.n150 avdd.n149 0.3785
R1120 avdd.n149 avdd.n148 0.3785
R1121 avdd.n148 avdd.n147 0.3785
R1122 avdd.n147 avdd.n146 0.3785
R1123 avdd.n314 avdd.n136 0.368921
R1124 avdd.n516 avdd.n515 0.368375
R1125 avdd.n419 avdd.n111 0.3645
R1126 avdd.n2 avdd.n449 0.346811
R1127 avdd.n682 avdd.n450 0.346271
R1128 avdd.n51 avdd.n451 0.345188
R1129 avdd.n91 avdd.n88 0.326525
R1130 avdd.n304 avdd.n152 0.325737
R1131 avdd.n317 avdd.n135 0.325737
R1132 avdd.n487 avdd.n486 0.2885
R1133 avdd.n486 avdd.n485 0.2885
R1134 avdd.n485 avdd.n484 0.2885
R1135 avdd.n484 avdd.n483 0.2885
R1136 avdd.n500 avdd.n499 0.2885
R1137 avdd.n499 avdd.n498 0.2885
R1138 avdd.n498 avdd.n497 0.2885
R1139 avdd.n497 avdd.n496 0.2885
R1140 avdd.n509 avdd.n508 0.2885
R1141 avdd.n508 avdd.n507 0.2885
R1142 avdd.n507 avdd.n506 0.2885
R1143 avdd.n506 avdd.n505 0.2885
R1144 avdd.n19 avdd.n411 0.431756
R1145 avdd.n308 avdd.n152 0.2768
R1146 avdd.n418 avdd.n113 0.2705
R1147 avdd.n376 avdd.n375 0.264726
R1148 avdd.n518 avdd.n517 0.263428
R1149 avdd.n680 avdd.t385 0.259912
R1150 avdd.n680 avdd.t386 0.259912
R1151 avdd.n572 avdd.t382 0.259912
R1152 avdd.n572 avdd.t383 0.259912
R1153 avdd.n676 avdd.t379 0.259912
R1154 avdd.n676 avdd.t380 0.259912
R1155 avdd.n574 avdd.t376 0.259912
R1156 avdd.n574 avdd.t377 0.259912
R1157 avdd.n576 avdd.t373 0.259912
R1158 avdd.n576 avdd.t374 0.259912
R1159 avdd.n578 avdd.t370 0.259912
R1160 avdd.n578 avdd.t371 0.259912
R1161 avdd.n670 avdd.t367 0.259912
R1162 avdd.n670 avdd.t368 0.259912
R1163 avdd.n580 avdd.t358 0.259912
R1164 avdd.n580 avdd.t359 0.259912
R1165 avdd.n583 avdd.t355 0.259912
R1166 avdd.n583 avdd.t356 0.259912
R1167 avdd.n586 avdd.t352 0.259912
R1168 avdd.n586 avdd.t353 0.259912
R1169 avdd.n666 avdd.t349 0.259912
R1170 avdd.n666 avdd.t350 0.259912
R1171 avdd.n589 avdd.t340 0.259912
R1172 avdd.n589 avdd.t341 0.259912
R1173 avdd.n592 avdd.t337 0.259912
R1174 avdd.n592 avdd.t338 0.259912
R1175 avdd.n595 avdd.t334 0.259912
R1176 avdd.n595 avdd.t335 0.259912
R1177 avdd.n662 avdd.t331 0.259912
R1178 avdd.n662 avdd.t332 0.259912
R1179 avdd.n611 avdd.t248 0.259912
R1180 avdd.n611 avdd.t249 0.259912
R1181 avdd.n629 avdd.t218 0.259912
R1182 avdd.n629 avdd.t219 0.259912
R1183 avdd.n627 avdd.t221 0.259912
R1184 avdd.n627 avdd.t222 0.259912
R1185 avdd.n625 avdd.t224 0.259912
R1186 avdd.n625 avdd.t225 0.259912
R1187 avdd.n623 avdd.t227 0.259912
R1188 avdd.n623 avdd.t228 0.259912
R1189 avdd.n620 avdd.t230 0.259912
R1190 avdd.n620 avdd.t231 0.259912
R1191 avdd.n617 avdd.t233 0.259912
R1192 avdd.n617 avdd.t234 0.259912
R1193 avdd.n607 avdd.t236 0.259912
R1194 avdd.n607 avdd.t237 0.259912
R1195 avdd.n635 avdd.t245 0.259912
R1196 avdd.n635 avdd.t246 0.259912
R1197 avdd.n639 avdd.t242 0.259912
R1198 avdd.n639 avdd.t243 0.259912
R1199 avdd.n642 avdd.t239 0.259912
R1200 avdd.n642 avdd.t240 0.259912
R1201 avdd.n598 avdd.t260 0.259912
R1202 avdd.n598 avdd.t261 0.259912
R1203 avdd.n601 avdd.t257 0.259912
R1204 avdd.n601 avdd.t258 0.259912
R1205 avdd.n604 avdd.t254 0.259912
R1206 avdd.n604 avdd.t255 0.259912
R1207 avdd.n645 avdd.t251 0.259912
R1208 avdd.n645 avdd.t252 0.259912
R1209 avdd.n649 avdd.t313 0.259912
R1210 avdd.n649 avdd.t314 0.259912
R1211 avdd.n658 avdd.t316 0.259912
R1212 avdd.n658 avdd.t317 0.259912
R1213 avdd.n655 avdd.t319 0.259912
R1214 avdd.n655 avdd.t320 0.259912
R1215 avdd.n652 avdd.t322 0.259912
R1216 avdd.n652 avdd.t323 0.259912
R1217 avdd.n446 avdd.t263 0.257728
R1218 avdd.n446 avdd.t264 0.257728
R1219 avdd.n427 avdd.t284 0.257728
R1220 avdd.n427 avdd.t285 0.257728
R1221 avdd.n430 avdd.t281 0.257728
R1222 avdd.n430 avdd.t282 0.257728
R1223 avdd.n433 avdd.t278 0.257728
R1224 avdd.n433 avdd.t279 0.257728
R1225 avdd.n436 avdd.t275 0.257728
R1226 avdd.n436 avdd.t276 0.257728
R1227 avdd.n439 avdd.t272 0.257728
R1228 avdd.n439 avdd.t273 0.257728
R1229 avdd.n442 avdd.t269 0.257728
R1230 avdd.n442 avdd.t270 0.257728
R1231 avdd.n413 avdd.t266 0.257728
R1232 avdd.n413 avdd.t267 0.257728
R1233 avdd.n452 avdd.t409 0.257728
R1234 avdd.n452 avdd.t410 0.257728
R1235 avdd.n454 avdd.t406 0.257728
R1236 avdd.n454 avdd.t407 0.257728
R1237 avdd.n457 avdd.t403 0.257728
R1238 avdd.n457 avdd.t404 0.257728
R1239 avdd.n460 avdd.t400 0.257728
R1240 avdd.n460 avdd.t401 0.257728
R1241 avdd.n463 avdd.t397 0.257728
R1242 avdd.n463 avdd.t398 0.257728
R1243 avdd.n466 avdd.t394 0.257728
R1244 avdd.n466 avdd.t395 0.257728
R1245 avdd.n469 avdd.t391 0.257728
R1246 avdd.n469 avdd.t392 0.257728
R1247 avdd.n472 avdd.t388 0.257728
R1248 avdd.n472 avdd.t389 0.257728
R1249 avdd.n553 avdd.t361 0.257728
R1250 avdd.n553 avdd.t362 0.257728
R1251 avdd.n480 avdd.t364 0.257728
R1252 avdd.n480 avdd.t365 0.257728
R1253 avdd.n533 avdd.t343 0.257728
R1254 avdd.n533 avdd.t344 0.257728
R1255 avdd.n494 avdd.t346 0.257728
R1256 avdd.n494 avdd.t347 0.257728
R1257 avdd.n510 avdd.t328 0.257728
R1258 avdd.n510 avdd.t329 0.257728
R1259 avdd.n513 avdd.t325 0.257728
R1260 avdd.n513 avdd.t326 0.257728
R1261 avdd.n704 avdd.n354 0.234387
R1262 avdd.n136 avdd.n135 0.2327
R1263 avdd.n424 avdd.n423 0.23072
R1264 avdd.n326 avdd.n29 0.2289
R1265 avdd.n382 avdd.t113 0.227567
R1266 avdd.n382 avdd.t114 0.227567
R1267 avdd.n698 avdd.t116 0.227567
R1268 avdd.n698 avdd.t117 0.227567
R1269 avdd.n404 avdd.t80 0.227567
R1270 avdd.n404 avdd.t81 0.227567
R1271 avdd.n402 avdd.t83 0.227567
R1272 avdd.n402 avdd.t84 0.227567
R1273 avdd.n400 avdd.t86 0.227567
R1274 avdd.n400 avdd.t87 0.227567
R1275 avdd.n398 avdd.t89 0.227567
R1276 avdd.n398 avdd.t90 0.227567
R1277 avdd.n396 avdd.t92 0.227567
R1278 avdd.n396 avdd.t93 0.227567
R1279 avdd.n394 avdd.t95 0.227567
R1280 avdd.n394 avdd.t96 0.227567
R1281 avdd.n392 avdd.t98 0.227567
R1282 avdd.n392 avdd.t99 0.227567
R1283 avdd.n390 avdd.t101 0.227567
R1284 avdd.n390 avdd.t102 0.227567
R1285 avdd.n388 avdd.t104 0.227567
R1286 avdd.n388 avdd.t105 0.227567
R1287 avdd.n386 avdd.t107 0.227567
R1288 avdd.n386 avdd.t108 0.227567
R1289 avdd.n384 avdd.t110 0.227567
R1290 avdd.n384 avdd.t111 0.227567
R1291 avdd.n363 avdd.t38 0.227567
R1292 avdd.n363 avdd.t39 0.227567
R1293 avdd.n711 avdd.t68 0.227567
R1294 avdd.n711 avdd.t69 0.227567
R1295 avdd.n756 avdd.t2 0.227567
R1296 avdd.n756 avdd.t3 0.227567
R1297 avdd.n763 avdd.t65 0.227567
R1298 avdd.n763 avdd.t66 0.227567
R1299 avdd.n360 avdd.t5 0.227567
R1300 avdd.n360 avdd.t6 0.227567
R1301 avdd.n724 avdd.t8 0.227567
R1302 avdd.n724 avdd.t9 0.227567
R1303 avdd.n722 avdd.t11 0.227567
R1304 avdd.n722 avdd.t12 0.227567
R1305 avdd.n720 avdd.t14 0.227567
R1306 avdd.n720 avdd.t15 0.227567
R1307 avdd.n718 avdd.t17 0.227567
R1308 avdd.n718 avdd.t18 0.227567
R1309 avdd.n716 avdd.t20 0.227567
R1310 avdd.n716 avdd.t21 0.227567
R1311 avdd.n373 avdd.t23 0.227567
R1312 avdd.n373 avdd.t24 0.227567
R1313 avdd.n371 avdd.t26 0.227567
R1314 avdd.n371 avdd.t27 0.227567
R1315 avdd.n369 avdd.t29 0.227567
R1316 avdd.n369 avdd.t30 0.227567
R1317 avdd.n367 avdd.t32 0.227567
R1318 avdd.n367 avdd.t33 0.227567
R1319 avdd.n365 avdd.t35 0.227567
R1320 avdd.n365 avdd.t36 0.227567
R1321 avdd.n377 avdd.t71 0.227567
R1322 avdd.n377 avdd.t72 0.227567
R1323 avdd.n327 avdd.t170 0.226542
R1324 avdd.n327 avdd.t171 0.226542
R1325 avdd.n833 avdd.t215 0.226542
R1326 avdd.n833 avdd.t216 0.226542
R1327 avdd.n805 avdd.t179 0.226542
R1328 avdd.n805 avdd.t180 0.226542
R1329 avdd.n808 avdd.t176 0.226542
R1330 avdd.n808 avdd.t177 0.226542
R1331 avdd.n105 avdd.t182 0.226542
R1332 avdd.n105 avdd.t183 0.226542
R1333 avdd.n331 avdd.t164 0.226542
R1334 avdd.n331 avdd.t165 0.226542
R1335 avdd.n789 avdd.t161 0.226542
R1336 avdd.n789 avdd.t162 0.226542
R1337 avdd.n791 avdd.t158 0.226542
R1338 avdd.n791 avdd.t159 0.226542
R1339 avdd.n94 avdd.t155 0.226542
R1340 avdd.n94 avdd.t156 0.226542
R1341 avdd.n97 avdd.t152 0.226542
R1342 avdd.n97 avdd.t153 0.226542
R1343 avdd.n100 avdd.t149 0.226542
R1344 avdd.n100 avdd.t150 0.226542
R1345 avdd.n102 avdd.t173 0.226542
R1346 avdd.n102 avdd.t174 0.226542
R1347 avdd.n863 avdd.t185 0.226542
R1348 avdd.n863 avdd.t186 0.226542
R1349 avdd.n830 avdd.t191 0.226542
R1350 avdd.n830 avdd.t192 0.226542
R1351 avdd.n108 avdd.t188 0.226542
R1352 avdd.n108 avdd.t189 0.226542
R1353 avdd.n823 avdd.t194 0.226542
R1354 avdd.n823 avdd.t195 0.226542
R1355 avdd.n828 avdd.t197 0.226542
R1356 avdd.n828 avdd.t198 0.226542
R1357 avdd.n825 avdd.t200 0.226542
R1358 avdd.n825 avdd.t201 0.226542
R1359 avdd.n841 avdd.t203 0.226542
R1360 avdd.n841 avdd.t204 0.226542
R1361 avdd.n839 avdd.t206 0.226542
R1362 avdd.n839 avdd.t207 0.226542
R1363 avdd.n837 avdd.t209 0.226542
R1364 avdd.n837 avdd.t210 0.226542
R1365 avdd.n835 avdd.t212 0.226542
R1366 avdd.n835 avdd.t213 0.226542
R1367 avdd.n329 avdd.t167 0.226542
R1368 avdd.n329 avdd.t168 0.226542
R1369 avdd.n781 avdd.t146 0.22634
R1370 avdd.n781 avdd.t147 0.22634
R1371 avdd.n334 avdd.t143 0.22634
R1372 avdd.n334 avdd.t144 0.22634
R1373 avdd.n90 avdd.t131 0.22634
R1374 avdd.n90 avdd.t132 0.22634
R1375 avdd.n738 avdd.t62 0.22634
R1376 avdd.n738 avdd.t63 0.22634
R1377 avdd.n352 avdd.t119 0.22634
R1378 avdd.n352 avdd.t120 0.22634
R1379 avdd.n350 avdd.t41 0.22634
R1380 avdd.n350 avdd.t42 0.22634
R1381 avdd.n344 avdd.t74 0.22634
R1382 avdd.n344 avdd.t75 0.22634
R1383 avdd.n347 avdd.t44 0.22634
R1384 avdd.n347 avdd.t45 0.22634
R1385 avdd.n748 avdd.t47 0.22634
R1386 avdd.n748 avdd.t48 0.22634
R1387 avdd.n746 avdd.t50 0.22634
R1388 avdd.n746 avdd.t51 0.22634
R1389 avdd.n744 avdd.t53 0.22634
R1390 avdd.n744 avdd.t54 0.22634
R1391 avdd.n742 avdd.t56 0.22634
R1392 avdd.n742 avdd.t57 0.22634
R1393 avdd.n740 avdd.t59 0.22634
R1394 avdd.n740 avdd.t60 0.22634
R1395 avdd.n337 avdd.t122 0.22634
R1396 avdd.n337 avdd.t123 0.22634
R1397 avdd.n339 avdd.t77 0.22634
R1398 avdd.n339 avdd.t78 0.22634
R1399 avdd.n92 avdd.t128 0.22634
R1400 avdd.n92 avdd.t129 0.22634
R1401 avdd.n797 avdd.t134 0.22634
R1402 avdd.n797 avdd.t135 0.22634
R1403 avdd.n787 avdd.t137 0.22634
R1404 avdd.n787 avdd.t138 0.22634
R1405 avdd.n784 avdd.t140 0.22634
R1406 avdd.n784 avdd.t141 0.22634
R1407 avdd.n355 avdd.t125 0.22634
R1408 avdd.n355 avdd.t126 0.22634
R1409 avdd.n846 avdd.n845 0.2255
R1410 avdd.n310 avdd.n309 0.2228
R1411 avdd.n552 avdd.n487 0.2228
R1412 avdd.n532 avdd.n500 0.2228
R1413 avdd.n516 avdd.n509 0.2228
R1414 avdd.n311 avdd.n145 0.2165
R1415 avdd.n909 avdd.n117 0.2165
R1416 avdd.n827 avdd.n14 4.78627
R1417 avdd.n119 avdd.t495 0.20635
R1418 avdd.n119 avdd.t496 0.20635
R1419 avdd.n300 avdd.t537 0.20635
R1420 avdd.n300 avdd.t538 0.20635
R1421 avdd.n306 avdd.t534 0.20635
R1422 avdd.n306 avdd.t535 0.20635
R1423 avdd.n153 avdd.t507 0.20635
R1424 avdd.n153 avdd.t508 0.20635
R1425 avdd.n124 avdd.t489 0.20635
R1426 avdd.n124 avdd.t490 0.20635
R1427 avdd.n126 avdd.t486 0.20635
R1428 avdd.n126 avdd.t487 0.20635
R1429 avdd.n128 avdd.t483 0.20635
R1430 avdd.n128 avdd.t484 0.20635
R1431 avdd.n130 avdd.t480 0.20635
R1432 avdd.n130 avdd.t481 0.20635
R1433 avdd.n133 avdd.t477 0.20635
R1434 avdd.n133 avdd.t478 0.20635
R1435 avdd.n318 avdd.t474 0.20635
R1436 avdd.n318 avdd.t475 0.20635
R1437 avdd.n315 avdd.t504 0.20635
R1438 avdd.n315 avdd.t505 0.20635
R1439 avdd.n172 avdd.t543 0.20635
R1440 avdd.n172 avdd.t544 0.20635
R1441 avdd.n157 avdd.t561 0.20635
R1442 avdd.n157 avdd.t562 0.20635
R1443 avdd.n160 avdd.t558 0.20635
R1444 avdd.n160 avdd.t559 0.20635
R1445 avdd.n164 avdd.t555 0.20635
R1446 avdd.n164 avdd.t556 0.20635
R1447 avdd.n166 avdd.t552 0.20635
R1448 avdd.n166 avdd.t553 0.20635
R1449 avdd.n168 avdd.t549 0.20635
R1450 avdd.n168 avdd.t550 0.20635
R1451 avdd.n170 avdd.t546 0.20635
R1452 avdd.n170 avdd.t547 0.20635
R1453 avdd.n286 avdd.t540 0.20635
R1454 avdd.n286 avdd.t541 0.20635
R1455 avdd.n121 avdd.t492 0.20635
R1456 avdd.n121 avdd.t493 0.20635
R1457 avdd.n1 avdd.n919 4.76256
R1458 avdd.n12 avdd.n794 1.02524
R1459 avdd.n7 avdd.n6 1.87776
R1460 avdd.n767 avdd.n60 4.78034
R1461 avdd.n750 avdd.n81 4.77907
R1462 avdd.n32 avdd.n6 1.87786
R1463 avdd.n752 avdd.n32 1.02612
R1464 avdd.n753 avdd.n7 1.02607
R1465 avdd.n66 avdd.n737 4.77569
R1466 avdd.n758 avdd.n11 4.77646
R1467 avdd.n726 avdd.n33 1.02603
R1468 avdd.n727 avdd.n11 4.77578
R1469 avdd.n728 avdd.n10 4.77628
R1470 avdd.n730 avdd.n71 4.77625
R1471 avdd.n732 avdd.n68 4.77625
R1472 avdd.n734 avdd.n64 4.77552
R1473 avdd.n73 avdd.n700 4.77526
R1474 avdd.n38 avdd.n406 4.77614
R1475 avdd.n52 avdd.n409 4.77551
R1476 avdd.n69 avdd.n689 4.77452
R1477 avdd.n56 avdd.n690 4.76575
R1478 avdd.n57 avdd.n691 1.02596
R1479 avdd.n204 avdd.t531 0.193083
R1480 avdd.n204 avdd.t532 0.193083
R1481 avdd.n206 avdd.t528 0.193083
R1482 avdd.n206 avdd.t529 0.193083
R1483 avdd.n209 avdd.t525 0.193083
R1484 avdd.n209 avdd.t526 0.193083
R1485 avdd.n212 avdd.t522 0.193083
R1486 avdd.n212 avdd.t523 0.193083
R1487 avdd.n215 avdd.t519 0.193083
R1488 avdd.n215 avdd.t520 0.193083
R1489 avdd.n218 avdd.t516 0.193083
R1490 avdd.n218 avdd.t517 0.193083
R1491 avdd.n221 avdd.t513 0.193083
R1492 avdd.n221 avdd.t514 0.193083
R1493 avdd.n224 avdd.t510 0.193083
R1494 avdd.n224 avdd.t511 0.193083
R1495 avdd.n199 avdd.t501 0.193083
R1496 avdd.n199 avdd.t502 0.193083
R1497 avdd.n227 avdd.t498 0.193083
R1498 avdd.n227 avdd.t499 0.193083
R1499 avdd.n176 avdd.t439 0.193083
R1500 avdd.n176 avdd.t440 0.193083
R1501 avdd.n178 avdd.t436 0.193083
R1502 avdd.n178 avdd.t437 0.193083
R1503 avdd.n181 avdd.t433 0.193083
R1504 avdd.n181 avdd.t434 0.193083
R1505 avdd.n184 avdd.t430 0.193083
R1506 avdd.n184 avdd.t431 0.193083
R1507 avdd.n187 avdd.t427 0.193083
R1508 avdd.n187 avdd.t428 0.193083
R1509 avdd.n190 avdd.t424 0.193083
R1510 avdd.n190 avdd.t425 0.193083
R1511 avdd.n193 avdd.t421 0.193083
R1512 avdd.n193 avdd.t422 0.193083
R1513 avdd.n196 avdd.t418 0.193083
R1514 avdd.n196 avdd.t419 0.193083
R1515 avdd.n174 avdd.t468 0.193083
R1516 avdd.n174 avdd.t469 0.193083
R1517 avdd.n276 avdd.t471 0.193083
R1518 avdd.n276 avdd.t472 0.193083
R1519 avdd.n144 avdd.n143 0.1868
R1520 avdd.n310 avdd.n150 0.1868
R1521 avdd.n289 avdd.n288 0.179762
R1522 avdd.n144 avdd.n137 0.1787
R1523 avdd.n299 avdd.n156 0.171422
R1524 avdd.n308 avdd.n307 0.1625
R1525 avdd.n915 avdd.n111 0.1605
R1526 avdd.n306 avdd.n305 0.156984
R1527 avdd.n316 avdd.n315 0.156984
R1528 avdd.n901 avdd.t287 0.155181
R1529 avdd.n899 avdd.t289 0.155181
R1530 avdd.n897 avdd.t291 0.155181
R1531 avdd.n895 avdd.t293 0.155181
R1532 avdd.n893 avdd.t295 0.155181
R1533 avdd.n891 avdd.t297 0.155181
R1534 avdd.n889 avdd.t299 0.155181
R1535 avdd.n887 avdd.t301 0.155181
R1536 avdd.n885 avdd.t303 0.155181
R1537 avdd.n883 avdd.t305 0.155181
R1538 avdd.n881 avdd.t307 0.155181
R1539 avdd.n879 avdd.t309 0.155181
R1540 avdd.n877 avdd.t311 0.155181
R1541 avdd.n247 avdd.t412 0.155181
R1542 avdd.n245 avdd.t414 0.155181
R1543 avdd.n242 avdd.t444 0.155181
R1544 avdd.n241 avdd.t446 0.155181
R1545 avdd.n240 avdd.t448 0.155181
R1546 avdd.n239 avdd.t450 0.155181
R1547 avdd.n238 avdd.t452 0.155181
R1548 avdd.n237 avdd.t454 0.155181
R1549 avdd.n236 avdd.t456 0.155181
R1550 avdd.n235 avdd.t458 0.155181
R1551 avdd.n234 avdd.t460 0.155181
R1552 avdd.n233 avdd.t462 0.155181
R1553 avdd.n232 avdd.t464 0.155181
R1554 avdd.n231 avdd.t466 0.155181
R1555 avdd.n202 avdd.t416 0.155181
R1556 avdd.n867 avdd.n118 0.1445
R1557 avdd.n156 avdd.n5 0.144146
R1558 avdd.n517 avdd.n504 0.13631
R1559 avdd.n875 avdd.n873 0.1355
R1560 avdd.n694 avdd.n380 0.1355
R1561 avdd.n696 avdd.n695 0.1355
R1562 avdd.n612 avdd.n611 0.125484
R1563 avdd.n571 avdd.n474 0.115849
R1564 avdd.n313 avdd.n137 0.11435
R1565 avdd.n28 avdd.n289 5.57288
R1566 avdd.n116 avdd.n111 0.1085
R1567 avdd.n569 avdd.n568 0.1085
R1568 avdd.n568 avdd.n567 0.1085
R1569 avdd.n567 avdd.n476 0.1085
R1570 avdd.n563 avdd.n476 0.1085
R1571 avdd.n563 avdd.n562 0.1085
R1572 avdd.n562 avdd.n561 0.1085
R1573 avdd.n558 avdd.n557 0.1085
R1574 avdd.n489 avdd.n482 0.1085
R1575 avdd.n550 avdd.n489 0.1085
R1576 avdd.n544 avdd.n488 0.1085
R1577 avdd.n544 avdd.n543 0.1085
R1578 avdd.n543 avdd.n542 0.1085
R1579 avdd.n539 avdd.n538 0.1085
R1580 avdd.n526 avdd.n493 0.1085
R1581 avdd.n530 avdd.n526 0.1085
R1582 avdd.n525 avdd.n501 0.1085
R1583 avdd.n523 avdd.n501 0.1085
R1584 avdd.n523 avdd.n522 0.1085
R1585 avdd.n520 avdd.n503 0.1085
R1586 avdd.n504 avdd.n503 0.1085
R1587 avdd.n85 avdd.n84 0.100041
R1588 avdd.n58 avdd.n766 0.100041
R1589 avdd.n866 avdd.n803 0.100021
R1590 avdd.n13 avdd.n917 0.100021
R1591 avdd.n917 avdd.n916 0.100012
R1592 avdd.n920 avdd.n1 0.170423
R1593 avdd.n1 avdd.n16 0.167539
R1594 avdd.n43 avdd.n1 0.16681
R1595 avdd.n1 avdd.n21 0.166872
R1596 avdd.n39 avdd.n31 0.167064
R1597 avdd.n800 avdd.n1 0.169225
R1598 avdd.n531 avdd.n530 0.085775
R1599 avdd.n298 avdd.n29 0.0829762
R1600 avdd.n2 avdd.n682 0.0800495
R1601 avdd.n615 avdd.n613 0.0748204
R1602 avdd.n558 avdd.n478 0.0725
R1603 avdd.n557 avdd.n556 0.0725
R1604 avdd.n539 avdd.n491 0.0725
R1605 avdd.n538 avdd.n537 0.0725
R1606 avdd.n521 avdd.n520 0.0725
R1607 avdd.n551 avdd.n550 0.070025
R1608 avdd.n299 avdd.n298 0.0695483
R1609 avdd.n375 avdd.n65 0.0682517
R1610 avdd.n59 avdd.n58 0.0670846
R1611 avdd.n285 avdd.n284 0.0638362
R1612 avdd.n66 avdd.n59 0.0734914
R1613 avdd.n3 avdd.n2 0.0578383
R1614 avdd.n609 avdd.n4 4.81998
R1615 avdd.n19 avdd.n412 4.74674
R1616 avdd.n28 avdd.n27 0.0677394
R1617 avdd.n910 avdd.n909 0.0485
R1618 avdd.n117 avdd.n116 0.0485
R1619 avdd.n682 avdd.n62 0.0480035
R1620 avdd.n912 avdd.n911 0.0455
R1621 avdd.n766 avdd.n45 0.0451596
R1622 avdd.n375 avdd.n72 0.0423427
R1623 avdd.n38 avdd.n8 0.0456829
R1624 avdd.n383 avdd.n380 0.041
R1625 avdd.n699 avdd.n696 0.041
R1626 avdd.n447 avdd.n446 0.0398706
R1627 avdd.n428 avdd.n427 0.0398706
R1628 avdd.n431 avdd.n430 0.0398706
R1629 avdd.n434 avdd.n433 0.0398706
R1630 avdd.n437 avdd.n436 0.0398706
R1631 avdd.n440 avdd.n439 0.0398706
R1632 avdd.n443 avdd.n442 0.0398706
R1633 avdd.n414 avdd.n413 0.0398706
R1634 avdd.n453 avdd.n452 0.0398706
R1635 avdd.n455 avdd.n454 0.0398706
R1636 avdd.n458 avdd.n457 0.0398706
R1637 avdd.n461 avdd.n460 0.0398706
R1638 avdd.n464 avdd.n463 0.0398706
R1639 avdd.n467 avdd.n466 0.0398706
R1640 avdd.n470 avdd.n469 0.0398706
R1641 avdd.n473 avdd.n472 0.0398706
R1642 avdd.n554 avdd.n553 0.0398706
R1643 avdd.n481 avdd.n480 0.0398706
R1644 avdd.n534 avdd.n533 0.0398706
R1645 avdd.n495 avdd.n494 0.0398706
R1646 avdd.n511 avdd.n510 0.0398706
R1647 avdd.n514 avdd.n513 0.0398706
R1648 avdd.n551 avdd.n488 0.038975
R1649 avdd.n569 avdd.n474 0.0365
R1650 avdd.n561 avdd.n478 0.0365
R1651 avdd.n556 avdd.n482 0.0365
R1652 avdd.n542 avdd.n491 0.0365
R1653 avdd.n537 avdd.n493 0.0365
R1654 avdd.n522 avdd.n521 0.0365
R1655 avdd.n120 avdd.n119 0.0348857
R1656 avdd.n301 avdd.n300 0.0348857
R1657 avdd.n154 avdd.n153 0.0348857
R1658 avdd.n125 avdd.n124 0.0348857
R1659 avdd.n127 avdd.n126 0.0348857
R1660 avdd.n129 avdd.n128 0.0348857
R1661 avdd.n131 avdd.n130 0.0348857
R1662 avdd.n134 avdd.n133 0.0348857
R1663 avdd.n319 avdd.n318 0.0348857
R1664 avdd.n173 avdd.n172 0.0348857
R1665 avdd.n158 avdd.n157 0.0348857
R1666 avdd.n161 avdd.n160 0.0348857
R1667 avdd.n165 avdd.n164 0.0348857
R1668 avdd.n167 avdd.n166 0.0348857
R1669 avdd.n169 avdd.n168 0.0348857
R1670 avdd.n171 avdd.n170 0.0348857
R1671 avdd.n287 avdd.n286 0.0348857
R1672 avdd.n122 avdd.n121 0.0348857
R1673 avdd.n423 avdd.n415 0.0325
R1674 avdd.n90 avdd.n89 0.028787
R1675 avdd.n681 avdd.n680 0.0286053
R1676 avdd.n573 avdd.n572 0.0286053
R1677 avdd.n677 avdd.n676 0.0286053
R1678 avdd.n575 avdd.n574 0.0286053
R1679 avdd.n577 avdd.n576 0.0286053
R1680 avdd.n579 avdd.n578 0.0286053
R1681 avdd.n671 avdd.n670 0.0286053
R1682 avdd.n581 avdd.n580 0.0286053
R1683 avdd.n584 avdd.n583 0.0286053
R1684 avdd.n587 avdd.n586 0.0286053
R1685 avdd.n667 avdd.n666 0.0286053
R1686 avdd.n590 avdd.n589 0.0286053
R1687 avdd.n593 avdd.n592 0.0286053
R1688 avdd.n596 avdd.n595 0.0286053
R1689 avdd.n663 avdd.n662 0.0286053
R1690 avdd.n630 avdd.n629 0.0286053
R1691 avdd.n628 avdd.n627 0.0286053
R1692 avdd.n626 avdd.n625 0.0286053
R1693 avdd.n624 avdd.n623 0.0286053
R1694 avdd.n621 avdd.n620 0.0286053
R1695 avdd.n618 avdd.n617 0.0286053
R1696 avdd.n608 avdd.n607 0.0286053
R1697 avdd.n636 avdd.n635 0.0286053
R1698 avdd.n640 avdd.n639 0.0286053
R1699 avdd.n643 avdd.n642 0.0286053
R1700 avdd.n599 avdd.n598 0.0286053
R1701 avdd.n602 avdd.n601 0.0286053
R1702 avdd.n605 avdd.n604 0.0286053
R1703 avdd.n646 avdd.n645 0.0286053
R1704 avdd.n650 avdd.n649 0.0286053
R1705 avdd.n659 avdd.n658 0.0286053
R1706 avdd.n656 avdd.n655 0.0286053
R1707 avdd.n653 avdd.n652 0.0286053
R1708 avdd.n382 avdd.n381 0.0284592
R1709 avdd.n698 avdd.n697 0.0284592
R1710 avdd.n706 avdd.n379 0.02825
R1711 avdd.n707 avdd.n376 0.02825
R1712 avdd.n313 avdd.n138 0.026
R1713 avdd.n616 avdd.n609 0.026
R1714 avdd.n309 avdd.n151 0.02525
R1715 avdd.n536 avdd.n535 0.0245
R1716 avdd.n205 avdd.n204 0.023945
R1717 avdd.n207 avdd.n206 0.023945
R1718 avdd.n210 avdd.n209 0.023945
R1719 avdd.n213 avdd.n212 0.023945
R1720 avdd.n216 avdd.n215 0.023945
R1721 avdd.n219 avdd.n218 0.023945
R1722 avdd.n222 avdd.n221 0.023945
R1723 avdd.n225 avdd.n224 0.023945
R1724 avdd.n200 avdd.n199 0.023945
R1725 avdd.n228 avdd.n227 0.023945
R1726 avdd.n177 avdd.n176 0.023945
R1727 avdd.n179 avdd.n178 0.023945
R1728 avdd.n182 avdd.n181 0.023945
R1729 avdd.n185 avdd.n184 0.023945
R1730 avdd.n188 avdd.n187 0.023945
R1731 avdd.n191 avdd.n190 0.023945
R1732 avdd.n194 avdd.n193 0.023945
R1733 avdd.n197 avdd.n196 0.023945
R1734 avdd.n175 avdd.n174 0.023945
R1735 avdd.n277 avdd.n276 0.023945
R1736 avdd.n531 avdd.n525 0.023225
R1737 avdd.n648 avdd.n647 0.023
R1738 avdd.n296 avdd.n163 0.0218357
R1739 avdd.n298 avdd.n297 0.0218357
R1740 avdd.n297 avdd.n296 0.0218113
R1741 avdd.n661 avdd.n651 0.0215
R1742 avdd.n782 avdd.n781 0.0209142
R1743 avdd.n335 avdd.n334 0.0209142
R1744 avdd.n739 avdd.n738 0.0209142
R1745 avdd.n353 avdd.n352 0.0209142
R1746 avdd.n351 avdd.n350 0.0209142
R1747 avdd.n345 avdd.n344 0.0209142
R1748 avdd.n348 avdd.n347 0.0209142
R1749 avdd.n749 avdd.n748 0.0209142
R1750 avdd.n747 avdd.n746 0.0209142
R1751 avdd.n745 avdd.n744 0.0209142
R1752 avdd.n743 avdd.n742 0.0209142
R1753 avdd.n741 avdd.n740 0.0209142
R1754 avdd.n338 avdd.n337 0.0209142
R1755 avdd.n340 avdd.n339 0.0209142
R1756 avdd.n93 avdd.n92 0.0209142
R1757 avdd.n798 avdd.n797 0.0209142
R1758 avdd.n788 avdd.n787 0.0209142
R1759 avdd.n785 avdd.n784 0.0209142
R1760 avdd.n356 avdd.n355 0.0209142
R1761 avdd.n328 avdd.n327 0.0208763
R1762 avdd.n834 avdd.n833 0.0208763
R1763 avdd.n806 avdd.n805 0.0208763
R1764 avdd.n809 avdd.n808 0.0208763
R1765 avdd.n106 avdd.n105 0.0208763
R1766 avdd.n332 avdd.n331 0.0208763
R1767 avdd.n790 avdd.n789 0.0208763
R1768 avdd.n792 avdd.n791 0.0208763
R1769 avdd.n95 avdd.n94 0.0208763
R1770 avdd.n98 avdd.n97 0.0208763
R1771 avdd.n101 avdd.n100 0.0208763
R1772 avdd.n103 avdd.n102 0.0208763
R1773 avdd.n864 avdd.n863 0.0208763
R1774 avdd.n831 avdd.n830 0.0208763
R1775 avdd.n109 avdd.n108 0.0208763
R1776 avdd.n824 avdd.n823 0.0208763
R1777 avdd.n829 avdd.n828 0.0208763
R1778 avdd.n826 avdd.n825 0.0208763
R1779 avdd.n842 avdd.n841 0.0208763
R1780 avdd.n840 avdd.n839 0.0208763
R1781 avdd.n838 avdd.n837 0.0208763
R1782 avdd.n836 avdd.n835 0.0208763
R1783 avdd.n330 avdd.n329 0.0208763
R1784 avdd.n405 avdd.n404 0.0206869
R1785 avdd.n403 avdd.n402 0.0206869
R1786 avdd.n401 avdd.n400 0.0206869
R1787 avdd.n399 avdd.n398 0.0206869
R1788 avdd.n397 avdd.n396 0.0206869
R1789 avdd.n395 avdd.n394 0.0206869
R1790 avdd.n393 avdd.n392 0.0206869
R1791 avdd.n391 avdd.n390 0.0206869
R1792 avdd.n389 avdd.n388 0.0206869
R1793 avdd.n387 avdd.n386 0.0206869
R1794 avdd.n385 avdd.n384 0.0206869
R1795 avdd.n364 avdd.n363 0.0206869
R1796 avdd.n712 avdd.n711 0.0206869
R1797 avdd.n757 avdd.n756 0.0206869
R1798 avdd.n764 avdd.n763 0.0206869
R1799 avdd.n361 avdd.n360 0.0206869
R1800 avdd.n725 avdd.n724 0.0206869
R1801 avdd.n723 avdd.n722 0.0206869
R1802 avdd.n721 avdd.n720 0.0206869
R1803 avdd.n719 avdd.n718 0.0206869
R1804 avdd.n717 avdd.n716 0.0206869
R1805 avdd.n374 avdd.n373 0.0206869
R1806 avdd.n372 avdd.n371 0.0206869
R1807 avdd.n370 avdd.n369 0.0206869
R1808 avdd.n368 avdd.n367 0.0206869
R1809 avdd.n366 avdd.n365 0.0206869
R1810 avdd.n378 avdd.n377 0.0206869
R1811 avdd.n570 avdd.n475 0.0205
R1812 avdd.n566 avdd.n475 0.0205
R1813 avdd.n566 avdd.n565 0.0205
R1814 avdd.n565 avdd.n564 0.0205
R1815 avdd.n564 avdd.n477 0.0205
R1816 avdd.n560 avdd.n477 0.0205
R1817 avdd.n560 avdd.n559 0.0205
R1818 avdd.n559 avdd.n479 0.0205
R1819 avdd.n547 avdd.n479 0.0205
R1820 avdd.n548 avdd.n547 0.0205
R1821 avdd.n549 avdd.n548 0.0205
R1822 avdd.n549 avdd.n546 0.0205
R1823 avdd.n546 avdd.n545 0.0205
R1824 avdd.n545 avdd.n490 0.0205
R1825 avdd.n541 avdd.n490 0.0205
R1826 avdd.n541 avdd.n540 0.0205
R1827 avdd.n540 avdd.n492 0.0205
R1828 avdd.n527 avdd.n492 0.0205
R1829 avdd.n528 avdd.n527 0.0205
R1830 avdd.n529 avdd.n528 0.0205
R1831 avdd.n62 avdd.n61 0.0205
R1832 avdd.n61 avdd.n524 0.0205
R1833 avdd.n524 avdd.n502 0.0205
R1834 avdd.n519 avdd.n502 0.0205
R1835 avdd.n519 avdd.n518 0.0205
R1836 avdd.n665 avdd.n664 0.02
R1837 avdd.n529 avdd.n62 0.0188333
R1838 avdd.n669 avdd.n668 0.0185
R1839 avdd.n72 avdd.n54 0.0270475
R1840 avdd.n76 avdd.n65 0.0270456
R1841 avdd.n78 avdd.n46 0.0215167
R1842 avdd.n357 avdd.n35 0.017
R1843 avdd.n920 avdd.n46 0.107843
R1844 avdd.n16 avdd.n41 0.107342
R1845 avdd.n44 avdd.n43 0.107342
R1846 avdd.n800 avdd.n42 0.107615
R1847 avdd.n795 avdd.n40 0.107647
R1848 avdd.n303 avdd.n151 0.0155
R1849 avdd.n274 avdd.n273 0.0155
R1850 avdd.n275 avdd.n274 0.0155
R1851 avdd.n230 avdd.n226 0.0155
R1852 avdd.n847 avdd.n827 0.0155
R1853 avdd.n919 avdd.n918 0.0155
R1854 avdd.n768 avdd.n349 0.0155
R1855 avdd.n634 avdd.n633 0.0155
R1856 avdd.n20 avdd.n410 0.0849529
R1857 avdd.n515 avdd.n512 0.0155
R1858 avdd.n732 avdd.n731 0.0155
R1859 avdd.n45 avdd.n44 0.00373099
R1860 avdd.n925 avdd.n924 0.0143399
R1861 avdd.n49 avdd.n40 0.0362633
R1862 avdd.n17 avdd.n1 1.86964
R1863 avdd.n851 avdd.n15 1.01307
R1864 avdd.n87 avdd.n22 0.0634178
R1865 avdd.n79 avdd.n87 0.0291369
R1866 avdd.n924 avdd.n79 0.0288743
R1867 avdd.n81 avdd.n83 0.0329031
R1868 avdd.n67 avdd.n6 0.0385897
R1869 avdd.n70 avdd.n38 0.0297666
R1870 avdd.n55 avdd.n57 1.87587
R1871 avdd.n69 avdd.n56 0.0622939
R1872 avdd.n69 avdd.n74 0.0321623
R1873 avdd.n55 avdd.n54 0.0384029
R1874 avdd.n735 avdd.n63 4.77578
R1875 avdd.n48 avdd.n849 4.78533
R1876 avdd.n36 avdd.n35 1.98444
R1877 avdd.n37 avdd.n679 1.72844
R1878 avdd.n53 avdd.n70 0.0638504
R1879 avdd.n10 avdd.n9 0.0375029
R1880 avdd.n64 avdd.n63 0.0319599
R1881 avdd.n63 avdd.n76 0.0386888
R1882 avdd.n41 avdd.n82 0.0305544
R1883 avdd.n229 avdd.n201 0.01325
R1884 avdd.n854 avdd.n110 0.01325
R1885 avdd.n685 avdd.n52 0.089363
R1886 avdd.n923 avdd.n80 0.00641158
R1887 avdd.n51 avdd.n50 0.345501
R1888 avdd.n922 avdd.n34 0.194
R1889 avdd.n326 avdd.n5 0.16924
R1890 avdd.n803 avdd.n1 0.169029
R1891 avdd.n1 avdd.n39 0.164213
R1892 avdd.n1 avdd.n13 0.144411
R1893 avdd.n48 avdd.n0 0.12581
R1894 avdd.n81 avdd.n6 0.117962
R1895 avdd.n11 avdd.n10 0.11648
R1896 avdd.n62 avdd.n51 0.113651
R1897 avdd.n14 avdd.n77 0.103353
R1898 avdd avdd.n0 0.0005
R1899 dvdd.n11 dvdd.n10 41.2133
R1900 dvdd.n12 dvdd.n11 25.9411
R1901 dvdd.n10 dvdd.n9 23.4735
R1902 dvdd.n2 dvdd.n3 20.0705
R1903 dvdd.n6 dvdd.t1 16.5268
R1904 dvdd.n8 dvdd.t3 15.1483
R1905 dvdd.n2 dvdd.t4 15.0931
R1906 dvdd.n3 dvdd.t0 15.0481
R1907 dvdd.n11 dvdd.t2 10.5249
R1908 dvdd.n10 dvdd.t6 10.5033
R1909 dvdd.n5 dvdd.t5 10.4782
R1910 dvdd.n2 dvdd.n8 10.4405
R1911 dvdd.n5 dvdd.n4 6.0305
R1912 dvdd.n6 dvdd.n5 5.13038
R1913 dvdd.n4 dvdd.n1 2.53348
R1914 dvdd.n9 dvdd.n2 2.4305
R1915 dvdd.n8 dvdd.n7 1.35458
R1916 dvdd.n2 dvdd.n1 1.1705
R1917 dvdd.n7 dvdd.n6 1.12573
R1918 dvdd.n9 dvdd.n0 1.1255
R1919 dvdd dvdd.n12 1.00821
R1920 dvdd.n12 dvdd.n0 0.761363
R1921 dvdd.n7 dvdd.n1 0.199468
R1922 dvdd.n4 dvdd.n3 0.1355
R1923 dvdd.n1 dvdd.n0 0.1205
R1924 avss.n1824 avss.n1822 122.168
R1925 avss.n1826 avss.n1822 122.168
R1926 avss.n1826 avss.n1825 122.168
R1927 avss.n1825 avss.n1824 122.168
R1928 avss.n64 avss.n62 122.168
R1929 avss.n66 avss.n62 122.168
R1930 avss.n66 avss.n65 122.168
R1931 avss.n65 avss.n64 122.168
R1932 avss.n73 avss.n71 122.168
R1933 avss.n75 avss.n71 122.168
R1934 avss.n75 avss.n74 122.168
R1935 avss.n74 avss.n73 122.168
R1936 avss.n84 avss.n82 122.168
R1937 avss.n86 avss.n82 122.168
R1938 avss.n86 avss.n85 122.168
R1939 avss.n85 avss.n84 122.168
R1940 avss.n95 avss.n93 122.168
R1941 avss.n97 avss.n93 122.168
R1942 avss.n97 avss.n96 122.168
R1943 avss.n96 avss.n95 122.168
R1944 avss.n1668 avss.n1666 122.168
R1945 avss.n1670 avss.n1666 122.168
R1946 avss.n1670 avss.n1669 122.168
R1947 avss.n1669 avss.n1668 122.168
R1948 avss.n1638 avss.n1636 122.168
R1949 avss.n1640 avss.n1636 122.168
R1950 avss.n1640 avss.n1639 122.168
R1951 avss.n1639 avss.n1638 122.168
R1952 avss.n1648 avss.n1646 122.168
R1953 avss.n1650 avss.n1646 122.168
R1954 avss.n1650 avss.n1649 122.168
R1955 avss.n1649 avss.n1648 122.168
R1956 avss.n1657 avss.n1655 122.168
R1957 avss.n1659 avss.n1655 122.168
R1958 avss.n1659 avss.n1658 122.168
R1959 avss.n1658 avss.n1657 122.168
R1960 avss.n1628 avss.n1626 122.168
R1961 avss.n1630 avss.n1626 122.168
R1962 avss.n1630 avss.n1629 122.168
R1963 avss.n1629 avss.n1628 122.168
R1964 avss.n1677 avss.n1676 62.2513
R1965 avss.n1726 avss.n1723 50.738
R1966 avss.n1737 avss.n1734 41.7425
R1967 avss.n217 avss.t206 36.779
R1968 avss.n42 avss.n43 7.02266
R1969 avss.n28 avss.n27 7.02206
R1970 avss.n25 avss.n26 6.95642
R1971 avss.n45 avss.t214 32.7629
R1972 avss.n1743 avss.n58 29.3779
R1973 avss.n1812 avss.n103 25.79
R1974 avss avss.n1801 24.3005
R1975 avss.n218 avss.t207 23.4413
R1976 avss.n105 avss.t0 23.0375
R1977 avss.n1675 avss.n1623 20.2955
R1978 avss.n1683 avss.n1682 20.1265
R1979 avss.n1811 avss.n1810 19.6655
R1980 avss.n1719 avss.n1718 19.6205
R1981 avss.n1809 avss.t239 18.6687
R1982 avss.n1814 avss.n104 18.6305
R1983 avss.n105 avss.t240 18.3645
R1984 avss.n1745 avss.t213 18.3299
R1985 avss.n1675 avss.n1674 18.2705
R1986 avss.n104 avss.t6 17.852
R1987 avss.n44 avss.n1719 17.7305
R1988 avss.n1810 avss.n105 15.9755
R1989 avss.n1815 avss.n1814 15.8405
R1990 avss.n1772 avss.n40 15.7588
R1991 avss.n1709 avss.t4 15.5285
R1992 avss.n1744 avss.n150 15.3455
R1993 avss.n1804 avss.t93 15.1395
R1994 avss.n132 avss.t75 15.1395
R1995 avss.n118 avss.t72 15.1395
R1996 avss.n120 avss.t69 15.1395
R1997 avss.n123 avss.t66 15.1395
R1998 avss.n126 avss.t63 15.1395
R1999 avss.n129 avss.t60 15.1395
R2000 avss.n116 avss.t57 15.1395
R2001 avss.n114 avss.t78 15.1395
R2002 avss.n140 avss.t96 15.1395
R2003 avss.n137 avss.t99 15.1395
R2004 avss.n142 avss.t102 15.1395
R2005 avss.n1798 avss.t105 15.1395
R2006 avss.n1796 avss.t108 15.1395
R2007 avss.n1813 avss.t2 14.7703
R2008 avss.n1793 avss.t1 14.7027
R2009 avss.n1811 avss.t211 14.1655
R2010 avss.n1707 avss.t5 13.9283
R2011 avss.n1676 avss.n1675 13.8605
R2012 avss.n1792 avss.n1784 13.6894
R2013 avss.n1806 avss.n52 13.5005
R2014 avss.n1810 avss.n1809 13.4105
R2015 avss.n1753 avss.t171 12.4325
R2016 avss.n145 avss.t198 12.4325
R2017 avss.n1762 avss.t195 12.4325
R2018 avss.n1765 avss.t192 12.4325
R2019 avss.n1768 avss.t189 12.4325
R2020 avss.n1771 avss.t186 12.4325
R2021 avss.n1749 avss.t174 12.4325
R2022 avss.n152 avss.t177 12.4325
R2023 avss.n149 avss.t180 12.4325
R2024 avss.n1758 avss.t183 12.4049
R2025 avss.n1812 avss.n1811 11.8805
R2026 avss.n130 avss.n127 10.7105
R2027 avss.n53 avss.n130 10.6655
R2028 avss.n942 avss.n941 10.5005
R2029 avss.n12 avss.n1741 10.4555
R2030 avss.n187 avss.t203 10.3787
R2031 avss.n155 avss.t208 10.3787
R2032 avss.n1677 avss.t201 10.3067
R2033 avss.n1683 avss.t202 10.2353
R2034 avss.n187 avss.t204 9.82074
R2035 avss.n188 avss.t205 9.82074
R2036 avss.n189 avss.t7 9.82074
R2037 avss.n190 avss.t8 9.82074
R2038 avss.n191 avss.t3 9.82074
R2039 avss.n155 avss.t209 9.82074
R2040 avss.n156 avss.t210 9.82074
R2041 avss.n157 avss.t236 9.82074
R2042 avss.n158 avss.t237 9.82074
R2043 avss.n159 avss.t238 9.82074
R2044 avss.n1791 avss.t212 9.70008
R2045 avss.n78 avss 9.2255
R2046 avss.n1674 avss.n1673 9.1805
R2047 avss.n1815 avss 9.15251
R2048 avss.n1819 avss.n1818 9.1355
R2049 avss.n78 avss 9.0905
R2050 avss.n100 avss 9.0905
R2051 avss avss.n102 9.0905
R2052 avss.n1644 avss 9.0905
R2053 avss.n1653 avss 9.0905
R2054 avss.n80 avss 9.014
R2055 avss.n1664 avss 9.014
R2056 avss.t226 avss.n26 0.135759
R2057 avss.n28 avss.t228 0.131433
R2058 avss.n43 avss.t230 0.131394
R2059 avss.n1678 avss.n1677 9.0005
R2060 avss.n89 avss 9.0005
R2061 avss.n91 avss.n90 9.0005
R2062 avss.n1634 avss.n1633 9.0005
R2063 avss.n218 avss.n217 8.9555
R2064 avss.n1774 avss.t126 8.66734
R2065 avss.n1776 avss.t123 8.66734
R2066 avss.n1779 avss.t120 8.66734
R2067 avss.n107 avss.t84 8.66734
R2068 avss.n109 avss.t81 8.66734
R2069 avss.n1782 avss.t117 8.66734
R2070 avss.n111 avss.t111 8.66734
R2071 avss.n1784 avss.t114 8.66734
R2072 avss.n1786 avss.t87 8.66734
R2073 avss.n1788 avss.t90 8.66734
R2074 avss.n199 avss.t30 8.35004
R2075 avss.n1725 avss.t51 8.35004
R2076 avss.n1736 avss.t144 8.35004
R2077 avss.n1739 avss.t168 8.35004
R2078 avss.n180 avss.t165 8.35004
R2079 avss.n177 avss.t162 8.35004
R2080 avss.n174 avss.t159 8.35004
R2081 avss.n171 avss.t156 8.35004
R2082 avss.n168 avss.t153 8.35004
R2083 avss.n165 avss.t150 8.35004
R2084 avss.n161 avss.t141 8.35004
R2085 avss.n201 avss.t27 8.35004
R2086 avss.n204 avss.t24 8.35004
R2087 avss.n207 avss.t21 8.35004
R2088 avss.n209 avss.t18 8.35004
R2089 avss.n211 avss.t15 8.35004
R2090 avss.n195 avss.t12 8.35004
R2091 avss.n1721 avss.t9 8.35004
R2092 avss.n185 avss.t48 8.29121
R2093 avss.n1729 avss.t147 8.29121
R2094 avss.n1708 avss.n1691 8.2805
R2095 avss.n1621 avss.n221 8.16717
R2096 avss.n1751 avss.n146 7.772
R2097 avss.n1789 avss.n1788 7.73065
R2098 avss.n1777 avss.n1774 7.62445
R2099 avss.n121 avss.n118 7.53742
R2100 avss.n1794 avss.n1793 7.5155
R2101 avss.n196 avss.n42 7.49688
R2102 avss.n571 avss.n221 7.0005
R2103 avss.n571 avss.n570 7.0005
R2104 avss.n575 avss.n570 7.0005
R2105 avss.n576 avss.n575 7.0005
R2106 avss.n577 avss.n576 7.0005
R2107 avss.n577 avss.n568 7.0005
R2108 avss.n581 avss.n568 7.0005
R2109 avss.n582 avss.n581 7.0005
R2110 avss.n583 avss.n582 7.0005
R2111 avss.n583 avss.n566 7.0005
R2112 avss.n587 avss.n566 7.0005
R2113 avss.n588 avss.n587 7.0005
R2114 avss.n589 avss.n588 7.0005
R2115 avss.n589 avss.n564 7.0005
R2116 avss.n593 avss.n564 7.0005
R2117 avss.n594 avss.n593 7.0005
R2118 avss.n595 avss.n594 7.0005
R2119 avss.n595 avss.n562 7.0005
R2120 avss.n599 avss.n562 7.0005
R2121 avss.n600 avss.n599 7.0005
R2122 avss.n601 avss.n600 7.0005
R2123 avss.n601 avss.n560 7.0005
R2124 avss.n605 avss.n560 7.0005
R2125 avss.n606 avss.n605 7.0005
R2126 avss.n607 avss.n606 7.0005
R2127 avss.n607 avss.n558 7.0005
R2128 avss.n611 avss.n558 7.0005
R2129 avss.n612 avss.n611 7.0005
R2130 avss.n613 avss.n612 7.0005
R2131 avss.n613 avss.n556 7.0005
R2132 avss.n617 avss.n556 7.0005
R2133 avss.n618 avss.n617 7.0005
R2134 avss.n619 avss.n618 7.0005
R2135 avss.n619 avss.n554 7.0005
R2136 avss.n623 avss.n554 7.0005
R2137 avss.n624 avss.n623 7.0005
R2138 avss.n625 avss.n624 7.0005
R2139 avss.n625 avss.n552 7.0005
R2140 avss.n629 avss.n552 7.0005
R2141 avss.n630 avss.n629 7.0005
R2142 avss.n631 avss.n630 7.0005
R2143 avss.n631 avss.n550 7.0005
R2144 avss.n635 avss.n550 7.0005
R2145 avss.n636 avss.n635 7.0005
R2146 avss.n637 avss.n636 7.0005
R2147 avss.n637 avss.n548 7.0005
R2148 avss.n641 avss.n548 7.0005
R2149 avss.n642 avss.n641 7.0005
R2150 avss.n643 avss.n642 7.0005
R2151 avss.n643 avss.n546 7.0005
R2152 avss.n647 avss.n546 7.0005
R2153 avss.n648 avss.n647 7.0005
R2154 avss.n649 avss.n648 7.0005
R2155 avss.n649 avss.n544 7.0005
R2156 avss.n653 avss.n544 7.0005
R2157 avss.n654 avss.n653 7.0005
R2158 avss.n655 avss.n654 7.0005
R2159 avss.n655 avss.n542 7.0005
R2160 avss.n659 avss.n542 7.0005
R2161 avss.n660 avss.n659 7.0005
R2162 avss.n661 avss.n660 7.0005
R2163 avss.n661 avss.n540 7.0005
R2164 avss.n665 avss.n540 7.0005
R2165 avss.n666 avss.n665 7.0005
R2166 avss.n667 avss.n666 7.0005
R2167 avss.n667 avss.n538 7.0005
R2168 avss.n671 avss.n538 7.0005
R2169 avss.n672 avss.n671 7.0005
R2170 avss.n673 avss.n672 7.0005
R2171 avss.n673 avss.n536 7.0005
R2172 avss.n677 avss.n536 7.0005
R2173 avss.n678 avss.n677 7.0005
R2174 avss.n679 avss.n678 7.0005
R2175 avss.n679 avss.n534 7.0005
R2176 avss.n683 avss.n534 7.0005
R2177 avss.n684 avss.n683 7.0005
R2178 avss.n685 avss.n684 7.0005
R2179 avss.n685 avss.n532 7.0005
R2180 avss.n689 avss.n532 7.0005
R2181 avss.n690 avss.n689 7.0005
R2182 avss.n691 avss.n690 7.0005
R2183 avss.n691 avss.n530 7.0005
R2184 avss.n695 avss.n530 7.0005
R2185 avss.n696 avss.n695 7.0005
R2186 avss.n697 avss.n696 7.0005
R2187 avss.n697 avss.n528 7.0005
R2188 avss.n701 avss.n528 7.0005
R2189 avss.n702 avss.n701 7.0005
R2190 avss.n703 avss.n702 7.0005
R2191 avss.n703 avss.n526 7.0005
R2192 avss.n707 avss.n526 7.0005
R2193 avss.n708 avss.n707 7.0005
R2194 avss.n709 avss.n708 7.0005
R2195 avss.n709 avss.n524 7.0005
R2196 avss.n713 avss.n524 7.0005
R2197 avss.n714 avss.n713 7.0005
R2198 avss.n715 avss.n714 7.0005
R2199 avss.n715 avss.n522 7.0005
R2200 avss.n719 avss.n522 7.0005
R2201 avss.n720 avss.n719 7.0005
R2202 avss.n721 avss.n720 7.0005
R2203 avss.n721 avss.n520 7.0005
R2204 avss.n725 avss.n520 7.0005
R2205 avss.n726 avss.n725 7.0005
R2206 avss.n727 avss.n726 7.0005
R2207 avss.n727 avss.n518 7.0005
R2208 avss.n731 avss.n518 7.0005
R2209 avss.n732 avss.n731 7.0005
R2210 avss.n733 avss.n732 7.0005
R2211 avss.n733 avss.n516 7.0005
R2212 avss.n737 avss.n516 7.0005
R2213 avss.n738 avss.n737 7.0005
R2214 avss.n739 avss.n738 7.0005
R2215 avss.n739 avss.n514 7.0005
R2216 avss.n743 avss.n514 7.0005
R2217 avss.n744 avss.n743 7.0005
R2218 avss.n745 avss.n744 7.0005
R2219 avss.n745 avss.n512 7.0005
R2220 avss.n749 avss.n512 7.0005
R2221 avss.n750 avss.n749 7.0005
R2222 avss.n751 avss.n750 7.0005
R2223 avss.n751 avss.n510 7.0005
R2224 avss.n755 avss.n510 7.0005
R2225 avss.n756 avss.n755 7.0005
R2226 avss.n757 avss.n756 7.0005
R2227 avss.n757 avss.n508 7.0005
R2228 avss.n761 avss.n508 7.0005
R2229 avss.n762 avss.n761 7.0005
R2230 avss.n763 avss.n762 7.0005
R2231 avss.n763 avss.n506 7.0005
R2232 avss.n767 avss.n506 7.0005
R2233 avss.n768 avss.n767 7.0005
R2234 avss.n769 avss.n768 7.0005
R2235 avss.n769 avss.n504 7.0005
R2236 avss.n773 avss.n504 7.0005
R2237 avss.n774 avss.n773 7.0005
R2238 avss.n775 avss.n774 7.0005
R2239 avss.n775 avss.n502 7.0005
R2240 avss.n779 avss.n502 7.0005
R2241 avss.n780 avss.n779 7.0005
R2242 avss.n781 avss.n780 7.0005
R2243 avss.n781 avss.n500 7.0005
R2244 avss.n785 avss.n500 7.0005
R2245 avss.n786 avss.n785 7.0005
R2246 avss.n787 avss.n786 7.0005
R2247 avss.n787 avss.n498 7.0005
R2248 avss.n791 avss.n498 7.0005
R2249 avss.n792 avss.n791 7.0005
R2250 avss.n793 avss.n792 7.0005
R2251 avss.n793 avss.n496 7.0005
R2252 avss.n797 avss.n496 7.0005
R2253 avss.n798 avss.n797 7.0005
R2254 avss.n799 avss.n798 7.0005
R2255 avss.n799 avss.n494 7.0005
R2256 avss.n803 avss.n494 7.0005
R2257 avss.n804 avss.n803 7.0005
R2258 avss.n805 avss.n804 7.0005
R2259 avss.n805 avss.n492 7.0005
R2260 avss.n809 avss.n492 7.0005
R2261 avss.n810 avss.n809 7.0005
R2262 avss.n811 avss.n810 7.0005
R2263 avss.n811 avss.n490 7.0005
R2264 avss.n815 avss.n490 7.0005
R2265 avss.n816 avss.n815 7.0005
R2266 avss.n817 avss.n816 7.0005
R2267 avss.n817 avss.n488 7.0005
R2268 avss.n821 avss.n488 7.0005
R2269 avss.n822 avss.n821 7.0005
R2270 avss.n823 avss.n822 7.0005
R2271 avss.n823 avss.n486 7.0005
R2272 avss.n827 avss.n486 7.0005
R2273 avss.n828 avss.n827 7.0005
R2274 avss.n829 avss.n828 7.0005
R2275 avss.n829 avss.n484 7.0005
R2276 avss.n833 avss.n484 7.0005
R2277 avss.n834 avss.n833 7.0005
R2278 avss.n835 avss.n834 7.0005
R2279 avss.n835 avss.n482 7.0005
R2280 avss.n839 avss.n482 7.0005
R2281 avss.n840 avss.n839 7.0005
R2282 avss.n841 avss.n840 7.0005
R2283 avss.n841 avss.n480 7.0005
R2284 avss.n845 avss.n480 7.0005
R2285 avss.n846 avss.n845 7.0005
R2286 avss.n847 avss.n846 7.0005
R2287 avss.n847 avss.n478 7.0005
R2288 avss.n851 avss.n478 7.0005
R2289 avss.n852 avss.n851 7.0005
R2290 avss.n853 avss.n852 7.0005
R2291 avss.n853 avss.n476 7.0005
R2292 avss.n857 avss.n476 7.0005
R2293 avss.n858 avss.n857 7.0005
R2294 avss.n859 avss.n858 7.0005
R2295 avss.n859 avss.n474 7.0005
R2296 avss.n863 avss.n474 7.0005
R2297 avss.n864 avss.n863 7.0005
R2298 avss.n865 avss.n864 7.0005
R2299 avss.n865 avss.n472 7.0005
R2300 avss.n869 avss.n472 7.0005
R2301 avss.n870 avss.n869 7.0005
R2302 avss.n871 avss.n870 7.0005
R2303 avss.n871 avss.n470 7.0005
R2304 avss.n875 avss.n470 7.0005
R2305 avss.n876 avss.n875 7.0005
R2306 avss.n877 avss.n876 7.0005
R2307 avss.n877 avss.n468 7.0005
R2308 avss.n881 avss.n468 7.0005
R2309 avss.n882 avss.n881 7.0005
R2310 avss.n883 avss.n882 7.0005
R2311 avss.n883 avss.n466 7.0005
R2312 avss.n887 avss.n466 7.0005
R2313 avss.n888 avss.n887 7.0005
R2314 avss.n889 avss.n888 7.0005
R2315 avss.n889 avss.n464 7.0005
R2316 avss.n893 avss.n464 7.0005
R2317 avss.n894 avss.n893 7.0005
R2318 avss.n895 avss.n894 7.0005
R2319 avss.n895 avss.n462 7.0005
R2320 avss.n899 avss.n462 7.0005
R2321 avss.n900 avss.n899 7.0005
R2322 avss.n901 avss.n900 7.0005
R2323 avss.n901 avss.n460 7.0005
R2324 avss.n905 avss.n460 7.0005
R2325 avss.n906 avss.n905 7.0005
R2326 avss.n907 avss.n906 7.0005
R2327 avss.n907 avss.n458 7.0005
R2328 avss.n911 avss.n458 7.0005
R2329 avss.n912 avss.n911 7.0005
R2330 avss.n913 avss.n912 7.0005
R2331 avss.n913 avss.n456 7.0005
R2332 avss.n917 avss.n456 7.0005
R2333 avss.n918 avss.n917 7.0005
R2334 avss.n919 avss.n918 7.0005
R2335 avss.n919 avss.n454 7.0005
R2336 avss.n923 avss.n454 7.0005
R2337 avss.n924 avss.n923 7.0005
R2338 avss.n925 avss.n924 7.0005
R2339 avss.n925 avss.n452 7.0005
R2340 avss.n929 avss.n452 7.0005
R2341 avss.n930 avss.n929 7.0005
R2342 avss.n931 avss.n930 7.0005
R2343 avss.n931 avss.n450 7.0005
R2344 avss.n935 avss.n450 7.0005
R2345 avss.n936 avss.n935 7.0005
R2346 avss.n937 avss.n936 7.0005
R2347 avss.n937 avss.n448 7.0005
R2348 avss.n941 avss.n448 7.0005
R2349 avss.n1470 avss.n1469 7.0005
R2350 avss.n1471 avss.n1470 7.0005
R2351 avss.n1471 avss.n270 7.0005
R2352 avss.n1475 avss.n270 7.0005
R2353 avss.n1476 avss.n1475 7.0005
R2354 avss.n1477 avss.n1476 7.0005
R2355 avss.n1477 avss.n268 7.0005
R2356 avss.n1481 avss.n268 7.0005
R2357 avss.n1482 avss.n1481 7.0005
R2358 avss.n1483 avss.n1482 7.0005
R2359 avss.n1483 avss.n266 7.0005
R2360 avss.n1487 avss.n266 7.0005
R2361 avss.n1488 avss.n1487 7.0005
R2362 avss.n1489 avss.n1488 7.0005
R2363 avss.n1489 avss.n264 7.0005
R2364 avss.n1493 avss.n264 7.0005
R2365 avss.n1494 avss.n1493 7.0005
R2366 avss.n1495 avss.n1494 7.0005
R2367 avss.n1495 avss.n262 7.0005
R2368 avss.n1499 avss.n262 7.0005
R2369 avss.n1500 avss.n1499 7.0005
R2370 avss.n1501 avss.n1500 7.0005
R2371 avss.n1501 avss.n260 7.0005
R2372 avss.n1505 avss.n260 7.0005
R2373 avss.n1506 avss.n1505 7.0005
R2374 avss.n1507 avss.n1506 7.0005
R2375 avss.n1507 avss.n258 7.0005
R2376 avss.n1511 avss.n258 7.0005
R2377 avss.n1512 avss.n1511 7.0005
R2378 avss.n1513 avss.n1512 7.0005
R2379 avss.n1513 avss.n256 7.0005
R2380 avss.n1517 avss.n256 7.0005
R2381 avss.n1518 avss.n1517 7.0005
R2382 avss.n1519 avss.n1518 7.0005
R2383 avss.n1519 avss.n254 7.0005
R2384 avss.n1523 avss.n254 7.0005
R2385 avss.n1524 avss.n1523 7.0005
R2386 avss.n1525 avss.n1524 7.0005
R2387 avss.n1525 avss.n252 7.0005
R2388 avss.n1529 avss.n252 7.0005
R2389 avss.n1530 avss.n1529 7.0005
R2390 avss.n1531 avss.n1530 7.0005
R2391 avss.n1531 avss.n250 7.0005
R2392 avss.n1535 avss.n250 7.0005
R2393 avss.n1536 avss.n1535 7.0005
R2394 avss.n1537 avss.n1536 7.0005
R2395 avss.n1537 avss.n248 7.0005
R2396 avss.n1541 avss.n248 7.0005
R2397 avss.n1542 avss.n1541 7.0005
R2398 avss.n1543 avss.n1542 7.0005
R2399 avss.n1543 avss.n246 7.0005
R2400 avss.n1547 avss.n246 7.0005
R2401 avss.n1548 avss.n1547 7.0005
R2402 avss.n1549 avss.n1548 7.0005
R2403 avss.n1549 avss.n244 7.0005
R2404 avss.n1553 avss.n244 7.0005
R2405 avss.n1554 avss.n1553 7.0005
R2406 avss.n1555 avss.n1554 7.0005
R2407 avss.n1555 avss.n242 7.0005
R2408 avss.n1559 avss.n242 7.0005
R2409 avss.n1560 avss.n1559 7.0005
R2410 avss.n1561 avss.n1560 7.0005
R2411 avss.n1561 avss.n240 7.0005
R2412 avss.n1565 avss.n240 7.0005
R2413 avss.n1566 avss.n1565 7.0005
R2414 avss.n1567 avss.n1566 7.0005
R2415 avss.n1567 avss.n238 7.0005
R2416 avss.n1571 avss.n238 7.0005
R2417 avss.n1572 avss.n1571 7.0005
R2418 avss.n1573 avss.n1572 7.0005
R2419 avss.n1573 avss.n236 7.0005
R2420 avss.n1577 avss.n236 7.0005
R2421 avss.n1578 avss.n1577 7.0005
R2422 avss.n1579 avss.n1578 7.0005
R2423 avss.n1579 avss.n234 7.0005
R2424 avss.n1583 avss.n234 7.0005
R2425 avss.n1584 avss.n1583 7.0005
R2426 avss.n1585 avss.n1584 7.0005
R2427 avss.n1585 avss.n232 7.0005
R2428 avss.n1589 avss.n232 7.0005
R2429 avss.n1590 avss.n1589 7.0005
R2430 avss.n1591 avss.n1590 7.0005
R2431 avss.n1591 avss.n230 7.0005
R2432 avss.n1595 avss.n230 7.0005
R2433 avss.n1596 avss.n1595 7.0005
R2434 avss.n1597 avss.n1596 7.0005
R2435 avss.n1597 avss.n228 7.0005
R2436 avss.n1601 avss.n228 7.0005
R2437 avss.n1602 avss.n1601 7.0005
R2438 avss.n1603 avss.n1602 7.0005
R2439 avss.n1603 avss.n226 7.0005
R2440 avss.n1607 avss.n226 7.0005
R2441 avss.n1608 avss.n1607 7.0005
R2442 avss.n1609 avss.n1608 7.0005
R2443 avss.n1609 avss.n224 7.0005
R2444 avss.n1613 avss.n224 7.0005
R2445 avss.n1614 avss.n1613 7.0005
R2446 avss.n1615 avss.n1614 7.0005
R2447 avss.n1615 avss.n222 7.0005
R2448 avss.n1619 avss.n222 7.0005
R2449 avss.n1620 avss.n1619 7.0005
R2450 avss.n1621 avss.n1620 7.0005
R2451 avss.n1093 avss.n396 7.0005
R2452 avss.n1093 avss.n1092 7.0005
R2453 avss.n1092 avss.n1091 7.0005
R2454 avss.n1091 avss.n398 7.0005
R2455 avss.n1087 avss.n398 7.0005
R2456 avss.n1087 avss.n1086 7.0005
R2457 avss.n1086 avss.n1085 7.0005
R2458 avss.n1085 avss.n400 7.0005
R2459 avss.n1081 avss.n400 7.0005
R2460 avss.n1081 avss.n1080 7.0005
R2461 avss.n1080 avss.n1079 7.0005
R2462 avss.n1079 avss.n402 7.0005
R2463 avss.n1075 avss.n402 7.0005
R2464 avss.n1075 avss.n1074 7.0005
R2465 avss.n1074 avss.n1073 7.0005
R2466 avss.n1073 avss.n404 7.0005
R2467 avss.n1069 avss.n404 7.0005
R2468 avss.n1069 avss.n1068 7.0005
R2469 avss.n1068 avss.n1067 7.0005
R2470 avss.n1067 avss.n406 7.0005
R2471 avss.n1063 avss.n406 7.0005
R2472 avss.n1063 avss.n1062 7.0005
R2473 avss.n1062 avss.n1061 7.0005
R2474 avss.n1061 avss.n408 7.0005
R2475 avss.n1057 avss.n408 7.0005
R2476 avss.n1057 avss.n1056 7.0005
R2477 avss.n1056 avss.n1055 7.0005
R2478 avss.n1055 avss.n410 7.0005
R2479 avss.n1051 avss.n410 7.0005
R2480 avss.n1051 avss.n1050 7.0005
R2481 avss.n1050 avss.n1049 7.0005
R2482 avss.n1049 avss.n412 7.0005
R2483 avss.n1045 avss.n412 7.0005
R2484 avss.n1045 avss.n1044 7.0005
R2485 avss.n1044 avss.n1043 7.0005
R2486 avss.n1043 avss.n414 7.0005
R2487 avss.n1039 avss.n414 7.0005
R2488 avss.n1039 avss.n1038 7.0005
R2489 avss.n1038 avss.n1037 7.0005
R2490 avss.n1037 avss.n416 7.0005
R2491 avss.n1033 avss.n416 7.0005
R2492 avss.n1033 avss.n1032 7.0005
R2493 avss.n1032 avss.n1031 7.0005
R2494 avss.n1031 avss.n418 7.0005
R2495 avss.n1027 avss.n418 7.0005
R2496 avss.n1027 avss.n1026 7.0005
R2497 avss.n1026 avss.n1025 7.0005
R2498 avss.n1025 avss.n420 7.0005
R2499 avss.n1021 avss.n420 7.0005
R2500 avss.n1021 avss.n1020 7.0005
R2501 avss.n1020 avss.n1019 7.0005
R2502 avss.n1019 avss.n422 7.0005
R2503 avss.n1015 avss.n422 7.0005
R2504 avss.n1015 avss.n1014 7.0005
R2505 avss.n1014 avss.n1013 7.0005
R2506 avss.n1013 avss.n424 7.0005
R2507 avss.n1009 avss.n424 7.0005
R2508 avss.n1009 avss.n1008 7.0005
R2509 avss.n1008 avss.n1007 7.0005
R2510 avss.n1007 avss.n426 7.0005
R2511 avss.n1003 avss.n426 7.0005
R2512 avss.n1003 avss.n1002 7.0005
R2513 avss.n1002 avss.n1001 7.0005
R2514 avss.n1001 avss.n428 7.0005
R2515 avss.n997 avss.n428 7.0005
R2516 avss.n997 avss.n996 7.0005
R2517 avss.n996 avss.n995 7.0005
R2518 avss.n995 avss.n430 7.0005
R2519 avss.n991 avss.n430 7.0005
R2520 avss.n991 avss.n990 7.0005
R2521 avss.n990 avss.n989 7.0005
R2522 avss.n989 avss.n432 7.0005
R2523 avss.n985 avss.n432 7.0005
R2524 avss.n985 avss.n984 7.0005
R2525 avss.n984 avss.n983 7.0005
R2526 avss.n983 avss.n434 7.0005
R2527 avss.n979 avss.n434 7.0005
R2528 avss.n979 avss.n978 7.0005
R2529 avss.n978 avss.n977 7.0005
R2530 avss.n977 avss.n436 7.0005
R2531 avss.n973 avss.n436 7.0005
R2532 avss.n973 avss.n972 7.0005
R2533 avss.n972 avss.n971 7.0005
R2534 avss.n971 avss.n438 7.0005
R2535 avss.n967 avss.n438 7.0005
R2536 avss.n967 avss.n966 7.0005
R2537 avss.n966 avss.n965 7.0005
R2538 avss.n965 avss.n440 7.0005
R2539 avss.n961 avss.n440 7.0005
R2540 avss.n961 avss.n960 7.0005
R2541 avss.n960 avss.n959 7.0005
R2542 avss.n959 avss.n442 7.0005
R2543 avss.n955 avss.n442 7.0005
R2544 avss.n955 avss.n954 7.0005
R2545 avss.n954 avss.n953 7.0005
R2546 avss.n953 avss.n444 7.0005
R2547 avss.n949 avss.n444 7.0005
R2548 avss.n949 avss.n948 7.0005
R2549 avss.n948 avss.n947 7.0005
R2550 avss.n947 avss.n446 7.0005
R2551 avss.n943 avss.n446 7.0005
R2552 avss.n943 avss.n942 7.0005
R2553 avss.n1465 avss.n272 7.0005
R2554 avss.n1465 avss.n1464 7.0005
R2555 avss.n1464 avss.n1463 7.0005
R2556 avss.n1463 avss.n274 7.0005
R2557 avss.n1459 avss.n274 7.0005
R2558 avss.n1459 avss.n1458 7.0005
R2559 avss.n1458 avss.n1457 7.0005
R2560 avss.n1457 avss.n276 7.0005
R2561 avss.n1453 avss.n276 7.0005
R2562 avss.n1453 avss.n1452 7.0005
R2563 avss.n1452 avss.n1451 7.0005
R2564 avss.n1451 avss.n278 7.0005
R2565 avss.n1447 avss.n278 7.0005
R2566 avss.n1447 avss.n1446 7.0005
R2567 avss.n1446 avss.n1445 7.0005
R2568 avss.n1445 avss.n280 7.0005
R2569 avss.n1441 avss.n280 7.0005
R2570 avss.n1441 avss.n1440 7.0005
R2571 avss.n1440 avss.n1439 7.0005
R2572 avss.n1439 avss.n282 7.0005
R2573 avss.n1435 avss.n282 7.0005
R2574 avss.n1435 avss.n1434 7.0005
R2575 avss.n1434 avss.n1433 7.0005
R2576 avss.n1433 avss.n284 7.0005
R2577 avss.n1429 avss.n284 7.0005
R2578 avss.n1429 avss.n1428 7.0005
R2579 avss.n1428 avss.n1427 7.0005
R2580 avss.n1427 avss.n286 7.0005
R2581 avss.n1423 avss.n286 7.0005
R2582 avss.n1423 avss.n1422 7.0005
R2583 avss.n1422 avss.n1421 7.0005
R2584 avss.n1421 avss.n288 7.0005
R2585 avss.n1417 avss.n288 7.0005
R2586 avss.n1417 avss.n1416 7.0005
R2587 avss.n1416 avss.n1415 7.0005
R2588 avss.n1415 avss.n290 7.0005
R2589 avss.n1411 avss.n290 7.0005
R2590 avss.n1411 avss.n1410 7.0005
R2591 avss.n1410 avss.n1409 7.0005
R2592 avss.n1409 avss.n292 7.0005
R2593 avss.n1405 avss.n292 7.0005
R2594 avss.n1405 avss.n1404 7.0005
R2595 avss.n1404 avss.n1403 7.0005
R2596 avss.n1403 avss.n294 7.0005
R2597 avss.n1399 avss.n294 7.0005
R2598 avss.n1399 avss.n1398 7.0005
R2599 avss.n1398 avss.n1397 7.0005
R2600 avss.n1397 avss.n296 7.0005
R2601 avss.n1393 avss.n296 7.0005
R2602 avss.n1393 avss.n1392 7.0005
R2603 avss.n1392 avss.n1391 7.0005
R2604 avss.n1391 avss.n298 7.0005
R2605 avss.n1387 avss.n298 7.0005
R2606 avss.n1387 avss.n1386 7.0005
R2607 avss.n1386 avss.n1385 7.0005
R2608 avss.n1385 avss.n300 7.0005
R2609 avss.n1381 avss.n300 7.0005
R2610 avss.n1381 avss.n1380 7.0005
R2611 avss.n1380 avss.n1379 7.0005
R2612 avss.n1379 avss.n302 7.0005
R2613 avss.n1375 avss.n302 7.0005
R2614 avss.n1375 avss.n1374 7.0005
R2615 avss.n1374 avss.n1373 7.0005
R2616 avss.n1373 avss.n304 7.0005
R2617 avss.n1369 avss.n304 7.0005
R2618 avss.n1369 avss.n1368 7.0005
R2619 avss.n1368 avss.n1367 7.0005
R2620 avss.n1367 avss.n306 7.0005
R2621 avss.n1363 avss.n306 7.0005
R2622 avss.n1363 avss.n1362 7.0005
R2623 avss.n1362 avss.n1361 7.0005
R2624 avss.n1361 avss.n308 7.0005
R2625 avss.n1357 avss.n308 7.0005
R2626 avss.n1357 avss.n1356 7.0005
R2627 avss.n1356 avss.n1355 7.0005
R2628 avss.n1355 avss.n310 7.0005
R2629 avss.n1351 avss.n310 7.0005
R2630 avss.n1351 avss.n1350 7.0005
R2631 avss.n1350 avss.n1349 7.0005
R2632 avss.n1349 avss.n312 7.0005
R2633 avss.n1345 avss.n312 7.0005
R2634 avss.n1345 avss.n1344 7.0005
R2635 avss.n1344 avss.n1343 7.0005
R2636 avss.n1343 avss.n314 7.0005
R2637 avss.n1339 avss.n314 7.0005
R2638 avss.n1339 avss.n1338 7.0005
R2639 avss.n1338 avss.n1337 7.0005
R2640 avss.n1337 avss.n316 7.0005
R2641 avss.n1333 avss.n316 7.0005
R2642 avss.n1333 avss.n1332 7.0005
R2643 avss.n1332 avss.n1331 7.0005
R2644 avss.n1331 avss.n318 7.0005
R2645 avss.n1327 avss.n318 7.0005
R2646 avss.n1327 avss.n1326 7.0005
R2647 avss.n1326 avss.n1325 7.0005
R2648 avss.n1325 avss.n320 7.0005
R2649 avss.n1321 avss.n320 7.0005
R2650 avss.n1321 avss.n1320 7.0005
R2651 avss.n1320 avss.n1319 7.0005
R2652 avss.n1319 avss.n322 7.0005
R2653 avss.n1315 avss.n322 7.0005
R2654 avss.n1315 avss.n1314 7.0005
R2655 avss.n1314 avss.n1313 7.0005
R2656 avss.n1313 avss.n324 7.0005
R2657 avss.n1309 avss.n324 7.0005
R2658 avss.n1309 avss.n1308 7.0005
R2659 avss.n1308 avss.n1307 7.0005
R2660 avss.n1307 avss.n326 7.0005
R2661 avss.n1303 avss.n326 7.0005
R2662 avss.n1303 avss.n1302 7.0005
R2663 avss.n1302 avss.n1301 7.0005
R2664 avss.n1301 avss.n328 7.0005
R2665 avss.n1297 avss.n328 7.0005
R2666 avss.n1297 avss.n1296 7.0005
R2667 avss.n1296 avss.n1295 7.0005
R2668 avss.n1295 avss.n330 7.0005
R2669 avss.n1291 avss.n330 7.0005
R2670 avss.n1291 avss.n1290 7.0005
R2671 avss.n1290 avss.n1289 7.0005
R2672 avss.n1289 avss.n332 7.0005
R2673 avss.n1285 avss.n332 7.0005
R2674 avss.n1285 avss.n1284 7.0005
R2675 avss.n1284 avss.n1283 7.0005
R2676 avss.n1283 avss.n334 7.0005
R2677 avss.n1279 avss.n334 7.0005
R2678 avss.n1279 avss.n1278 7.0005
R2679 avss.n1278 avss.n1277 7.0005
R2680 avss.n1277 avss.n336 7.0005
R2681 avss.n1273 avss.n336 7.0005
R2682 avss.n1273 avss.n1272 7.0005
R2683 avss.n1272 avss.n1271 7.0005
R2684 avss.n1271 avss.n338 7.0005
R2685 avss.n1267 avss.n338 7.0005
R2686 avss.n1267 avss.n1266 7.0005
R2687 avss.n1266 avss.n1265 7.0005
R2688 avss.n1265 avss.n340 7.0005
R2689 avss.n1261 avss.n340 7.0005
R2690 avss.n1261 avss.n1260 7.0005
R2691 avss.n1260 avss.n1259 7.0005
R2692 avss.n1259 avss.n342 7.0005
R2693 avss.n1255 avss.n342 7.0005
R2694 avss.n1255 avss.n1254 7.0005
R2695 avss.n1254 avss.n1253 7.0005
R2696 avss.n1253 avss.n344 7.0005
R2697 avss.n1249 avss.n344 7.0005
R2698 avss.n1249 avss.n1248 7.0005
R2699 avss.n1248 avss.n1247 7.0005
R2700 avss.n1247 avss.n346 7.0005
R2701 avss.n1243 avss.n346 7.0005
R2702 avss.n1243 avss.n1242 7.0005
R2703 avss.n1242 avss.n1241 7.0005
R2704 avss.n1241 avss.n348 7.0005
R2705 avss.n1237 avss.n348 7.0005
R2706 avss.n1237 avss.n1236 7.0005
R2707 avss.n1236 avss.n1235 7.0005
R2708 avss.n1235 avss.n350 7.0005
R2709 avss.n1231 avss.n350 7.0005
R2710 avss.n1231 avss.n1230 7.0005
R2711 avss.n1230 avss.n1229 7.0005
R2712 avss.n1229 avss.n352 7.0005
R2713 avss.n1225 avss.n352 7.0005
R2714 avss.n1225 avss.n1224 7.0005
R2715 avss.n1224 avss.n1223 7.0005
R2716 avss.n1223 avss.n354 7.0005
R2717 avss.n1219 avss.n354 7.0005
R2718 avss.n1219 avss.n1218 7.0005
R2719 avss.n1218 avss.n1217 7.0005
R2720 avss.n1217 avss.n356 7.0005
R2721 avss.n1213 avss.n356 7.0005
R2722 avss.n1213 avss.n1212 7.0005
R2723 avss.n1212 avss.n1211 7.0005
R2724 avss.n1211 avss.n358 7.0005
R2725 avss.n1207 avss.n358 7.0005
R2726 avss.n1207 avss.n1206 7.0005
R2727 avss.n1206 avss.n1205 7.0005
R2728 avss.n1205 avss.n360 7.0005
R2729 avss.n1201 avss.n360 7.0005
R2730 avss.n1201 avss.n1200 7.0005
R2731 avss.n1200 avss.n1199 7.0005
R2732 avss.n1199 avss.n362 7.0005
R2733 avss.n1195 avss.n362 7.0005
R2734 avss.n1195 avss.n1194 7.0005
R2735 avss.n1194 avss.n1193 7.0005
R2736 avss.n1193 avss.n364 7.0005
R2737 avss.n1189 avss.n364 7.0005
R2738 avss.n1189 avss.n1188 7.0005
R2739 avss.n1188 avss.n1187 7.0005
R2740 avss.n1187 avss.n366 7.0005
R2741 avss.n1183 avss.n366 7.0005
R2742 avss.n1183 avss.n1182 7.0005
R2743 avss.n1182 avss.n1181 7.0005
R2744 avss.n1181 avss.n368 7.0005
R2745 avss.n1177 avss.n368 7.0005
R2746 avss.n1177 avss.n1176 7.0005
R2747 avss.n1176 avss.n1175 7.0005
R2748 avss.n1175 avss.n370 7.0005
R2749 avss.n1171 avss.n370 7.0005
R2750 avss.n1171 avss.n1170 7.0005
R2751 avss.n1170 avss.n1169 7.0005
R2752 avss.n1169 avss.n372 7.0005
R2753 avss.n1165 avss.n372 7.0005
R2754 avss.n1165 avss.n1164 7.0005
R2755 avss.n1164 avss.n1163 7.0005
R2756 avss.n1163 avss.n374 7.0005
R2757 avss.n1159 avss.n374 7.0005
R2758 avss.n1159 avss.n1158 7.0005
R2759 avss.n1158 avss.n1157 7.0005
R2760 avss.n1157 avss.n376 7.0005
R2761 avss.n1153 avss.n376 7.0005
R2762 avss.n1153 avss.n1152 7.0005
R2763 avss.n1152 avss.n1151 7.0005
R2764 avss.n1151 avss.n378 7.0005
R2765 avss.n1147 avss.n378 7.0005
R2766 avss.n1147 avss.n1146 7.0005
R2767 avss.n1146 avss.n1145 7.0005
R2768 avss.n1145 avss.n380 7.0005
R2769 avss.n1141 avss.n380 7.0005
R2770 avss.n1141 avss.n1140 7.0005
R2771 avss.n1140 avss.n1139 7.0005
R2772 avss.n1139 avss.n382 7.0005
R2773 avss.n1135 avss.n382 7.0005
R2774 avss.n1135 avss.n1134 7.0005
R2775 avss.n1134 avss.n1133 7.0005
R2776 avss.n1133 avss.n384 7.0005
R2777 avss.n1129 avss.n384 7.0005
R2778 avss.n1129 avss.n1128 7.0005
R2779 avss.n1128 avss.n1127 7.0005
R2780 avss.n1127 avss.n386 7.0005
R2781 avss.n1123 avss.n386 7.0005
R2782 avss.n1123 avss.n1122 7.0005
R2783 avss.n1122 avss.n1121 7.0005
R2784 avss.n1121 avss.n388 7.0005
R2785 avss.n1117 avss.n388 7.0005
R2786 avss.n1117 avss.n1116 7.0005
R2787 avss.n1116 avss.n1115 7.0005
R2788 avss.n1115 avss.n390 7.0005
R2789 avss.n1111 avss.n390 7.0005
R2790 avss.n1111 avss.n1110 7.0005
R2791 avss.n1110 avss.n1109 7.0005
R2792 avss.n1109 avss.n392 7.0005
R2793 avss.n1105 avss.n392 7.0005
R2794 avss.n1105 avss.n1104 7.0005
R2795 avss.n1104 avss.n1103 7.0005
R2796 avss.n1103 avss.n394 7.0005
R2797 avss.n1099 avss.n394 7.0005
R2798 avss.n1099 avss.n1098 7.0005
R2799 avss.n1098 avss.n1097 7.0005
R2800 avss.n101 avss.n100 6.8405
R2801 avss.n1707 avss.n1706 6.7955
R2802 avss.n1644 avss.n1643 6.75078
R2803 avss.n1673 avss.n1664 6.7055
R2804 avss.n1662 avss.n1653 6.6605
R2805 avss.n79 avss.n69 6.571
R2806 avss.n1685 avss.t42 6.49783
R2807 avss.n1701 avss.t36 6.49783
R2808 avss.n1703 avss.t33 6.49783
R2809 avss.n1687 avss.t39 6.49783
R2810 avss.n1690 avss.t54 6.49739
R2811 avss.n1711 avss.t45 6.49739
R2812 avss.n1693 avss.t138 6.49739
R2813 avss.n1695 avss.t135 6.49739
R2814 avss.n1697 avss.t132 6.49739
R2815 avss.n1714 avss.t129 6.49739
R2816 avss.n1712 avss.n1709 6.3905
R2817 avss.n39 avss.n1808 6.30208
R2818 avss.n1691 avss.n1690 5.91493
R2819 avss.n1712 avss.n1711 5.91493
R2820 avss.n1717 avss.n1693 5.91493
R2821 avss.n1716 avss.n1695 5.91493
R2822 avss.n1698 avss.n1697 5.91493
R2823 avss.n1715 avss.n1714 5.91493
R2824 avss.n1806 avss.n114 5.87242
R2825 avss.n1805 avss.n1804 5.87092
R2826 avss.n133 avss.n132 5.87092
R2827 avss.n121 avss.n120 5.87092
R2828 avss.n124 avss.n123 5.87092
R2829 avss.n127 avss.n126 5.87092
R2830 avss.n130 avss.n129 5.87092
R2831 avss.n53 avss.n116 5.87092
R2832 avss.n1802 avss.n140 5.87092
R2833 avss.n138 avss.n137 5.87092
R2834 avss.n143 avss.n142 5.87092
R2835 avss.n1799 avss.n1798 5.87092
R2836 avss.n1800 avss.n1796 5.87092
R2837 avss.n1754 avss.n1753 5.85717
R2838 avss.n48 avss.n145 6.64749
R2839 avss.n1763 avss.n1762 5.85717
R2840 avss.n1766 avss.n1765 5.85717
R2841 avss.n1769 avss.n1768 5.85717
R2842 avss.n1772 avss.n1771 5.85717
R2843 avss.n1750 avss.n1749 5.85717
R2844 avss.n1747 avss.n152 5.85717
R2845 avss.n150 avss.n149 5.85717
R2846 avss.n1808 avss.n109 5.84065
R2847 avss.n1789 avss.n1786 5.84065
R2848 avss.n1097 avss.n396 5.83383
R2849 avss.n8 avss.n199 6.84668
R2850 avss.n1726 avss.n1725 5.83375
R2851 avss.n1737 avss.n1736 5.83375
R2852 avss.n33 avss.n1739 6.8651
R2853 avss.n181 avss.n180 5.83375
R2854 avss.n178 avss.n177 5.83375
R2855 avss.n175 avss.n174 5.83375
R2856 avss.n172 avss.n171 5.83375
R2857 avss.n169 avss.n168 5.83375
R2858 avss.n166 avss.n165 5.83375
R2859 avss.n162 avss.n161 5.83375
R2860 avss.n202 avss.n201 5.83375
R2861 avss.n205 avss.n204 5.83375
R2862 avss.n214 avss.n207 5.83375
R2863 avss.n213 avss.n209 5.83375
R2864 avss.n212 avss.n211 5.83375
R2865 avss.n17 avss.n195 5.83375
R2866 avss.n44 avss.n1721 5.83375
R2867 avss.n1777 avss.n1776 5.83165
R2868 avss.n1780 avss.n1779 5.83165
R2869 avss.n41 avss.n1782 5.83165
R2870 avss.n112 avss.n111 5.83165
R2871 avss.n1718 avss.n1685 5.82266
R2872 avss.n1705 avss.n1701 5.82266
R2873 avss.n1704 avss.n1703 5.82266
R2874 avss.n1688 avss.n1687 5.82266
R2875 avss.n1622 avss.n1621 5.2005
R2876 avss.n1620 avss.n220 5.2005
R2877 avss.n1619 avss.n1618 5.2005
R2878 avss.n1617 avss.n222 5.2005
R2879 avss.n1616 avss.n1615 5.2005
R2880 avss.n1614 avss.n223 5.2005
R2881 avss.n1613 avss.n1612 5.2005
R2882 avss.n1611 avss.n224 5.2005
R2883 avss.n1610 avss.n1609 5.2005
R2884 avss.n1608 avss.n225 5.2005
R2885 avss.n1607 avss.n1606 5.2005
R2886 avss.n1605 avss.n226 5.2005
R2887 avss.n1604 avss.n1603 5.2005
R2888 avss.n1602 avss.n227 5.2005
R2889 avss.n1601 avss.n1600 5.2005
R2890 avss.n1599 avss.n228 5.2005
R2891 avss.n1598 avss.n1597 5.2005
R2892 avss.n1596 avss.n229 5.2005
R2893 avss.n1595 avss.n1594 5.2005
R2894 avss.n1593 avss.n230 5.2005
R2895 avss.n1592 avss.n1591 5.2005
R2896 avss.n1590 avss.n231 5.2005
R2897 avss.n1589 avss.n1588 5.2005
R2898 avss.n1587 avss.n232 5.2005
R2899 avss.n1586 avss.n1585 5.2005
R2900 avss.n1584 avss.n233 5.2005
R2901 avss.n1583 avss.n1582 5.2005
R2902 avss.n1581 avss.n234 5.2005
R2903 avss.n1580 avss.n1579 5.2005
R2904 avss.n1578 avss.n235 5.2005
R2905 avss.n1577 avss.n1576 5.2005
R2906 avss.n1575 avss.n236 5.2005
R2907 avss.n1574 avss.n1573 5.2005
R2908 avss.n1572 avss.n237 5.2005
R2909 avss.n1571 avss.n1570 5.2005
R2910 avss.n1569 avss.n238 5.2005
R2911 avss.n1568 avss.n1567 5.2005
R2912 avss.n1566 avss.n239 5.2005
R2913 avss.n1565 avss.n1564 5.2005
R2914 avss.n1563 avss.n240 5.2005
R2915 avss.n1562 avss.n1561 5.2005
R2916 avss.n1560 avss.n241 5.2005
R2917 avss.n1559 avss.n1558 5.2005
R2918 avss.n1557 avss.n242 5.2005
R2919 avss.n1556 avss.n1555 5.2005
R2920 avss.n1554 avss.n243 5.2005
R2921 avss.n1553 avss.n1552 5.2005
R2922 avss.n1551 avss.n244 5.2005
R2923 avss.n1550 avss.n1549 5.2005
R2924 avss.n1548 avss.n245 5.2005
R2925 avss.n1547 avss.n1546 5.2005
R2926 avss.n1545 avss.n246 5.2005
R2927 avss.n1544 avss.n1543 5.2005
R2928 avss.n1542 avss.n247 5.2005
R2929 avss.n1541 avss.n1540 5.2005
R2930 avss.n1539 avss.n248 5.2005
R2931 avss.n1538 avss.n1537 5.2005
R2932 avss.n1536 avss.n249 5.2005
R2933 avss.n1535 avss.n1534 5.2005
R2934 avss.n1533 avss.n250 5.2005
R2935 avss.n1532 avss.n1531 5.2005
R2936 avss.n1530 avss.n251 5.2005
R2937 avss.n1529 avss.n1528 5.2005
R2938 avss.n1527 avss.n252 5.2005
R2939 avss.n1526 avss.n1525 5.2005
R2940 avss.n1524 avss.n253 5.2005
R2941 avss.n1523 avss.n1522 5.2005
R2942 avss.n1521 avss.n254 5.2005
R2943 avss.n1520 avss.n1519 5.2005
R2944 avss.n1518 avss.n255 5.2005
R2945 avss.n1517 avss.n1516 5.2005
R2946 avss.n1515 avss.n256 5.2005
R2947 avss.n1514 avss.n1513 5.2005
R2948 avss.n1512 avss.n257 5.2005
R2949 avss.n1511 avss.n1510 5.2005
R2950 avss.n1509 avss.n258 5.2005
R2951 avss.n1508 avss.n1507 5.2005
R2952 avss.n1506 avss.n259 5.2005
R2953 avss.n1505 avss.n1504 5.2005
R2954 avss.n1503 avss.n260 5.2005
R2955 avss.n1502 avss.n1501 5.2005
R2956 avss.n1500 avss.n261 5.2005
R2957 avss.n1499 avss.n1498 5.2005
R2958 avss.n1497 avss.n262 5.2005
R2959 avss.n1496 avss.n1495 5.2005
R2960 avss.n1494 avss.n263 5.2005
R2961 avss.n1493 avss.n1492 5.2005
R2962 avss.n1491 avss.n264 5.2005
R2963 avss.n1490 avss.n1489 5.2005
R2964 avss.n1488 avss.n265 5.2005
R2965 avss.n1487 avss.n1486 5.2005
R2966 avss.n1485 avss.n266 5.2005
R2967 avss.n1484 avss.n1483 5.2005
R2968 avss.n1482 avss.n267 5.2005
R2969 avss.n1481 avss.n1480 5.2005
R2970 avss.n1479 avss.n268 5.2005
R2971 avss.n1478 avss.n1477 5.2005
R2972 avss.n1476 avss.n269 5.2005
R2973 avss.n1475 avss.n1474 5.2005
R2974 avss.n1473 avss.n270 5.2005
R2975 avss.n1472 avss.n1471 5.2005
R2976 avss.n1470 avss.n271 5.2005
R2977 avss.n1469 avss.n1468 5.2005
R2978 avss.n1097 avss.n1096 5.2005
R2979 avss.n1098 avss.n395 5.2005
R2980 avss.n1100 avss.n1099 5.2005
R2981 avss.n1101 avss.n394 5.2005
R2982 avss.n1103 avss.n1102 5.2005
R2983 avss.n1104 avss.n393 5.2005
R2984 avss.n1106 avss.n1105 5.2005
R2985 avss.n1107 avss.n392 5.2005
R2986 avss.n1109 avss.n1108 5.2005
R2987 avss.n1110 avss.n391 5.2005
R2988 avss.n1112 avss.n1111 5.2005
R2989 avss.n1113 avss.n390 5.2005
R2990 avss.n1115 avss.n1114 5.2005
R2991 avss.n1116 avss.n389 5.2005
R2992 avss.n1118 avss.n1117 5.2005
R2993 avss.n1119 avss.n388 5.2005
R2994 avss.n1121 avss.n1120 5.2005
R2995 avss.n1122 avss.n387 5.2005
R2996 avss.n1124 avss.n1123 5.2005
R2997 avss.n1125 avss.n386 5.2005
R2998 avss.n1127 avss.n1126 5.2005
R2999 avss.n1128 avss.n385 5.2005
R3000 avss.n1130 avss.n1129 5.2005
R3001 avss.n1131 avss.n384 5.2005
R3002 avss.n1133 avss.n1132 5.2005
R3003 avss.n1134 avss.n383 5.2005
R3004 avss.n1136 avss.n1135 5.2005
R3005 avss.n1137 avss.n382 5.2005
R3006 avss.n1139 avss.n1138 5.2005
R3007 avss.n1140 avss.n381 5.2005
R3008 avss.n1142 avss.n1141 5.2005
R3009 avss.n1143 avss.n380 5.2005
R3010 avss.n1145 avss.n1144 5.2005
R3011 avss.n1146 avss.n379 5.2005
R3012 avss.n1148 avss.n1147 5.2005
R3013 avss.n1149 avss.n378 5.2005
R3014 avss.n1151 avss.n1150 5.2005
R3015 avss.n1152 avss.n377 5.2005
R3016 avss.n1154 avss.n1153 5.2005
R3017 avss.n1155 avss.n376 5.2005
R3018 avss.n1157 avss.n1156 5.2005
R3019 avss.n1158 avss.n375 5.2005
R3020 avss.n1160 avss.n1159 5.2005
R3021 avss.n1161 avss.n374 5.2005
R3022 avss.n1163 avss.n1162 5.2005
R3023 avss.n1164 avss.n373 5.2005
R3024 avss.n1166 avss.n1165 5.2005
R3025 avss.n1167 avss.n372 5.2005
R3026 avss.n1169 avss.n1168 5.2005
R3027 avss.n1170 avss.n371 5.2005
R3028 avss.n1172 avss.n1171 5.2005
R3029 avss.n1173 avss.n370 5.2005
R3030 avss.n1175 avss.n1174 5.2005
R3031 avss.n1176 avss.n369 5.2005
R3032 avss.n1178 avss.n1177 5.2005
R3033 avss.n1179 avss.n368 5.2005
R3034 avss.n1181 avss.n1180 5.2005
R3035 avss.n1182 avss.n367 5.2005
R3036 avss.n1184 avss.n1183 5.2005
R3037 avss.n1185 avss.n366 5.2005
R3038 avss.n1187 avss.n1186 5.2005
R3039 avss.n1188 avss.n365 5.2005
R3040 avss.n1190 avss.n1189 5.2005
R3041 avss.n1191 avss.n364 5.2005
R3042 avss.n1193 avss.n1192 5.2005
R3043 avss.n1194 avss.n363 5.2005
R3044 avss.n1196 avss.n1195 5.2005
R3045 avss.n1197 avss.n362 5.2005
R3046 avss.n1199 avss.n1198 5.2005
R3047 avss.n1200 avss.n361 5.2005
R3048 avss.n1202 avss.n1201 5.2005
R3049 avss.n1203 avss.n360 5.2005
R3050 avss.n1205 avss.n1204 5.2005
R3051 avss.n1206 avss.n359 5.2005
R3052 avss.n1208 avss.n1207 5.2005
R3053 avss.n1209 avss.n358 5.2005
R3054 avss.n1211 avss.n1210 5.2005
R3055 avss.n1212 avss.n357 5.2005
R3056 avss.n1214 avss.n1213 5.2005
R3057 avss.n1215 avss.n356 5.2005
R3058 avss.n1217 avss.n1216 5.2005
R3059 avss.n1218 avss.n355 5.2005
R3060 avss.n1220 avss.n1219 5.2005
R3061 avss.n1221 avss.n354 5.2005
R3062 avss.n1223 avss.n1222 5.2005
R3063 avss.n1224 avss.n353 5.2005
R3064 avss.n1226 avss.n1225 5.2005
R3065 avss.n1227 avss.n352 5.2005
R3066 avss.n1229 avss.n1228 5.2005
R3067 avss.n1230 avss.n351 5.2005
R3068 avss.n1232 avss.n1231 5.2005
R3069 avss.n1233 avss.n350 5.2005
R3070 avss.n1235 avss.n1234 5.2005
R3071 avss.n1236 avss.n349 5.2005
R3072 avss.n1238 avss.n1237 5.2005
R3073 avss.n1239 avss.n348 5.2005
R3074 avss.n1241 avss.n1240 5.2005
R3075 avss.n1242 avss.n347 5.2005
R3076 avss.n1244 avss.n1243 5.2005
R3077 avss.n1245 avss.n346 5.2005
R3078 avss.n1247 avss.n1246 5.2005
R3079 avss.n1248 avss.n345 5.2005
R3080 avss.n1250 avss.n1249 5.2005
R3081 avss.n1251 avss.n344 5.2005
R3082 avss.n1253 avss.n1252 5.2005
R3083 avss.n1254 avss.n343 5.2005
R3084 avss.n1256 avss.n1255 5.2005
R3085 avss.n1257 avss.n342 5.2005
R3086 avss.n1259 avss.n1258 5.2005
R3087 avss.n1260 avss.n341 5.2005
R3088 avss.n1262 avss.n1261 5.2005
R3089 avss.n1263 avss.n340 5.2005
R3090 avss.n1265 avss.n1264 5.2005
R3091 avss.n1266 avss.n339 5.2005
R3092 avss.n1268 avss.n1267 5.2005
R3093 avss.n1269 avss.n338 5.2005
R3094 avss.n1271 avss.n1270 5.2005
R3095 avss.n1272 avss.n337 5.2005
R3096 avss.n1274 avss.n1273 5.2005
R3097 avss.n1275 avss.n336 5.2005
R3098 avss.n1277 avss.n1276 5.2005
R3099 avss.n1278 avss.n335 5.2005
R3100 avss.n1280 avss.n1279 5.2005
R3101 avss.n1281 avss.n334 5.2005
R3102 avss.n1283 avss.n1282 5.2005
R3103 avss.n1284 avss.n333 5.2005
R3104 avss.n1286 avss.n1285 5.2005
R3105 avss.n1287 avss.n332 5.2005
R3106 avss.n1289 avss.n1288 5.2005
R3107 avss.n1290 avss.n331 5.2005
R3108 avss.n1292 avss.n1291 5.2005
R3109 avss.n1293 avss.n330 5.2005
R3110 avss.n1295 avss.n1294 5.2005
R3111 avss.n1296 avss.n329 5.2005
R3112 avss.n1298 avss.n1297 5.2005
R3113 avss.n1299 avss.n328 5.2005
R3114 avss.n1301 avss.n1300 5.2005
R3115 avss.n1302 avss.n327 5.2005
R3116 avss.n1304 avss.n1303 5.2005
R3117 avss.n1305 avss.n326 5.2005
R3118 avss.n1307 avss.n1306 5.2005
R3119 avss.n1308 avss.n325 5.2005
R3120 avss.n1310 avss.n1309 5.2005
R3121 avss.n1311 avss.n324 5.2005
R3122 avss.n1313 avss.n1312 5.2005
R3123 avss.n1314 avss.n323 5.2005
R3124 avss.n1316 avss.n1315 5.2005
R3125 avss.n1317 avss.n322 5.2005
R3126 avss.n1319 avss.n1318 5.2005
R3127 avss.n1320 avss.n321 5.2005
R3128 avss.n1322 avss.n1321 5.2005
R3129 avss.n1323 avss.n320 5.2005
R3130 avss.n1325 avss.n1324 5.2005
R3131 avss.n1326 avss.n319 5.2005
R3132 avss.n1328 avss.n1327 5.2005
R3133 avss.n1329 avss.n318 5.2005
R3134 avss.n1331 avss.n1330 5.2005
R3135 avss.n1332 avss.n317 5.2005
R3136 avss.n1334 avss.n1333 5.2005
R3137 avss.n1335 avss.n316 5.2005
R3138 avss.n1337 avss.n1336 5.2005
R3139 avss.n1338 avss.n315 5.2005
R3140 avss.n1340 avss.n1339 5.2005
R3141 avss.n1341 avss.n314 5.2005
R3142 avss.n1343 avss.n1342 5.2005
R3143 avss.n1344 avss.n313 5.2005
R3144 avss.n1346 avss.n1345 5.2005
R3145 avss.n1347 avss.n312 5.2005
R3146 avss.n1349 avss.n1348 5.2005
R3147 avss.n1350 avss.n311 5.2005
R3148 avss.n1352 avss.n1351 5.2005
R3149 avss.n1353 avss.n310 5.2005
R3150 avss.n1355 avss.n1354 5.2005
R3151 avss.n1356 avss.n309 5.2005
R3152 avss.n1358 avss.n1357 5.2005
R3153 avss.n1359 avss.n308 5.2005
R3154 avss.n1361 avss.n1360 5.2005
R3155 avss.n1362 avss.n307 5.2005
R3156 avss.n1364 avss.n1363 5.2005
R3157 avss.n1365 avss.n306 5.2005
R3158 avss.n1367 avss.n1366 5.2005
R3159 avss.n1368 avss.n305 5.2005
R3160 avss.n1370 avss.n1369 5.2005
R3161 avss.n1371 avss.n304 5.2005
R3162 avss.n1373 avss.n1372 5.2005
R3163 avss.n1374 avss.n303 5.2005
R3164 avss.n1376 avss.n1375 5.2005
R3165 avss.n1377 avss.n302 5.2005
R3166 avss.n1379 avss.n1378 5.2005
R3167 avss.n1380 avss.n301 5.2005
R3168 avss.n1382 avss.n1381 5.2005
R3169 avss.n1383 avss.n300 5.2005
R3170 avss.n1385 avss.n1384 5.2005
R3171 avss.n1386 avss.n299 5.2005
R3172 avss.n1388 avss.n1387 5.2005
R3173 avss.n1389 avss.n298 5.2005
R3174 avss.n1391 avss.n1390 5.2005
R3175 avss.n1392 avss.n297 5.2005
R3176 avss.n1394 avss.n1393 5.2005
R3177 avss.n1395 avss.n296 5.2005
R3178 avss.n1397 avss.n1396 5.2005
R3179 avss.n1398 avss.n295 5.2005
R3180 avss.n1400 avss.n1399 5.2005
R3181 avss.n1401 avss.n294 5.2005
R3182 avss.n1403 avss.n1402 5.2005
R3183 avss.n1404 avss.n293 5.2005
R3184 avss.n1406 avss.n1405 5.2005
R3185 avss.n1407 avss.n292 5.2005
R3186 avss.n1409 avss.n1408 5.2005
R3187 avss.n1410 avss.n291 5.2005
R3188 avss.n1412 avss.n1411 5.2005
R3189 avss.n1413 avss.n290 5.2005
R3190 avss.n1415 avss.n1414 5.2005
R3191 avss.n1416 avss.n289 5.2005
R3192 avss.n1418 avss.n1417 5.2005
R3193 avss.n1419 avss.n288 5.2005
R3194 avss.n1421 avss.n1420 5.2005
R3195 avss.n1422 avss.n287 5.2005
R3196 avss.n1424 avss.n1423 5.2005
R3197 avss.n1425 avss.n286 5.2005
R3198 avss.n1427 avss.n1426 5.2005
R3199 avss.n1428 avss.n285 5.2005
R3200 avss.n1430 avss.n1429 5.2005
R3201 avss.n1431 avss.n284 5.2005
R3202 avss.n1433 avss.n1432 5.2005
R3203 avss.n1434 avss.n283 5.2005
R3204 avss.n1436 avss.n1435 5.2005
R3205 avss.n1437 avss.n282 5.2005
R3206 avss.n1439 avss.n1438 5.2005
R3207 avss.n1440 avss.n281 5.2005
R3208 avss.n1442 avss.n1441 5.2005
R3209 avss.n1443 avss.n280 5.2005
R3210 avss.n1445 avss.n1444 5.2005
R3211 avss.n1446 avss.n279 5.2005
R3212 avss.n1448 avss.n1447 5.2005
R3213 avss.n1449 avss.n278 5.2005
R3214 avss.n1451 avss.n1450 5.2005
R3215 avss.n1452 avss.n277 5.2005
R3216 avss.n1454 avss.n1453 5.2005
R3217 avss.n1455 avss.n276 5.2005
R3218 avss.n1457 avss.n1456 5.2005
R3219 avss.n1458 avss.n275 5.2005
R3220 avss.n1460 avss.n1459 5.2005
R3221 avss.n1461 avss.n274 5.2005
R3222 avss.n1463 avss.n1462 5.2005
R3223 avss.n1464 avss.n273 5.2005
R3224 avss.n1466 avss.n1465 5.2005
R3225 avss.n1467 avss.n272 5.2005
R3226 avss.n1095 avss.n396 5.2005
R3227 avss.n1094 avss.n1093 5.2005
R3228 avss.n1092 avss.n397 5.2005
R3229 avss.n1091 avss.n1090 5.2005
R3230 avss.n1089 avss.n398 5.2005
R3231 avss.n1088 avss.n1087 5.2005
R3232 avss.n1086 avss.n399 5.2005
R3233 avss.n1085 avss.n1084 5.2005
R3234 avss.n1083 avss.n400 5.2005
R3235 avss.n1082 avss.n1081 5.2005
R3236 avss.n1080 avss.n401 5.2005
R3237 avss.n1079 avss.n1078 5.2005
R3238 avss.n1077 avss.n402 5.2005
R3239 avss.n1076 avss.n1075 5.2005
R3240 avss.n1074 avss.n403 5.2005
R3241 avss.n1073 avss.n1072 5.2005
R3242 avss.n1071 avss.n404 5.2005
R3243 avss.n1070 avss.n1069 5.2005
R3244 avss.n1068 avss.n405 5.2005
R3245 avss.n1067 avss.n1066 5.2005
R3246 avss.n1065 avss.n406 5.2005
R3247 avss.n1064 avss.n1063 5.2005
R3248 avss.n1062 avss.n407 5.2005
R3249 avss.n1061 avss.n1060 5.2005
R3250 avss.n1059 avss.n408 5.2005
R3251 avss.n1058 avss.n1057 5.2005
R3252 avss.n1056 avss.n409 5.2005
R3253 avss.n1055 avss.n1054 5.2005
R3254 avss.n1053 avss.n410 5.2005
R3255 avss.n1052 avss.n1051 5.2005
R3256 avss.n1050 avss.n411 5.2005
R3257 avss.n1049 avss.n1048 5.2005
R3258 avss.n1047 avss.n412 5.2005
R3259 avss.n1046 avss.n1045 5.2005
R3260 avss.n1044 avss.n413 5.2005
R3261 avss.n1043 avss.n1042 5.2005
R3262 avss.n1041 avss.n414 5.2005
R3263 avss.n1040 avss.n1039 5.2005
R3264 avss.n1038 avss.n415 5.2005
R3265 avss.n1037 avss.n1036 5.2005
R3266 avss.n1035 avss.n416 5.2005
R3267 avss.n1034 avss.n1033 5.2005
R3268 avss.n1032 avss.n417 5.2005
R3269 avss.n1031 avss.n1030 5.2005
R3270 avss.n1029 avss.n418 5.2005
R3271 avss.n1028 avss.n1027 5.2005
R3272 avss.n1026 avss.n419 5.2005
R3273 avss.n1025 avss.n1024 5.2005
R3274 avss.n1023 avss.n420 5.2005
R3275 avss.n1022 avss.n1021 5.2005
R3276 avss.n1020 avss.n421 5.2005
R3277 avss.n1019 avss.n1018 5.2005
R3278 avss.n1017 avss.n422 5.2005
R3279 avss.n1016 avss.n1015 5.2005
R3280 avss.n1014 avss.n423 5.2005
R3281 avss.n1013 avss.n1012 5.2005
R3282 avss.n1011 avss.n424 5.2005
R3283 avss.n1010 avss.n1009 5.2005
R3284 avss.n1008 avss.n425 5.2005
R3285 avss.n1007 avss.n1006 5.2005
R3286 avss.n1005 avss.n426 5.2005
R3287 avss.n1004 avss.n1003 5.2005
R3288 avss.n1002 avss.n427 5.2005
R3289 avss.n1001 avss.n1000 5.2005
R3290 avss.n999 avss.n428 5.2005
R3291 avss.n998 avss.n997 5.2005
R3292 avss.n996 avss.n429 5.2005
R3293 avss.n995 avss.n994 5.2005
R3294 avss.n993 avss.n430 5.2005
R3295 avss.n992 avss.n991 5.2005
R3296 avss.n990 avss.n431 5.2005
R3297 avss.n989 avss.n988 5.2005
R3298 avss.n987 avss.n432 5.2005
R3299 avss.n986 avss.n985 5.2005
R3300 avss.n984 avss.n433 5.2005
R3301 avss.n983 avss.n982 5.2005
R3302 avss.n981 avss.n434 5.2005
R3303 avss.n980 avss.n979 5.2005
R3304 avss.n978 avss.n435 5.2005
R3305 avss.n977 avss.n976 5.2005
R3306 avss.n975 avss.n436 5.2005
R3307 avss.n974 avss.n973 5.2005
R3308 avss.n972 avss.n437 5.2005
R3309 avss.n971 avss.n970 5.2005
R3310 avss.n969 avss.n438 5.2005
R3311 avss.n968 avss.n967 5.2005
R3312 avss.n966 avss.n439 5.2005
R3313 avss.n965 avss.n964 5.2005
R3314 avss.n963 avss.n440 5.2005
R3315 avss.n962 avss.n961 5.2005
R3316 avss.n960 avss.n441 5.2005
R3317 avss.n959 avss.n958 5.2005
R3318 avss.n957 avss.n442 5.2005
R3319 avss.n956 avss.n955 5.2005
R3320 avss.n954 avss.n443 5.2005
R3321 avss.n953 avss.n952 5.2005
R3322 avss.n951 avss.n444 5.2005
R3323 avss.n950 avss.n949 5.2005
R3324 avss.n948 avss.n445 5.2005
R3325 avss.n947 avss.n946 5.2005
R3326 avss.n945 avss.n446 5.2005
R3327 avss.n944 avss.n943 5.2005
R3328 avss.n942 avss.n447 5.2005
R3329 avss.n221 avss.n219 5.2005
R3330 avss.n572 avss.n571 5.2005
R3331 avss.n573 avss.n570 5.2005
R3332 avss.n575 avss.n574 5.2005
R3333 avss.n576 avss.n569 5.2005
R3334 avss.n578 avss.n577 5.2005
R3335 avss.n579 avss.n568 5.2005
R3336 avss.n581 avss.n580 5.2005
R3337 avss.n582 avss.n567 5.2005
R3338 avss.n584 avss.n583 5.2005
R3339 avss.n585 avss.n566 5.2005
R3340 avss.n587 avss.n586 5.2005
R3341 avss.n588 avss.n565 5.2005
R3342 avss.n590 avss.n589 5.2005
R3343 avss.n591 avss.n564 5.2005
R3344 avss.n593 avss.n592 5.2005
R3345 avss.n594 avss.n563 5.2005
R3346 avss.n596 avss.n595 5.2005
R3347 avss.n597 avss.n562 5.2005
R3348 avss.n599 avss.n598 5.2005
R3349 avss.n600 avss.n561 5.2005
R3350 avss.n602 avss.n601 5.2005
R3351 avss.n603 avss.n560 5.2005
R3352 avss.n605 avss.n604 5.2005
R3353 avss.n606 avss.n559 5.2005
R3354 avss.n608 avss.n607 5.2005
R3355 avss.n609 avss.n558 5.2005
R3356 avss.n611 avss.n610 5.2005
R3357 avss.n612 avss.n557 5.2005
R3358 avss.n614 avss.n613 5.2005
R3359 avss.n615 avss.n556 5.2005
R3360 avss.n617 avss.n616 5.2005
R3361 avss.n618 avss.n555 5.2005
R3362 avss.n620 avss.n619 5.2005
R3363 avss.n621 avss.n554 5.2005
R3364 avss.n623 avss.n622 5.2005
R3365 avss.n624 avss.n553 5.2005
R3366 avss.n626 avss.n625 5.2005
R3367 avss.n627 avss.n552 5.2005
R3368 avss.n629 avss.n628 5.2005
R3369 avss.n630 avss.n551 5.2005
R3370 avss.n632 avss.n631 5.2005
R3371 avss.n633 avss.n550 5.2005
R3372 avss.n635 avss.n634 5.2005
R3373 avss.n636 avss.n549 5.2005
R3374 avss.n638 avss.n637 5.2005
R3375 avss.n639 avss.n548 5.2005
R3376 avss.n641 avss.n640 5.2005
R3377 avss.n642 avss.n547 5.2005
R3378 avss.n644 avss.n643 5.2005
R3379 avss.n645 avss.n546 5.2005
R3380 avss.n647 avss.n646 5.2005
R3381 avss.n648 avss.n545 5.2005
R3382 avss.n650 avss.n649 5.2005
R3383 avss.n651 avss.n544 5.2005
R3384 avss.n653 avss.n652 5.2005
R3385 avss.n654 avss.n543 5.2005
R3386 avss.n656 avss.n655 5.2005
R3387 avss.n657 avss.n542 5.2005
R3388 avss.n659 avss.n658 5.2005
R3389 avss.n660 avss.n541 5.2005
R3390 avss.n662 avss.n661 5.2005
R3391 avss.n663 avss.n540 5.2005
R3392 avss.n665 avss.n664 5.2005
R3393 avss.n666 avss.n539 5.2005
R3394 avss.n668 avss.n667 5.2005
R3395 avss.n669 avss.n538 5.2005
R3396 avss.n671 avss.n670 5.2005
R3397 avss.n672 avss.n537 5.2005
R3398 avss.n674 avss.n673 5.2005
R3399 avss.n675 avss.n536 5.2005
R3400 avss.n677 avss.n676 5.2005
R3401 avss.n678 avss.n535 5.2005
R3402 avss.n680 avss.n679 5.2005
R3403 avss.n681 avss.n534 5.2005
R3404 avss.n683 avss.n682 5.2005
R3405 avss.n684 avss.n533 5.2005
R3406 avss.n686 avss.n685 5.2005
R3407 avss.n687 avss.n532 5.2005
R3408 avss.n689 avss.n688 5.2005
R3409 avss.n690 avss.n531 5.2005
R3410 avss.n692 avss.n691 5.2005
R3411 avss.n693 avss.n530 5.2005
R3412 avss.n695 avss.n694 5.2005
R3413 avss.n696 avss.n529 5.2005
R3414 avss.n698 avss.n697 5.2005
R3415 avss.n699 avss.n528 5.2005
R3416 avss.n701 avss.n700 5.2005
R3417 avss.n702 avss.n527 5.2005
R3418 avss.n704 avss.n703 5.2005
R3419 avss.n705 avss.n526 5.2005
R3420 avss.n707 avss.n706 5.2005
R3421 avss.n708 avss.n525 5.2005
R3422 avss.n710 avss.n709 5.2005
R3423 avss.n711 avss.n524 5.2005
R3424 avss.n713 avss.n712 5.2005
R3425 avss.n714 avss.n523 5.2005
R3426 avss.n716 avss.n715 5.2005
R3427 avss.n717 avss.n522 5.2005
R3428 avss.n719 avss.n718 5.2005
R3429 avss.n720 avss.n521 5.2005
R3430 avss.n722 avss.n721 5.2005
R3431 avss.n723 avss.n520 5.2005
R3432 avss.n725 avss.n724 5.2005
R3433 avss.n726 avss.n519 5.2005
R3434 avss.n728 avss.n727 5.2005
R3435 avss.n729 avss.n518 5.2005
R3436 avss.n731 avss.n730 5.2005
R3437 avss.n732 avss.n517 5.2005
R3438 avss.n734 avss.n733 5.2005
R3439 avss.n735 avss.n516 5.2005
R3440 avss.n737 avss.n736 5.2005
R3441 avss.n738 avss.n515 5.2005
R3442 avss.n740 avss.n739 5.2005
R3443 avss.n741 avss.n514 5.2005
R3444 avss.n743 avss.n742 5.2005
R3445 avss.n744 avss.n513 5.2005
R3446 avss.n746 avss.n745 5.2005
R3447 avss.n747 avss.n512 5.2005
R3448 avss.n749 avss.n748 5.2005
R3449 avss.n750 avss.n511 5.2005
R3450 avss.n752 avss.n751 5.2005
R3451 avss.n753 avss.n510 5.2005
R3452 avss.n755 avss.n754 5.2005
R3453 avss.n756 avss.n509 5.2005
R3454 avss.n758 avss.n757 5.2005
R3455 avss.n759 avss.n508 5.2005
R3456 avss.n761 avss.n760 5.2005
R3457 avss.n762 avss.n507 5.2005
R3458 avss.n764 avss.n763 5.2005
R3459 avss.n765 avss.n506 5.2005
R3460 avss.n767 avss.n766 5.2005
R3461 avss.n768 avss.n505 5.2005
R3462 avss.n770 avss.n769 5.2005
R3463 avss.n771 avss.n504 5.2005
R3464 avss.n773 avss.n772 5.2005
R3465 avss.n774 avss.n503 5.2005
R3466 avss.n776 avss.n775 5.2005
R3467 avss.n777 avss.n502 5.2005
R3468 avss.n779 avss.n778 5.2005
R3469 avss.n780 avss.n501 5.2005
R3470 avss.n782 avss.n781 5.2005
R3471 avss.n783 avss.n500 5.2005
R3472 avss.n785 avss.n784 5.2005
R3473 avss.n786 avss.n499 5.2005
R3474 avss.n788 avss.n787 5.2005
R3475 avss.n789 avss.n498 5.2005
R3476 avss.n791 avss.n790 5.2005
R3477 avss.n792 avss.n497 5.2005
R3478 avss.n794 avss.n793 5.2005
R3479 avss.n795 avss.n496 5.2005
R3480 avss.n797 avss.n796 5.2005
R3481 avss.n798 avss.n495 5.2005
R3482 avss.n800 avss.n799 5.2005
R3483 avss.n801 avss.n494 5.2005
R3484 avss.n803 avss.n802 5.2005
R3485 avss.n804 avss.n493 5.2005
R3486 avss.n806 avss.n805 5.2005
R3487 avss.n807 avss.n492 5.2005
R3488 avss.n809 avss.n808 5.2005
R3489 avss.n810 avss.n491 5.2005
R3490 avss.n812 avss.n811 5.2005
R3491 avss.n813 avss.n490 5.2005
R3492 avss.n815 avss.n814 5.2005
R3493 avss.n816 avss.n489 5.2005
R3494 avss.n818 avss.n817 5.2005
R3495 avss.n819 avss.n488 5.2005
R3496 avss.n821 avss.n820 5.2005
R3497 avss.n822 avss.n487 5.2005
R3498 avss.n824 avss.n823 5.2005
R3499 avss.n825 avss.n486 5.2005
R3500 avss.n827 avss.n826 5.2005
R3501 avss.n828 avss.n485 5.2005
R3502 avss.n830 avss.n829 5.2005
R3503 avss.n831 avss.n484 5.2005
R3504 avss.n833 avss.n832 5.2005
R3505 avss.n834 avss.n483 5.2005
R3506 avss.n836 avss.n835 5.2005
R3507 avss.n837 avss.n482 5.2005
R3508 avss.n839 avss.n838 5.2005
R3509 avss.n840 avss.n481 5.2005
R3510 avss.n842 avss.n841 5.2005
R3511 avss.n843 avss.n480 5.2005
R3512 avss.n845 avss.n844 5.2005
R3513 avss.n846 avss.n479 5.2005
R3514 avss.n848 avss.n847 5.2005
R3515 avss.n849 avss.n478 5.2005
R3516 avss.n851 avss.n850 5.2005
R3517 avss.n852 avss.n477 5.2005
R3518 avss.n854 avss.n853 5.2005
R3519 avss.n855 avss.n476 5.2005
R3520 avss.n857 avss.n856 5.2005
R3521 avss.n858 avss.n475 5.2005
R3522 avss.n860 avss.n859 5.2005
R3523 avss.n861 avss.n474 5.2005
R3524 avss.n863 avss.n862 5.2005
R3525 avss.n864 avss.n473 5.2005
R3526 avss.n866 avss.n865 5.2005
R3527 avss.n867 avss.n472 5.2005
R3528 avss.n869 avss.n868 5.2005
R3529 avss.n870 avss.n471 5.2005
R3530 avss.n872 avss.n871 5.2005
R3531 avss.n873 avss.n470 5.2005
R3532 avss.n875 avss.n874 5.2005
R3533 avss.n876 avss.n469 5.2005
R3534 avss.n878 avss.n877 5.2005
R3535 avss.n879 avss.n468 5.2005
R3536 avss.n881 avss.n880 5.2005
R3537 avss.n882 avss.n467 5.2005
R3538 avss.n884 avss.n883 5.2005
R3539 avss.n885 avss.n466 5.2005
R3540 avss.n887 avss.n886 5.2005
R3541 avss.n888 avss.n465 5.2005
R3542 avss.n890 avss.n889 5.2005
R3543 avss.n891 avss.n464 5.2005
R3544 avss.n893 avss.n892 5.2005
R3545 avss.n894 avss.n463 5.2005
R3546 avss.n896 avss.n895 5.2005
R3547 avss.n897 avss.n462 5.2005
R3548 avss.n899 avss.n898 5.2005
R3549 avss.n900 avss.n461 5.2005
R3550 avss.n902 avss.n901 5.2005
R3551 avss.n903 avss.n460 5.2005
R3552 avss.n905 avss.n904 5.2005
R3553 avss.n906 avss.n459 5.2005
R3554 avss.n908 avss.n907 5.2005
R3555 avss.n909 avss.n458 5.2005
R3556 avss.n911 avss.n910 5.2005
R3557 avss.n912 avss.n457 5.2005
R3558 avss.n914 avss.n913 5.2005
R3559 avss.n915 avss.n456 5.2005
R3560 avss.n917 avss.n916 5.2005
R3561 avss.n918 avss.n455 5.2005
R3562 avss.n920 avss.n919 5.2005
R3563 avss.n921 avss.n454 5.2005
R3564 avss.n923 avss.n922 5.2005
R3565 avss.n924 avss.n453 5.2005
R3566 avss.n926 avss.n925 5.2005
R3567 avss.n927 avss.n452 5.2005
R3568 avss.n929 avss.n928 5.2005
R3569 avss.n930 avss.n451 5.2005
R3570 avss.n932 avss.n931 5.2005
R3571 avss.n933 avss.n450 5.2005
R3572 avss.n935 avss.n934 5.2005
R3573 avss.n936 avss.n449 5.2005
R3574 avss.n938 avss.n937 5.2005
R3575 avss.n939 avss.n448 5.2005
R3576 avss.n941 avss.n940 5.2005
R3577 avss.n1732 avss.n1731 5.11483
R3578 avss.n1733 avss.n1732 5.0045
R3579 avss.n40 avss.n1756 4.98776
R3580 avss.n44 avss.n193 4.9595
R3581 avss.n134 avss.n53 4.93037
R3582 avss.n193 avss.n192 4.92541
R3583 avss.n15 avss.n21 2.06547
R3584 avss.n1802 avss.n15 4.85651
R3585 avss.n21 avss.n138 0.727985
R3586 avss.n0 avss.n33 1.89876
R3587 avss.n5 avss.n6 1.88378
R3588 avss.n1 avss.n166 4.83674
R3589 avss.n1755 avss.n1754 4.81972
R3590 avss.n1750 avss.n147 4.81972
R3591 avss.n1747 avss.n1746 4.81972
R3592 avss.n40 avss.n146 4.78385
R3593 avss.n49 avss.n1715 4.78176
R3594 avss.n8 avss.n7 1.88424
R3595 avss.n9 avss.n1704 4.76079
R3596 avss.n60 avss.n1772 4.75846
R3597 avss.n1712 avss.n1699 4.75445
R3598 avss.n3 avss.n1726 4.74977
R3599 avss.n0 avss.n1737 4.74942
R3600 avss.n59 avss.n1691 4.73146
R3601 avss.n1727 avss.n153 4.73059
R3602 avss.n183 avss.n182 4.73059
R3603 avss.n215 avss.n214 4.7093
R3604 avss.n213 avss.n24 4.74184
R3605 avss.n33 avss.n181 1.02431
R3606 avss.n34 avss.n175 1.02737
R3607 avss.n0 avss.n4 1.89001
R3608 avss.n4 avss.n169 1.02724
R3609 avss.n40 avss.n1760 4.69782
R3610 avss.n29 avss.n1688 1.03213
R3611 avss.n58 avss.n153 0.573459
R3612 avss.n1792 avss.n1791 4.6355
R3613 avss.n1673 avss 4.5905
R3614 avss.n1723 avss.n154 4.5455
R3615 avss.n1734 avss.n1733 4.5455
R3616 avss.n1820 avss.n101 4.5455
R3617 avss.n46 avss.n45 2.2418
R3618 avss.n186 avss.n185 4.50421
R3619 avss.n1730 avss.n1729 4.50421
R3620 avss.n163 avss.n162 4.5005
R3621 avss.n1722 avss.n182 4.5005
R3622 avss.n46 avss.t224 4.52152
R3623 avss.n1676 avss.n218 4.5005
R3624 avss.n38 avss.n39 2.25521
R3625 avss.n1818 avss.n101 4.5005
R3626 avss avss.n1828 4.5005
R3627 avss avss.n68 4.5005
R3628 avss avss.n77 4.5005
R3629 avss avss.n88 4.5005
R3630 avss avss.n99 4.5005
R3631 avss avss.n1632 4.5005
R3632 avss.n1663 avss.n1662 4.5005
R3633 avss.n1674 avss.n1624 4.5005
R3634 avss avss.n1672 4.5005
R3635 avss.n1662 avss 4.5005
R3636 avss avss.n1642 4.5005
R3637 avss avss.n1652 4.5005
R3638 avss avss.n1661 4.5005
R3639 avss.n1744 avss.n1743 4.4555
R3640 avss.n1814 avss.n1813 3.9155
R3641 avss.n1469 avss.n272 3.5005
R3642 avss.n1809 avss.n38 3.4985
R3643 avss avss.n16 2.73357
R3644 avss.n1709 avss.n1708 2.7005
R3645 avss.n1718 avss.n29 1.01869
R3646 avss.n6 avss.n17 1.03673
R3647 avss.n212 avss.n17 2.6105
R3648 avss.n213 avss.n212 2.6105
R3649 avss.n214 avss.n213 2.6105
R3650 avss.n214 avss.n205 2.6105
R3651 avss.n205 avss.n202 2.6105
R3652 avss.n169 avss.n166 2.6105
R3653 avss.n172 avss.n4 1.02724
R3654 avss.n175 avss.n172 2.6105
R3655 avss.n178 avss.n34 1.02713
R3656 avss.n181 avss.n178 2.6105
R3657 avss.n1716 avss.n1698 2.6105
R3658 avss.n1715 avss.n1698 2.582
R3659 avss.n1717 avss.n1716 2.582
R3660 avss.n1705 avss.n1704 2.5685
R3661 avss.n1731 avss.n166 2.5655
R3662 avss.n1807 avss.n1806 2.4755
R3663 avss.n217 avss.n104 2.4305
R3664 avss.n90 avss.n89 2.3855
R3665 avss.n1663 avss.n1634 2.3405
R3666 avss.n1759 avss.n1758 2.31944
R3667 avss.n133 avss.n52 2.29424
R3668 avss.n1760 avss.n1757 2.19639
R3669 avss.n1747 avss.n150 2.1605
R3670 avss.n1750 avss.n1747 2.1605
R3671 avss.n1769 avss.n47 0.881568
R3672 avss.n1766 avss.n1763 2.1605
R3673 avss.n79 avss.n78 1.9805
R3674 avss.n1780 avss.n1777 1.8365
R3675 avss.n41 avss.n1780 1.7105
R3676 avss.n1800 avss.n1799 1.7105
R3677 avss.n1799 avss.n143 1.7105
R3678 avss.n143 avss.n21 0.728006
R3679 avss.n1802 avss.n138 1.7105
R3680 avss.n1805 avss.n1802 1.7105
R3681 avss.n127 avss.n124 1.7105
R3682 avss.n124 avss.n121 1.7105
R3683 avss.n1706 avss.n1705 1.7105
R3684 avss.n1719 avss.n1683 1.6655
R3685 avss.n1708 avss.n1707 1.5755
R3686 avss.n1791 avss.n1790 1.5755
R3687 avss.n1828 avss.n1827 1.57121
R3688 avss.n1827 avss.n1823 1.57121
R3689 avss.n1828 avss.n1821 1.57121
R3690 avss.n1823 avss.n1821 1.57121
R3691 avss.n68 avss.n67 1.57121
R3692 avss.n67 avss.n63 1.57121
R3693 avss.n68 avss.n61 1.57121
R3694 avss.n63 avss.n61 1.57121
R3695 avss.n77 avss.n76 1.57121
R3696 avss.n76 avss.n72 1.57121
R3697 avss.n77 avss.n70 1.57121
R3698 avss.n72 avss.n70 1.57121
R3699 avss.n88 avss.n87 1.57121
R3700 avss.n87 avss.n83 1.57121
R3701 avss.n88 avss.n81 1.57121
R3702 avss.n83 avss.n81 1.57121
R3703 avss.n99 avss.n98 1.57121
R3704 avss.n98 avss.n94 1.57121
R3705 avss.n99 avss.n92 1.57121
R3706 avss.n94 avss.n92 1.57121
R3707 avss.n1672 avss.n1671 1.57121
R3708 avss.n1671 avss.n1667 1.57121
R3709 avss.n1672 avss.n1665 1.57121
R3710 avss.n1667 avss.n1665 1.57121
R3711 avss.n1642 avss.n1641 1.57121
R3712 avss.n1641 avss.n1637 1.57121
R3713 avss.n1642 avss.n1635 1.57121
R3714 avss.n1637 avss.n1635 1.57121
R3715 avss.n1652 avss.n1651 1.57121
R3716 avss.n1651 avss.n1647 1.57121
R3717 avss.n1652 avss.n1645 1.57121
R3718 avss.n1647 avss.n1645 1.57121
R3719 avss.n1661 avss.n1660 1.57121
R3720 avss.n1660 avss.n1656 1.57121
R3721 avss.n1661 avss.n1654 1.57121
R3722 avss.n1656 avss.n1654 1.57121
R3723 avss.n1632 avss.n1631 1.57121
R3724 avss.n1631 avss.n1627 1.57121
R3725 avss.n1632 avss.n1625 1.57121
R3726 avss.n1627 avss.n1625 1.57121
R3727 avss.n1801 avss.n41 1.568
R3728 avss.n1679 avss.n1678 1.53119
R3729 avss.n1743 avss.n54 1.4955
R3730 avss.n184 avss.n183 1.44692
R3731 avss.n1728 avss.n1727 1.44692
R3732 avss.n1793 avss.n1792 1.3505
R3733 avss.n39 avss.n107 1.38938
R3734 avss.n55 avss.n1745 1.1755
R3735 avss.n55 avss.n56 0.00393712
R3736 avss.n1716 avss.n23 4.74526
R3737 avss.n50 avss.n23 0.0362594
R3738 avss.n30 avss.n24 0.0481176
R3739 avss.n20 avss.n212 4.74181
R3740 avss.n5 avss.n19 0.0412653
R3741 avss.n13 avss.n14 0.0115183
R3742 avss.n215 avss.n7 0.56199
R3743 avss.n5 avss.n7 0.0672593
R3744 avss.n202 avss.n8 1.02244
R3745 avss.n1 avss.n58 2.14994
R3746 avss.n1722 avss.n12 1.1255
R3747 avss.n12 avss.n31 0.0630241
R3748 avss.n1740 avss.n36 1.1255
R3749 avss.n192 avss.n11 1.13251
R3750 avss.n1754 avss.n1751 1.1255
R3751 avss.n35 avss.t232 0.643831
R3752 avss.n1816 avss.n1815 1.1255
R3753 avss.n29 avss.n10 1.87093
R3754 avss.n1715 avss.n1712 1.03563
R3755 avss.n1751 avss.n1750 1.0355
R3756 avss.n1808 avss.n1807 0.953075
R3757 avss.n1706 avss.n1688 0.9005
R3758 avss.n1818 avss.n1817 0.889211
R3759 avss.n1741 avss.n154 0.809375
R3760 avss.n196 avss.t222 0.764898
R3761 avss.n1817 avss.n1816 0.727422
R3762 avss.n1801 avss.n1800 0.7205
R3763 avss.n1813 avss.n1812 0.6755
R3764 avss.t214 avss.t224 0.635552
R3765 avss.t216 avss.n26 0.491784
R3766 avss.t220 avss.n43 0.496457
R3767 avss.n28 avss.t218 0.496415
R3768 avss.n1773 avss.t127 0.611204
R3769 avss.n1773 avss.t128 0.611204
R3770 avss.n1775 avss.t124 0.611204
R3771 avss.n1775 avss.t125 0.611204
R3772 avss.n1778 avss.t121 0.611204
R3773 avss.n1778 avss.t122 0.611204
R3774 avss.n106 avss.t85 0.611204
R3775 avss.n106 avss.t86 0.611204
R3776 avss.n108 avss.t82 0.611204
R3777 avss.n108 avss.t83 0.611204
R3778 avss.n1781 avss.t118 0.611204
R3779 avss.n1781 avss.t119 0.611204
R3780 avss.n110 avss.t112 0.611204
R3781 avss.n110 avss.t113 0.611204
R3782 avss.n1783 avss.t115 0.611204
R3783 avss.n1783 avss.t116 0.611204
R3784 avss.n1785 avss.t88 0.611204
R3785 avss.n1785 avss.t89 0.611204
R3786 avss.n1787 avss.t91 0.611204
R3787 avss.n1787 avss.t92 0.611204
R3788 avss.n1790 avss.n1789 0.5855
R3789 avss.n24 avss.n5 0.0925347
R3790 avss.n59 avss.n10 0.0571669
R3791 avss.n1705 avss.n10 4.79522
R3792 avss.n14 avss.n35 0.20883
R3793 avss.n35 avss.n32 0.103011
R3794 avss.n32 avss.n19 0.233262
R3795 avss.n30 avss.n19 0.027297
R3796 avss.n191 avss.n190 0.5585
R3797 avss.n190 avss.n189 0.5585
R3798 avss.n189 avss.n188 0.5585
R3799 avss.n188 avss.n187 0.5585
R3800 avss.n159 avss.n158 0.5585
R3801 avss.n158 avss.n157 0.5585
R3802 avss.n157 avss.n156 0.5585
R3803 avss.n156 avss.n155 0.5585
R3804 avss.n22 avss.n23 0.0140024
R3805 avss.n5 avss.n20 0.0596163
R3806 avss.n13 avss.n205 4.75547
R3807 avss.n5 avss.n197 0.55683
R3808 avss.n22 avss.n1717 4.75286
R3809 avss.n15 avss 0.491929
R3810 avss.n1817 avss.n102 0.457391
R3811 avss.n186 avss.n183 0.391602
R3812 avss.n1730 avss.n1727 0.391602
R3813 avss.n1684 avss.t43 0.37587
R3814 avss.n1684 avss.t44 0.37587
R3815 avss.n1700 avss.t37 0.37587
R3816 avss.n1700 avss.t38 0.37587
R3817 avss.n1702 avss.t34 0.37587
R3818 avss.n1702 avss.t35 0.37587
R3819 avss.n1689 avss.t55 0.37587
R3820 avss.n1689 avss.t56 0.37587
R3821 avss.n1686 avss.t40 0.37587
R3822 avss.n1686 avss.t41 0.37587
R3823 avss.n1710 avss.t46 0.37587
R3824 avss.n1710 avss.t47 0.37587
R3825 avss.n1692 avss.t139 0.37587
R3826 avss.n1692 avss.t140 0.37587
R3827 avss.n1694 avss.t136 0.37587
R3828 avss.n1694 avss.t137 0.37587
R3829 avss.n1696 avss.t133 0.37587
R3830 avss.n1696 avss.t134 0.37587
R3831 avss.n1713 avss.t130 0.37587
R3832 avss.n1713 avss.t131 0.37587
R3833 avss.n1 avss.n37 0.182138
R3834 avss.n36 avss.n37 0.0137238
R3835 avss.n1828 avss.n1822 0.371929
R3836 avss.n1825 avss.n1823 0.371929
R3837 avss.n68 avss.n62 0.371929
R3838 avss.n65 avss.n63 0.371929
R3839 avss.n77 avss.n71 0.371929
R3840 avss.n74 avss.n72 0.371929
R3841 avss.n88 avss.n82 0.371929
R3842 avss.n85 avss.n83 0.371929
R3843 avss.n99 avss.n93 0.371929
R3844 avss.n96 avss.n94 0.371929
R3845 avss.n1672 avss.n1666 0.371929
R3846 avss.n1669 avss.n1667 0.371929
R3847 avss.n1642 avss.n1636 0.371929
R3848 avss.n1639 avss.n1637 0.371929
R3849 avss.n1652 avss.n1646 0.371929
R3850 avss.n1649 avss.n1647 0.371929
R3851 avss.n1661 avss.n1655 0.371929
R3852 avss.n1658 avss.n1656 0.371929
R3853 avss.n1632 avss.n1626 0.371929
R3854 avss.n1629 avss.n1627 0.371929
R3855 avss.n135 avss.n134 0.355604
R3856 avss.n1805 avss.n18 4.75989
R3857 avss.n1803 avss.t94 0.315918
R3858 avss.n1803 avss.t95 0.315918
R3859 avss.n131 avss.t76 0.315918
R3860 avss.n131 avss.t77 0.315918
R3861 avss.n117 avss.t73 0.315918
R3862 avss.n117 avss.t74 0.315918
R3863 avss.n119 avss.t70 0.315918
R3864 avss.n119 avss.t71 0.315918
R3865 avss.n122 avss.t67 0.315918
R3866 avss.n122 avss.t68 0.315918
R3867 avss.n125 avss.t64 0.315918
R3868 avss.n125 avss.t65 0.315918
R3869 avss.n128 avss.t61 0.315918
R3870 avss.n128 avss.t62 0.315918
R3871 avss.n115 avss.t58 0.315918
R3872 avss.n115 avss.t59 0.315918
R3873 avss.n113 avss.t79 0.315918
R3874 avss.n113 avss.t80 0.315918
R3875 avss.n139 avss.t97 0.315918
R3876 avss.n139 avss.t98 0.315918
R3877 avss.n136 avss.t100 0.315918
R3878 avss.n136 avss.t101 0.315918
R3879 avss.n141 avss.t103 0.315918
R3880 avss.n141 avss.t104 0.315918
R3881 avss.n1797 avss.t106 0.315918
R3882 avss.n1797 avss.t107 0.315918
R3883 avss.n1795 avss.t109 0.315918
R3884 avss.n1795 avss.t110 0.315918
R3885 avss.n1679 avss.t224 0.31349
R3886 avss.n1680 avss.t226 0.31349
R3887 avss.n216 avss.t230 0.31349
R3888 avss.t228 avss.n1681 0.31349
R3889 avss.n1680 avss.n1679 0.3085
R3890 avss.n1681 avss.n1680 0.3085
R3891 avss.n1681 avss.n216 0.3085
R3892 avss.n1827 avss.n1826 0.306382
R3893 avss.n1824 avss.n1821 0.306382
R3894 avss.n67 avss.n66 0.306382
R3895 avss.n64 avss.n61 0.306382
R3896 avss.n76 avss.n75 0.306382
R3897 avss.n73 avss.n70 0.306382
R3898 avss.n87 avss.n86 0.306382
R3899 avss.n84 avss.n81 0.306382
R3900 avss.n98 avss.n97 0.306382
R3901 avss.n95 avss.n92 0.306382
R3902 avss.n1671 avss.n1670 0.306382
R3903 avss.n1668 avss.n1665 0.306382
R3904 avss.n1641 avss.n1640 0.306382
R3905 avss.n1638 avss.n1635 0.306382
R3906 avss.n1651 avss.n1650 0.306382
R3907 avss.n1648 avss.n1645 0.306382
R3908 avss.n1660 avss.n1659 0.306382
R3909 avss.n1657 avss.n1654 0.306382
R3910 avss.n1631 avss.n1630 0.306382
R3911 avss.n1628 avss.n1625 0.306382
R3912 avss.n1807 avss.n112 0.302675
R3913 avss.n198 avss.t31 0.280745
R3914 avss.n198 avss.t32 0.280745
R3915 avss.n1724 avss.t52 0.280745
R3916 avss.n1724 avss.t53 0.280745
R3917 avss.n184 avss.t49 0.280745
R3918 avss.n184 avss.t50 0.280745
R3919 avss.n1735 avss.t145 0.280745
R3920 avss.n1735 avss.t146 0.280745
R3921 avss.n1738 avss.t169 0.280745
R3922 avss.n1738 avss.t170 0.280745
R3923 avss.n179 avss.t166 0.280745
R3924 avss.n179 avss.t167 0.280745
R3925 avss.n176 avss.t163 0.280745
R3926 avss.n176 avss.t164 0.280745
R3927 avss.n173 avss.t160 0.280745
R3928 avss.n173 avss.t161 0.280745
R3929 avss.n170 avss.t157 0.280745
R3930 avss.n170 avss.t158 0.280745
R3931 avss.n167 avss.t154 0.280745
R3932 avss.n167 avss.t155 0.280745
R3933 avss.n164 avss.t151 0.280745
R3934 avss.n164 avss.t152 0.280745
R3935 avss.n1728 avss.t148 0.280745
R3936 avss.n1728 avss.t149 0.280745
R3937 avss.n160 avss.t142 0.280745
R3938 avss.n160 avss.t143 0.280745
R3939 avss.n200 avss.t28 0.280745
R3940 avss.n200 avss.t29 0.280745
R3941 avss.n203 avss.t25 0.280745
R3942 avss.n203 avss.t26 0.280745
R3943 avss.n206 avss.t22 0.280745
R3944 avss.n206 avss.t23 0.280745
R3945 avss.n208 avss.t19 0.280745
R3946 avss.n208 avss.t20 0.280745
R3947 avss.n210 avss.t16 0.280745
R3948 avss.n210 avss.t17 0.280745
R3949 avss.n194 avss.t13 0.280745
R3950 avss.n194 avss.t14 0.280745
R3951 avss.n1720 avss.t10 0.280745
R3952 avss.n1720 avss.t11 0.280745
R3953 avss.n16 avss.n48 1.74467
R3954 avss.n48 avss.n1763 0.944028
R3955 avss.n47 avss.n1766 0.881568
R3956 avss.n16 avss.n47 1.94502
R3957 avss.t232 avss.n196 0.25311
R3958 avss.n56 avss.n150 4.7512
R3959 avss.n53 avss.n133 1.319
R3960 avss.n1752 avss.t172 0.250627
R3961 avss.n1752 avss.t173 0.250627
R3962 avss.n144 avss.t199 0.250627
R3963 avss.n144 avss.t200 0.250627
R3964 avss.n1761 avss.t196 0.250627
R3965 avss.n1761 avss.t197 0.250627
R3966 avss.n1764 avss.t193 0.250627
R3967 avss.n1764 avss.t194 0.250627
R3968 avss.n1767 avss.t190 0.250627
R3969 avss.n1767 avss.t191 0.250627
R3970 avss.n1770 avss.t187 0.250627
R3971 avss.n1770 avss.t188 0.250627
R3972 avss.n1757 avss.t184 0.250627
R3973 avss.n1757 avss.t185 0.250627
R3974 avss.n1748 avss.t175 0.250627
R3975 avss.n1748 avss.t176 0.250627
R3976 avss.n151 avss.t178 0.250627
R3977 avss.n151 avss.t179 0.250627
R3978 avss.n148 avss.t181 0.250627
R3979 avss.n148 avss.t182 0.250627
R3980 avss.n1740 avss.n162 0.245413
R3981 avss.n192 avss.n182 0.245413
R3982 avss.n134 avss.n103 0.239028
R3983 avss.n135 avss.n52 0.220729
R3984 avss.n1698 avss.n50 4.75235
R3985 avss.n1742 avss.n51 0.208962
R3986 avss.n1760 avss.n1759 0.200225
R3987 avss.n192 avss.n191 0.1868
R3988 avss.n1740 avss.n159 0.1868
R3989 avss.n1722 avss.n57 0.1805
R3990 avss.n2 avss.n163 0.149379
R3991 avss.n80 avss.n79 0.1805
R3992 avss.n1756 avss.n51 0.17182
R3993 avss.n1742 avss.n55 0.17182
R3994 avss.n1 avss.n1742 0.156003
R3995 avss.n1643 avss 0.145111
R3996 avss.n1816 avss.n103 0.143948
R3997 avss.n15 avss.n135 0.139308
R3998 avss.n89 avss.n80 0.1355
R3999 avss.n1664 avss.n1663 0.1355
R4000 avss.n940 avss.n447 0.1355
R4001 avss.n12 avss.n11 0.0690092
R4002 avss.n69 avss 0.1225
R4003 avss.n193 avss.n186 0.122
R4004 avss.n1819 avss 0.122
R4005 avss.n1643 avss 0.113278
R4006 avss.n2 avss.n1 0.104175
R4007 avss.n31 avss.n57 0.188602
R4008 avss.n1741 avss.n1740 0.0980375
R4009 avss.n1732 avss.n1730 0.095
R4010 avss.n1745 avss.n1744 0.0905
R4011 avss avss.n1820 0.0905
R4012 avss.n100 avss.n90 0.0905
R4013 avss avss.n91 0.0905
R4014 avss.n1633 avss 0.0905
R4015 avss avss.n1624 0.0905
R4016 avss.n1653 avss.n1644 0.0905
R4017 avss.n1468 avss.n271 0.0905
R4018 avss.n1472 avss.n271 0.0905
R4019 avss.n1473 avss.n1472 0.0905
R4020 avss.n1474 avss.n1473 0.0905
R4021 avss.n1474 avss.n269 0.0905
R4022 avss.n1478 avss.n269 0.0905
R4023 avss.n1479 avss.n1478 0.0905
R4024 avss.n1480 avss.n1479 0.0905
R4025 avss.n1480 avss.n267 0.0905
R4026 avss.n1484 avss.n267 0.0905
R4027 avss.n1485 avss.n1484 0.0905
R4028 avss.n1486 avss.n1485 0.0905
R4029 avss.n1486 avss.n265 0.0905
R4030 avss.n1490 avss.n265 0.0905
R4031 avss.n1491 avss.n1490 0.0905
R4032 avss.n1492 avss.n1491 0.0905
R4033 avss.n1492 avss.n263 0.0905
R4034 avss.n1496 avss.n263 0.0905
R4035 avss.n1497 avss.n1496 0.0905
R4036 avss.n1498 avss.n1497 0.0905
R4037 avss.n1498 avss.n261 0.0905
R4038 avss.n1502 avss.n261 0.0905
R4039 avss.n1503 avss.n1502 0.0905
R4040 avss.n1504 avss.n1503 0.0905
R4041 avss.n1504 avss.n259 0.0905
R4042 avss.n1508 avss.n259 0.0905
R4043 avss.n1509 avss.n1508 0.0905
R4044 avss.n1510 avss.n1509 0.0905
R4045 avss.n1510 avss.n257 0.0905
R4046 avss.n1514 avss.n257 0.0905
R4047 avss.n1515 avss.n1514 0.0905
R4048 avss.n1516 avss.n1515 0.0905
R4049 avss.n1516 avss.n255 0.0905
R4050 avss.n1520 avss.n255 0.0905
R4051 avss.n1521 avss.n1520 0.0905
R4052 avss.n1522 avss.n1521 0.0905
R4053 avss.n1522 avss.n253 0.0905
R4054 avss.n1526 avss.n253 0.0905
R4055 avss.n1527 avss.n1526 0.0905
R4056 avss.n1528 avss.n1527 0.0905
R4057 avss.n1528 avss.n251 0.0905
R4058 avss.n1532 avss.n251 0.0905
R4059 avss.n1533 avss.n1532 0.0905
R4060 avss.n1534 avss.n1533 0.0905
R4061 avss.n1534 avss.n249 0.0905
R4062 avss.n1538 avss.n249 0.0905
R4063 avss.n1539 avss.n1538 0.0905
R4064 avss.n1540 avss.n1539 0.0905
R4065 avss.n1540 avss.n247 0.0905
R4066 avss.n1544 avss.n247 0.0905
R4067 avss.n1545 avss.n1544 0.0905
R4068 avss.n1546 avss.n1545 0.0905
R4069 avss.n1546 avss.n245 0.0905
R4070 avss.n1550 avss.n245 0.0905
R4071 avss.n1551 avss.n1550 0.0905
R4072 avss.n1552 avss.n1551 0.0905
R4073 avss.n1552 avss.n243 0.0905
R4074 avss.n1556 avss.n243 0.0905
R4075 avss.n1557 avss.n1556 0.0905
R4076 avss.n1558 avss.n1557 0.0905
R4077 avss.n1558 avss.n241 0.0905
R4078 avss.n1562 avss.n241 0.0905
R4079 avss.n1563 avss.n1562 0.0905
R4080 avss.n1564 avss.n1563 0.0905
R4081 avss.n1564 avss.n239 0.0905
R4082 avss.n1568 avss.n239 0.0905
R4083 avss.n1569 avss.n1568 0.0905
R4084 avss.n1570 avss.n1569 0.0905
R4085 avss.n1570 avss.n237 0.0905
R4086 avss.n1574 avss.n237 0.0905
R4087 avss.n1575 avss.n1574 0.0905
R4088 avss.n1576 avss.n1575 0.0905
R4089 avss.n1576 avss.n235 0.0905
R4090 avss.n1580 avss.n235 0.0905
R4091 avss.n1581 avss.n1580 0.0905
R4092 avss.n1582 avss.n1581 0.0905
R4093 avss.n1582 avss.n233 0.0905
R4094 avss.n1586 avss.n233 0.0905
R4095 avss.n1587 avss.n1586 0.0905
R4096 avss.n1588 avss.n1587 0.0905
R4097 avss.n1588 avss.n231 0.0905
R4098 avss.n1592 avss.n231 0.0905
R4099 avss.n1593 avss.n1592 0.0905
R4100 avss.n1594 avss.n1593 0.0905
R4101 avss.n1594 avss.n229 0.0905
R4102 avss.n1598 avss.n229 0.0905
R4103 avss.n1599 avss.n1598 0.0905
R4104 avss.n1600 avss.n1599 0.0905
R4105 avss.n1600 avss.n227 0.0905
R4106 avss.n1604 avss.n227 0.0905
R4107 avss.n1605 avss.n1604 0.0905
R4108 avss.n1606 avss.n1605 0.0905
R4109 avss.n1606 avss.n225 0.0905
R4110 avss.n1610 avss.n225 0.0905
R4111 avss.n1611 avss.n1610 0.0905
R4112 avss.n1612 avss.n1611 0.0905
R4113 avss.n1612 avss.n223 0.0905
R4114 avss.n1616 avss.n223 0.0905
R4115 avss.n1617 avss.n1616 0.0905
R4116 avss.n1618 avss.n1617 0.0905
R4117 avss.n1618 avss.n220 0.0905
R4118 avss.n1622 avss.n220 0.0905
R4119 avss.n1467 avss.n1466 0.0905
R4120 avss.n1466 avss.n273 0.0905
R4121 avss.n1462 avss.n273 0.0905
R4122 avss.n1462 avss.n1461 0.0905
R4123 avss.n1461 avss.n1460 0.0905
R4124 avss.n1460 avss.n275 0.0905
R4125 avss.n1456 avss.n275 0.0905
R4126 avss.n1456 avss.n1455 0.0905
R4127 avss.n1455 avss.n1454 0.0905
R4128 avss.n1454 avss.n277 0.0905
R4129 avss.n1450 avss.n277 0.0905
R4130 avss.n1450 avss.n1449 0.0905
R4131 avss.n1449 avss.n1448 0.0905
R4132 avss.n1448 avss.n279 0.0905
R4133 avss.n1444 avss.n279 0.0905
R4134 avss.n1444 avss.n1443 0.0905
R4135 avss.n1443 avss.n1442 0.0905
R4136 avss.n1442 avss.n281 0.0905
R4137 avss.n1438 avss.n281 0.0905
R4138 avss.n1438 avss.n1437 0.0905
R4139 avss.n1437 avss.n1436 0.0905
R4140 avss.n1436 avss.n283 0.0905
R4141 avss.n1432 avss.n283 0.0905
R4142 avss.n1432 avss.n1431 0.0905
R4143 avss.n1431 avss.n1430 0.0905
R4144 avss.n1430 avss.n285 0.0905
R4145 avss.n1426 avss.n285 0.0905
R4146 avss.n1426 avss.n1425 0.0905
R4147 avss.n1425 avss.n1424 0.0905
R4148 avss.n1424 avss.n287 0.0905
R4149 avss.n1420 avss.n287 0.0905
R4150 avss.n1420 avss.n1419 0.0905
R4151 avss.n1419 avss.n1418 0.0905
R4152 avss.n1418 avss.n289 0.0905
R4153 avss.n1414 avss.n289 0.0905
R4154 avss.n1414 avss.n1413 0.0905
R4155 avss.n1413 avss.n1412 0.0905
R4156 avss.n1412 avss.n291 0.0905
R4157 avss.n1408 avss.n291 0.0905
R4158 avss.n1408 avss.n1407 0.0905
R4159 avss.n1407 avss.n1406 0.0905
R4160 avss.n1406 avss.n293 0.0905
R4161 avss.n1402 avss.n293 0.0905
R4162 avss.n1402 avss.n1401 0.0905
R4163 avss.n1401 avss.n1400 0.0905
R4164 avss.n1400 avss.n295 0.0905
R4165 avss.n1396 avss.n295 0.0905
R4166 avss.n1396 avss.n1395 0.0905
R4167 avss.n1395 avss.n1394 0.0905
R4168 avss.n1394 avss.n297 0.0905
R4169 avss.n1390 avss.n297 0.0905
R4170 avss.n1390 avss.n1389 0.0905
R4171 avss.n1389 avss.n1388 0.0905
R4172 avss.n1388 avss.n299 0.0905
R4173 avss.n1384 avss.n299 0.0905
R4174 avss.n1384 avss.n1383 0.0905
R4175 avss.n1383 avss.n1382 0.0905
R4176 avss.n1382 avss.n301 0.0905
R4177 avss.n1378 avss.n301 0.0905
R4178 avss.n1378 avss.n1377 0.0905
R4179 avss.n1377 avss.n1376 0.0905
R4180 avss.n1376 avss.n303 0.0905
R4181 avss.n1372 avss.n303 0.0905
R4182 avss.n1372 avss.n1371 0.0905
R4183 avss.n1371 avss.n1370 0.0905
R4184 avss.n1370 avss.n305 0.0905
R4185 avss.n1366 avss.n305 0.0905
R4186 avss.n1366 avss.n1365 0.0905
R4187 avss.n1365 avss.n1364 0.0905
R4188 avss.n1364 avss.n307 0.0905
R4189 avss.n1360 avss.n307 0.0905
R4190 avss.n1360 avss.n1359 0.0905
R4191 avss.n1359 avss.n1358 0.0905
R4192 avss.n1358 avss.n309 0.0905
R4193 avss.n1354 avss.n309 0.0905
R4194 avss.n1354 avss.n1353 0.0905
R4195 avss.n1353 avss.n1352 0.0905
R4196 avss.n1352 avss.n311 0.0905
R4197 avss.n1348 avss.n311 0.0905
R4198 avss.n1348 avss.n1347 0.0905
R4199 avss.n1347 avss.n1346 0.0905
R4200 avss.n1346 avss.n313 0.0905
R4201 avss.n1342 avss.n313 0.0905
R4202 avss.n1342 avss.n1341 0.0905
R4203 avss.n1341 avss.n1340 0.0905
R4204 avss.n1340 avss.n315 0.0905
R4205 avss.n1336 avss.n315 0.0905
R4206 avss.n1336 avss.n1335 0.0905
R4207 avss.n1335 avss.n1334 0.0905
R4208 avss.n1334 avss.n317 0.0905
R4209 avss.n1330 avss.n317 0.0905
R4210 avss.n1330 avss.n1329 0.0905
R4211 avss.n1329 avss.n1328 0.0905
R4212 avss.n1328 avss.n319 0.0905
R4213 avss.n1324 avss.n319 0.0905
R4214 avss.n1324 avss.n1323 0.0905
R4215 avss.n1323 avss.n1322 0.0905
R4216 avss.n1322 avss.n321 0.0905
R4217 avss.n1318 avss.n321 0.0905
R4218 avss.n1318 avss.n1317 0.0905
R4219 avss.n1317 avss.n1316 0.0905
R4220 avss.n1316 avss.n323 0.0905
R4221 avss.n1312 avss.n323 0.0905
R4222 avss.n1312 avss.n1311 0.0905
R4223 avss.n1311 avss.n1310 0.0905
R4224 avss.n1310 avss.n325 0.0905
R4225 avss.n1306 avss.n325 0.0905
R4226 avss.n1306 avss.n1305 0.0905
R4227 avss.n1305 avss.n1304 0.0905
R4228 avss.n1304 avss.n327 0.0905
R4229 avss.n1300 avss.n327 0.0905
R4230 avss.n1300 avss.n1299 0.0905
R4231 avss.n1299 avss.n1298 0.0905
R4232 avss.n1298 avss.n329 0.0905
R4233 avss.n1294 avss.n329 0.0905
R4234 avss.n1294 avss.n1293 0.0905
R4235 avss.n1293 avss.n1292 0.0905
R4236 avss.n1292 avss.n331 0.0905
R4237 avss.n1288 avss.n331 0.0905
R4238 avss.n1288 avss.n1287 0.0905
R4239 avss.n1287 avss.n1286 0.0905
R4240 avss.n1286 avss.n333 0.0905
R4241 avss.n1282 avss.n333 0.0905
R4242 avss.n1282 avss.n1281 0.0905
R4243 avss.n1281 avss.n1280 0.0905
R4244 avss.n1280 avss.n335 0.0905
R4245 avss.n1276 avss.n335 0.0905
R4246 avss.n1276 avss.n1275 0.0905
R4247 avss.n1275 avss.n1274 0.0905
R4248 avss.n1274 avss.n337 0.0905
R4249 avss.n1270 avss.n337 0.0905
R4250 avss.n1270 avss.n1269 0.0905
R4251 avss.n1269 avss.n1268 0.0905
R4252 avss.n1268 avss.n339 0.0905
R4253 avss.n1264 avss.n339 0.0905
R4254 avss.n1264 avss.n1263 0.0905
R4255 avss.n1263 avss.n1262 0.0905
R4256 avss.n1262 avss.n341 0.0905
R4257 avss.n1258 avss.n341 0.0905
R4258 avss.n1258 avss.n1257 0.0905
R4259 avss.n1257 avss.n1256 0.0905
R4260 avss.n1256 avss.n343 0.0905
R4261 avss.n1252 avss.n343 0.0905
R4262 avss.n1252 avss.n1251 0.0905
R4263 avss.n1251 avss.n1250 0.0905
R4264 avss.n1250 avss.n345 0.0905
R4265 avss.n1246 avss.n345 0.0905
R4266 avss.n1246 avss.n1245 0.0905
R4267 avss.n1245 avss.n1244 0.0905
R4268 avss.n1244 avss.n347 0.0905
R4269 avss.n1240 avss.n347 0.0905
R4270 avss.n1240 avss.n1239 0.0905
R4271 avss.n1239 avss.n1238 0.0905
R4272 avss.n1238 avss.n349 0.0905
R4273 avss.n1234 avss.n349 0.0905
R4274 avss.n1234 avss.n1233 0.0905
R4275 avss.n1233 avss.n1232 0.0905
R4276 avss.n1232 avss.n351 0.0905
R4277 avss.n1228 avss.n351 0.0905
R4278 avss.n1228 avss.n1227 0.0905
R4279 avss.n1227 avss.n1226 0.0905
R4280 avss.n1226 avss.n353 0.0905
R4281 avss.n1222 avss.n353 0.0905
R4282 avss.n1222 avss.n1221 0.0905
R4283 avss.n1221 avss.n1220 0.0905
R4284 avss.n1220 avss.n355 0.0905
R4285 avss.n1216 avss.n355 0.0905
R4286 avss.n1216 avss.n1215 0.0905
R4287 avss.n1215 avss.n1214 0.0905
R4288 avss.n1214 avss.n357 0.0905
R4289 avss.n1210 avss.n357 0.0905
R4290 avss.n1210 avss.n1209 0.0905
R4291 avss.n1209 avss.n1208 0.0905
R4292 avss.n1208 avss.n359 0.0905
R4293 avss.n1204 avss.n359 0.0905
R4294 avss.n1204 avss.n1203 0.0905
R4295 avss.n1203 avss.n1202 0.0905
R4296 avss.n1202 avss.n361 0.0905
R4297 avss.n1198 avss.n361 0.0905
R4298 avss.n1198 avss.n1197 0.0905
R4299 avss.n1197 avss.n1196 0.0905
R4300 avss.n1196 avss.n363 0.0905
R4301 avss.n1192 avss.n363 0.0905
R4302 avss.n1192 avss.n1191 0.0905
R4303 avss.n1191 avss.n1190 0.0905
R4304 avss.n1190 avss.n365 0.0905
R4305 avss.n1186 avss.n365 0.0905
R4306 avss.n1186 avss.n1185 0.0905
R4307 avss.n1185 avss.n1184 0.0905
R4308 avss.n1184 avss.n367 0.0905
R4309 avss.n1180 avss.n367 0.0905
R4310 avss.n1180 avss.n1179 0.0905
R4311 avss.n1179 avss.n1178 0.0905
R4312 avss.n1178 avss.n369 0.0905
R4313 avss.n1174 avss.n369 0.0905
R4314 avss.n1174 avss.n1173 0.0905
R4315 avss.n1173 avss.n1172 0.0905
R4316 avss.n1172 avss.n371 0.0905
R4317 avss.n1168 avss.n371 0.0905
R4318 avss.n1168 avss.n1167 0.0905
R4319 avss.n1167 avss.n1166 0.0905
R4320 avss.n1166 avss.n373 0.0905
R4321 avss.n1162 avss.n373 0.0905
R4322 avss.n1162 avss.n1161 0.0905
R4323 avss.n1161 avss.n1160 0.0905
R4324 avss.n1160 avss.n375 0.0905
R4325 avss.n1156 avss.n375 0.0905
R4326 avss.n1156 avss.n1155 0.0905
R4327 avss.n1155 avss.n1154 0.0905
R4328 avss.n1154 avss.n377 0.0905
R4329 avss.n1150 avss.n377 0.0905
R4330 avss.n1150 avss.n1149 0.0905
R4331 avss.n1149 avss.n1148 0.0905
R4332 avss.n1148 avss.n379 0.0905
R4333 avss.n1144 avss.n379 0.0905
R4334 avss.n1144 avss.n1143 0.0905
R4335 avss.n1143 avss.n1142 0.0905
R4336 avss.n1142 avss.n381 0.0905
R4337 avss.n1138 avss.n381 0.0905
R4338 avss.n1138 avss.n1137 0.0905
R4339 avss.n1137 avss.n1136 0.0905
R4340 avss.n1136 avss.n383 0.0905
R4341 avss.n1132 avss.n383 0.0905
R4342 avss.n1132 avss.n1131 0.0905
R4343 avss.n1131 avss.n1130 0.0905
R4344 avss.n1130 avss.n385 0.0905
R4345 avss.n1126 avss.n385 0.0905
R4346 avss.n1126 avss.n1125 0.0905
R4347 avss.n1125 avss.n1124 0.0905
R4348 avss.n1124 avss.n387 0.0905
R4349 avss.n1120 avss.n387 0.0905
R4350 avss.n1120 avss.n1119 0.0905
R4351 avss.n1119 avss.n1118 0.0905
R4352 avss.n1118 avss.n389 0.0905
R4353 avss.n1114 avss.n389 0.0905
R4354 avss.n1114 avss.n1113 0.0905
R4355 avss.n1113 avss.n1112 0.0905
R4356 avss.n1112 avss.n391 0.0905
R4357 avss.n1108 avss.n391 0.0905
R4358 avss.n1108 avss.n1107 0.0905
R4359 avss.n1107 avss.n1106 0.0905
R4360 avss.n1106 avss.n393 0.0905
R4361 avss.n1102 avss.n393 0.0905
R4362 avss.n1102 avss.n1101 0.0905
R4363 avss.n1101 avss.n1100 0.0905
R4364 avss.n1100 avss.n395 0.0905
R4365 avss.n1096 avss.n395 0.0905
R4366 avss.n1095 avss.n1094 0.0905
R4367 avss.n1094 avss.n397 0.0905
R4368 avss.n1090 avss.n397 0.0905
R4369 avss.n1090 avss.n1089 0.0905
R4370 avss.n1089 avss.n1088 0.0905
R4371 avss.n1088 avss.n399 0.0905
R4372 avss.n1084 avss.n399 0.0905
R4373 avss.n1084 avss.n1083 0.0905
R4374 avss.n1083 avss.n1082 0.0905
R4375 avss.n1082 avss.n401 0.0905
R4376 avss.n1078 avss.n401 0.0905
R4377 avss.n1078 avss.n1077 0.0905
R4378 avss.n1077 avss.n1076 0.0905
R4379 avss.n1076 avss.n403 0.0905
R4380 avss.n1072 avss.n403 0.0905
R4381 avss.n1072 avss.n1071 0.0905
R4382 avss.n1071 avss.n1070 0.0905
R4383 avss.n1070 avss.n405 0.0905
R4384 avss.n1066 avss.n405 0.0905
R4385 avss.n1066 avss.n1065 0.0905
R4386 avss.n1065 avss.n1064 0.0905
R4387 avss.n1064 avss.n407 0.0905
R4388 avss.n1060 avss.n407 0.0905
R4389 avss.n1060 avss.n1059 0.0905
R4390 avss.n1059 avss.n1058 0.0905
R4391 avss.n1058 avss.n409 0.0905
R4392 avss.n1054 avss.n409 0.0905
R4393 avss.n1054 avss.n1053 0.0905
R4394 avss.n1053 avss.n1052 0.0905
R4395 avss.n1052 avss.n411 0.0905
R4396 avss.n1048 avss.n411 0.0905
R4397 avss.n1048 avss.n1047 0.0905
R4398 avss.n1047 avss.n1046 0.0905
R4399 avss.n1046 avss.n413 0.0905
R4400 avss.n1042 avss.n413 0.0905
R4401 avss.n1042 avss.n1041 0.0905
R4402 avss.n1041 avss.n1040 0.0905
R4403 avss.n1040 avss.n415 0.0905
R4404 avss.n1036 avss.n415 0.0905
R4405 avss.n1036 avss.n1035 0.0905
R4406 avss.n1035 avss.n1034 0.0905
R4407 avss.n1034 avss.n417 0.0905
R4408 avss.n1030 avss.n417 0.0905
R4409 avss.n1030 avss.n1029 0.0905
R4410 avss.n1029 avss.n1028 0.0905
R4411 avss.n1028 avss.n419 0.0905
R4412 avss.n1024 avss.n419 0.0905
R4413 avss.n1024 avss.n1023 0.0905
R4414 avss.n1023 avss.n1022 0.0905
R4415 avss.n1022 avss.n421 0.0905
R4416 avss.n1018 avss.n421 0.0905
R4417 avss.n1018 avss.n1017 0.0905
R4418 avss.n1017 avss.n1016 0.0905
R4419 avss.n1016 avss.n423 0.0905
R4420 avss.n1012 avss.n423 0.0905
R4421 avss.n1012 avss.n1011 0.0905
R4422 avss.n1011 avss.n1010 0.0905
R4423 avss.n1010 avss.n425 0.0905
R4424 avss.n1006 avss.n425 0.0905
R4425 avss.n1006 avss.n1005 0.0905
R4426 avss.n1005 avss.n1004 0.0905
R4427 avss.n1004 avss.n427 0.0905
R4428 avss.n1000 avss.n427 0.0905
R4429 avss.n1000 avss.n999 0.0905
R4430 avss.n999 avss.n998 0.0905
R4431 avss.n998 avss.n429 0.0905
R4432 avss.n994 avss.n429 0.0905
R4433 avss.n994 avss.n993 0.0905
R4434 avss.n993 avss.n992 0.0905
R4435 avss.n992 avss.n431 0.0905
R4436 avss.n988 avss.n431 0.0905
R4437 avss.n988 avss.n987 0.0905
R4438 avss.n987 avss.n986 0.0905
R4439 avss.n986 avss.n433 0.0905
R4440 avss.n982 avss.n433 0.0905
R4441 avss.n982 avss.n981 0.0905
R4442 avss.n981 avss.n980 0.0905
R4443 avss.n980 avss.n435 0.0905
R4444 avss.n976 avss.n435 0.0905
R4445 avss.n976 avss.n975 0.0905
R4446 avss.n975 avss.n974 0.0905
R4447 avss.n974 avss.n437 0.0905
R4448 avss.n970 avss.n437 0.0905
R4449 avss.n970 avss.n969 0.0905
R4450 avss.n969 avss.n968 0.0905
R4451 avss.n968 avss.n439 0.0905
R4452 avss.n964 avss.n439 0.0905
R4453 avss.n964 avss.n963 0.0905
R4454 avss.n963 avss.n962 0.0905
R4455 avss.n962 avss.n441 0.0905
R4456 avss.n958 avss.n441 0.0905
R4457 avss.n958 avss.n957 0.0905
R4458 avss.n957 avss.n956 0.0905
R4459 avss.n956 avss.n443 0.0905
R4460 avss.n952 avss.n443 0.0905
R4461 avss.n952 avss.n951 0.0905
R4462 avss.n951 avss.n950 0.0905
R4463 avss.n950 avss.n445 0.0905
R4464 avss.n946 avss.n445 0.0905
R4465 avss.n946 avss.n945 0.0905
R4466 avss.n945 avss.n944 0.0905
R4467 avss.n944 avss.n447 0.0905
R4468 avss.n572 avss.n219 0.0905
R4469 avss.n573 avss.n572 0.0905
R4470 avss.n574 avss.n573 0.0905
R4471 avss.n574 avss.n569 0.0905
R4472 avss.n578 avss.n569 0.0905
R4473 avss.n579 avss.n578 0.0905
R4474 avss.n580 avss.n579 0.0905
R4475 avss.n580 avss.n567 0.0905
R4476 avss.n584 avss.n567 0.0905
R4477 avss.n585 avss.n584 0.0905
R4478 avss.n586 avss.n585 0.0905
R4479 avss.n586 avss.n565 0.0905
R4480 avss.n590 avss.n565 0.0905
R4481 avss.n591 avss.n590 0.0905
R4482 avss.n592 avss.n591 0.0905
R4483 avss.n592 avss.n563 0.0905
R4484 avss.n596 avss.n563 0.0905
R4485 avss.n597 avss.n596 0.0905
R4486 avss.n598 avss.n597 0.0905
R4487 avss.n598 avss.n561 0.0905
R4488 avss.n602 avss.n561 0.0905
R4489 avss.n603 avss.n602 0.0905
R4490 avss.n604 avss.n603 0.0905
R4491 avss.n604 avss.n559 0.0905
R4492 avss.n608 avss.n559 0.0905
R4493 avss.n609 avss.n608 0.0905
R4494 avss.n610 avss.n609 0.0905
R4495 avss.n610 avss.n557 0.0905
R4496 avss.n614 avss.n557 0.0905
R4497 avss.n615 avss.n614 0.0905
R4498 avss.n616 avss.n615 0.0905
R4499 avss.n616 avss.n555 0.0905
R4500 avss.n620 avss.n555 0.0905
R4501 avss.n621 avss.n620 0.0905
R4502 avss.n622 avss.n621 0.0905
R4503 avss.n622 avss.n553 0.0905
R4504 avss.n626 avss.n553 0.0905
R4505 avss.n627 avss.n626 0.0905
R4506 avss.n628 avss.n627 0.0905
R4507 avss.n628 avss.n551 0.0905
R4508 avss.n632 avss.n551 0.0905
R4509 avss.n633 avss.n632 0.0905
R4510 avss.n634 avss.n633 0.0905
R4511 avss.n634 avss.n549 0.0905
R4512 avss.n638 avss.n549 0.0905
R4513 avss.n639 avss.n638 0.0905
R4514 avss.n640 avss.n639 0.0905
R4515 avss.n640 avss.n547 0.0905
R4516 avss.n644 avss.n547 0.0905
R4517 avss.n645 avss.n644 0.0905
R4518 avss.n646 avss.n645 0.0905
R4519 avss.n646 avss.n545 0.0905
R4520 avss.n650 avss.n545 0.0905
R4521 avss.n651 avss.n650 0.0905
R4522 avss.n652 avss.n651 0.0905
R4523 avss.n652 avss.n543 0.0905
R4524 avss.n656 avss.n543 0.0905
R4525 avss.n657 avss.n656 0.0905
R4526 avss.n658 avss.n657 0.0905
R4527 avss.n658 avss.n541 0.0905
R4528 avss.n662 avss.n541 0.0905
R4529 avss.n663 avss.n662 0.0905
R4530 avss.n664 avss.n663 0.0905
R4531 avss.n664 avss.n539 0.0905
R4532 avss.n668 avss.n539 0.0905
R4533 avss.n669 avss.n668 0.0905
R4534 avss.n670 avss.n669 0.0905
R4535 avss.n670 avss.n537 0.0905
R4536 avss.n674 avss.n537 0.0905
R4537 avss.n675 avss.n674 0.0905
R4538 avss.n676 avss.n675 0.0905
R4539 avss.n676 avss.n535 0.0905
R4540 avss.n680 avss.n535 0.0905
R4541 avss.n681 avss.n680 0.0905
R4542 avss.n682 avss.n681 0.0905
R4543 avss.n682 avss.n533 0.0905
R4544 avss.n686 avss.n533 0.0905
R4545 avss.n687 avss.n686 0.0905
R4546 avss.n688 avss.n687 0.0905
R4547 avss.n688 avss.n531 0.0905
R4548 avss.n692 avss.n531 0.0905
R4549 avss.n693 avss.n692 0.0905
R4550 avss.n694 avss.n693 0.0905
R4551 avss.n694 avss.n529 0.0905
R4552 avss.n698 avss.n529 0.0905
R4553 avss.n699 avss.n698 0.0905
R4554 avss.n700 avss.n699 0.0905
R4555 avss.n700 avss.n527 0.0905
R4556 avss.n704 avss.n527 0.0905
R4557 avss.n705 avss.n704 0.0905
R4558 avss.n706 avss.n705 0.0905
R4559 avss.n706 avss.n525 0.0905
R4560 avss.n710 avss.n525 0.0905
R4561 avss.n711 avss.n710 0.0905
R4562 avss.n712 avss.n711 0.0905
R4563 avss.n712 avss.n523 0.0905
R4564 avss.n716 avss.n523 0.0905
R4565 avss.n717 avss.n716 0.0905
R4566 avss.n718 avss.n717 0.0905
R4567 avss.n718 avss.n521 0.0905
R4568 avss.n722 avss.n521 0.0905
R4569 avss.n723 avss.n722 0.0905
R4570 avss.n724 avss.n723 0.0905
R4571 avss.n724 avss.n519 0.0905
R4572 avss.n728 avss.n519 0.0905
R4573 avss.n729 avss.n728 0.0905
R4574 avss.n730 avss.n729 0.0905
R4575 avss.n730 avss.n517 0.0905
R4576 avss.n734 avss.n517 0.0905
R4577 avss.n735 avss.n734 0.0905
R4578 avss.n736 avss.n735 0.0905
R4579 avss.n736 avss.n515 0.0905
R4580 avss.n740 avss.n515 0.0905
R4581 avss.n741 avss.n740 0.0905
R4582 avss.n742 avss.n741 0.0905
R4583 avss.n742 avss.n513 0.0905
R4584 avss.n746 avss.n513 0.0905
R4585 avss.n747 avss.n746 0.0905
R4586 avss.n748 avss.n747 0.0905
R4587 avss.n748 avss.n511 0.0905
R4588 avss.n752 avss.n511 0.0905
R4589 avss.n753 avss.n752 0.0905
R4590 avss.n754 avss.n753 0.0905
R4591 avss.n754 avss.n509 0.0905
R4592 avss.n758 avss.n509 0.0905
R4593 avss.n759 avss.n758 0.0905
R4594 avss.n760 avss.n759 0.0905
R4595 avss.n760 avss.n507 0.0905
R4596 avss.n764 avss.n507 0.0905
R4597 avss.n765 avss.n764 0.0905
R4598 avss.n766 avss.n765 0.0905
R4599 avss.n766 avss.n505 0.0905
R4600 avss.n770 avss.n505 0.0905
R4601 avss.n771 avss.n770 0.0905
R4602 avss.n772 avss.n771 0.0905
R4603 avss.n772 avss.n503 0.0905
R4604 avss.n776 avss.n503 0.0905
R4605 avss.n777 avss.n776 0.0905
R4606 avss.n778 avss.n777 0.0905
R4607 avss.n778 avss.n501 0.0905
R4608 avss.n782 avss.n501 0.0905
R4609 avss.n783 avss.n782 0.0905
R4610 avss.n784 avss.n783 0.0905
R4611 avss.n784 avss.n499 0.0905
R4612 avss.n788 avss.n499 0.0905
R4613 avss.n789 avss.n788 0.0905
R4614 avss.n790 avss.n789 0.0905
R4615 avss.n790 avss.n497 0.0905
R4616 avss.n794 avss.n497 0.0905
R4617 avss.n795 avss.n794 0.0905
R4618 avss.n796 avss.n795 0.0905
R4619 avss.n796 avss.n495 0.0905
R4620 avss.n800 avss.n495 0.0905
R4621 avss.n801 avss.n800 0.0905
R4622 avss.n802 avss.n801 0.0905
R4623 avss.n802 avss.n493 0.0905
R4624 avss.n806 avss.n493 0.0905
R4625 avss.n807 avss.n806 0.0905
R4626 avss.n808 avss.n807 0.0905
R4627 avss.n808 avss.n491 0.0905
R4628 avss.n812 avss.n491 0.0905
R4629 avss.n813 avss.n812 0.0905
R4630 avss.n814 avss.n813 0.0905
R4631 avss.n814 avss.n489 0.0905
R4632 avss.n818 avss.n489 0.0905
R4633 avss.n819 avss.n818 0.0905
R4634 avss.n820 avss.n819 0.0905
R4635 avss.n820 avss.n487 0.0905
R4636 avss.n824 avss.n487 0.0905
R4637 avss.n825 avss.n824 0.0905
R4638 avss.n826 avss.n825 0.0905
R4639 avss.n826 avss.n485 0.0905
R4640 avss.n830 avss.n485 0.0905
R4641 avss.n831 avss.n830 0.0905
R4642 avss.n832 avss.n831 0.0905
R4643 avss.n832 avss.n483 0.0905
R4644 avss.n836 avss.n483 0.0905
R4645 avss.n837 avss.n836 0.0905
R4646 avss.n838 avss.n837 0.0905
R4647 avss.n838 avss.n481 0.0905
R4648 avss.n842 avss.n481 0.0905
R4649 avss.n843 avss.n842 0.0905
R4650 avss.n844 avss.n843 0.0905
R4651 avss.n844 avss.n479 0.0905
R4652 avss.n848 avss.n479 0.0905
R4653 avss.n849 avss.n848 0.0905
R4654 avss.n850 avss.n849 0.0905
R4655 avss.n850 avss.n477 0.0905
R4656 avss.n854 avss.n477 0.0905
R4657 avss.n855 avss.n854 0.0905
R4658 avss.n856 avss.n855 0.0905
R4659 avss.n856 avss.n475 0.0905
R4660 avss.n860 avss.n475 0.0905
R4661 avss.n861 avss.n860 0.0905
R4662 avss.n862 avss.n861 0.0905
R4663 avss.n862 avss.n473 0.0905
R4664 avss.n866 avss.n473 0.0905
R4665 avss.n867 avss.n866 0.0905
R4666 avss.n868 avss.n867 0.0905
R4667 avss.n868 avss.n471 0.0905
R4668 avss.n872 avss.n471 0.0905
R4669 avss.n873 avss.n872 0.0905
R4670 avss.n874 avss.n873 0.0905
R4671 avss.n874 avss.n469 0.0905
R4672 avss.n878 avss.n469 0.0905
R4673 avss.n879 avss.n878 0.0905
R4674 avss.n880 avss.n879 0.0905
R4675 avss.n880 avss.n467 0.0905
R4676 avss.n884 avss.n467 0.0905
R4677 avss.n885 avss.n884 0.0905
R4678 avss.n886 avss.n885 0.0905
R4679 avss.n886 avss.n465 0.0905
R4680 avss.n890 avss.n465 0.0905
R4681 avss.n891 avss.n890 0.0905
R4682 avss.n892 avss.n891 0.0905
R4683 avss.n892 avss.n463 0.0905
R4684 avss.n896 avss.n463 0.0905
R4685 avss.n897 avss.n896 0.0905
R4686 avss.n898 avss.n897 0.0905
R4687 avss.n898 avss.n461 0.0905
R4688 avss.n902 avss.n461 0.0905
R4689 avss.n903 avss.n902 0.0905
R4690 avss.n904 avss.n903 0.0905
R4691 avss.n904 avss.n459 0.0905
R4692 avss.n908 avss.n459 0.0905
R4693 avss.n909 avss.n908 0.0905
R4694 avss.n910 avss.n909 0.0905
R4695 avss.n910 avss.n457 0.0905
R4696 avss.n914 avss.n457 0.0905
R4697 avss.n915 avss.n914 0.0905
R4698 avss.n916 avss.n915 0.0905
R4699 avss.n916 avss.n455 0.0905
R4700 avss.n920 avss.n455 0.0905
R4701 avss.n921 avss.n920 0.0905
R4702 avss.n922 avss.n921 0.0905
R4703 avss.n922 avss.n453 0.0905
R4704 avss.n926 avss.n453 0.0905
R4705 avss.n927 avss.n926 0.0905
R4706 avss.n928 avss.n927 0.0905
R4707 avss.n928 avss.n451 0.0905
R4708 avss.n932 avss.n451 0.0905
R4709 avss.n933 avss.n932 0.0905
R4710 avss.n934 avss.n933 0.0905
R4711 avss.n934 avss.n449 0.0905
R4712 avss.n938 avss.n449 0.0905
R4713 avss.n939 avss.n938 0.0905
R4714 avss.n940 avss.n939 0.0905
R4715 avss.n91 avss 0.077
R4716 avss.n1633 avss 0.077
R4717 avss.n1624 avss 0.077
R4718 avss.n185 avss.n184 0.0761176
R4719 avss.n1729 avss.n1728 0.0761176
R4720 avss.n1096 avss.n1095 0.0755
R4721 avss.n1734 avss.n163 0.0725
R4722 avss.n1723 avss.n1722 0.068
R4723 avss.n3 avss.n7 0.0654625
R4724 avss.n1759 avss.n146 0.064087
R4725 avss.n1623 avss.n1622 0.0605
R4726 avss.n9 avss.n1699 0.0535173
R4727 avss.n1758 avss.n1757 0.0518875
R4728 avss.n60 avss.n54 0.0504749
R4729 avss.n69 avss 0.0455588
R4730 avss.n1820 avss.n1819 0.0455
R4731 avss.n1634 avss.n102 0.0455
R4732 avss.n1468 avss.n1467 0.0455
R4733 avss.n1623 avss.n219 0.0455
R4734 avss.n12 avss.t234 0.0418724
R4735 avss.n1678 avss.n46 28.139
R4736 avss.n52 avss.n18 0.200191
R4737 avss.n49 avss.n1699 0.0360906
R4738 avss.n59 avss.n22 0.0341031
R4739 avss.n1746 avss.n147 0.0339079
R4740 avss.n1755 avss.n147 0.0293559
R4741 avss.n1731 avss.n153 0.029
R4742 avss.n1794 avss.n112 0.02825
R4743 avss.n57 avss.n11 0.0552539
R4744 avss.n216 avss.n32 0.0624937
R4745 avss.n1733 avss.n162 0.0275
R4746 avss.n36 avss.n2 0.0615642
R4747 avss.n31 avss.n37 0.0971064
R4748 avss.n1804 avss.n1803 0.0259055
R4749 avss.n132 avss.n131 0.0259055
R4750 avss.n118 avss.n117 0.0259055
R4751 avss.n120 avss.n119 0.0259055
R4752 avss.n123 avss.n122 0.0259055
R4753 avss.n126 avss.n125 0.0259055
R4754 avss.n129 avss.n128 0.0259055
R4755 avss.n116 avss.n115 0.0259055
R4756 avss.n114 avss.n113 0.0259055
R4757 avss.n140 avss.n139 0.0259055
R4758 avss.n137 avss.n136 0.0259055
R4759 avss.n142 avss.n141 0.0259055
R4760 avss.n1798 avss.n1797 0.0259055
R4761 avss.n1796 avss.n1795 0.0259055
R4762 avss.n1753 avss.n1752 0.0247985
R4763 avss.n145 avss.n144 0.0247985
R4764 avss.n1762 avss.n1761 0.0247985
R4765 avss.n1765 avss.n1764 0.0247985
R4766 avss.n1768 avss.n1767 0.0247985
R4767 avss.n1771 avss.n1770 0.0247985
R4768 avss.n1749 avss.n1748 0.0247985
R4769 avss.n152 avss.n151 0.0247985
R4770 avss.n149 avss.n148 0.0247985
R4771 avss.n182 avss.n154 0.023
R4772 avss.n1746 avss.n56 0.0255563
R4773 avss.n50 avss.n49 0.0253346
R4774 avss.n55 avss.n54 0.0189
R4775 avss.n199 avss.n198 0.0183918
R4776 avss.n1725 avss.n1724 0.0183918
R4777 avss.n1736 avss.n1735 0.0183918
R4778 avss.n1739 avss.n1738 0.0183918
R4779 avss.n180 avss.n179 0.0183918
R4780 avss.n177 avss.n176 0.0183918
R4781 avss.n174 avss.n173 0.0183918
R4782 avss.n171 avss.n170 0.0183918
R4783 avss.n168 avss.n167 0.0183918
R4784 avss.n165 avss.n164 0.0183918
R4785 avss.n161 avss.n160 0.0183918
R4786 avss.n201 avss.n200 0.0183918
R4787 avss.n204 avss.n203 0.0183918
R4788 avss.n207 avss.n206 0.0183918
R4789 avss.n209 avss.n208 0.0183918
R4790 avss.n211 avss.n210 0.0183918
R4791 avss.n195 avss.n194 0.0183918
R4792 avss.n1721 avss.n1720 0.0183918
R4793 avss.n1690 avss.n1689 0.0159559
R4794 avss.n1711 avss.n1710 0.0159559
R4795 avss.n1693 avss.n1692 0.0159559
R4796 avss.n1695 avss.n1694 0.0159559
R4797 avss.n1697 avss.n1696 0.0159559
R4798 avss.n1714 avss.n1713 0.0159559
R4799 avss.n1756 avss.n1755 0.0153055
R4800 avss.n1774 avss.n1773 0.0150591
R4801 avss.n1776 avss.n1775 0.0150591
R4802 avss.n1779 avss.n1778 0.0150591
R4803 avss.n107 avss.n106 0.0150591
R4804 avss.n109 avss.n108 0.0150591
R4805 avss.n1782 avss.n1781 0.0150591
R4806 avss.n111 avss.n110 0.0150591
R4807 avss.n1784 avss.n1783 0.0150591
R4808 avss.n1786 avss.n1785 0.0150591
R4809 avss.n1788 avss.n1787 0.0150591
R4810 avss.n1685 avss.n1684 0.0145027
R4811 avss.n1701 avss.n1700 0.0145027
R4812 avss.n1703 avss.n1702 0.0145027
R4813 avss.n1687 avss.n1686 0.0145027
R4814 avss.n215 avss.n197 0.0143399
R4815 avss.n34 avss.n0 1.89012
R4816 avss.n6 avss.n44 1.01659
R4817 avss.n1790 avss.n38 1.3145
R4818 avss.n40 avss.n1769 1.10885
R4819 avss.n45 avss.n25 0.976599
R4820 avss.n41 avss.n1794 0.974
R4821 avss.n42 avss.n27 0.92651
R4822 avss.n1682 avss.n25 0.723815
R4823 avss.n197 avss.n14 0.0291369
R4824 avss.n20 avss.n30 0.00905779
R4825 avss.n22 avss.n51 0.40805
R4826 avss.n1682 avss.n27 0.283247
R4827 avss.n1 avss.n12 0.197945
R4828 avss.n0 avss.n3 0.186404
R4829 avss.n18 avss.n15 0.140085
R4830 avss.n1 avss.n0 0.128974
R4831 avss.n10 avss.n9 0.121204
R4832 avss.n12 avss.n5 0.118425
R4833 avss.n7 avss.n13 0.116316
R4834 avss.n60 avss.n16 0.100562
R4835 psrg_mf1_protected psrg_mf1_protected.t1 34.4979
R4836 psrg_mf1_protected psrg_mf1_protected.t0 4.75063
R4837 y1.n4 y1.t2 36.3143
R4838 y1.n0 y1.t7 36.1922
R4839 y1.n5 y1.t13 36.1574
R4840 y1.n1 y1.t9 34.3923
R4841 y1.n3 y1.t11 34.3923
R4842 y1.n6 y1.t15 34.3574
R4843 y1.n8 y1.t17 34.3574
R4844 y1.n0 y1.t8 34.3472
R4845 y1.n2 y1.t10 34.3472
R4846 y1.n4 y1.t12 34.3472
R4847 y1.n5 y1.t14 34.2865
R4848 y1.n7 y1.t16 34.2865
R4849 y1.n9 y1.t18 34.2865
R4850 y1.n11 y1.n10 25.6505
R4851 y1.n14 y1.t0 21.1316
R4852 y1.n13 y1.t4 13.894
R4853 y1.n12 y1.t3 13.7842
R4854 y1.n11 y1.t6 13.759
R4855 y1.n15 y1.n13 10.6205
R4856 y1.n14 y1.t1 9.21558
R4857 y1.n12 y1.n11 8.6405
R4858 y1 y1.n15 7.394
R4859 y1.n10 y1.n4 5.9405
R4860 y1.n15 y1.n14 5.8505
R4861 y1 y1.t5 4.69308
R4862 y1.n13 y1.n12 2.7905
R4863 y1.n8 y1.n7 1.9805
R4864 y1.n6 y1.n5 1.9805
R4865 y1.n3 y1.n2 1.9805
R4866 y1.n1 y1.n0 1.9805
R4867 y1.n9 y1.n8 1.8005
R4868 y1.n7 y1.n6 1.8005
R4869 y1.n4 y1.n3 1.8005
R4870 y1.n2 y1.n1 1.8005
R4871 y1.n10 y1.n9 0.1805
R4872 pm1.n5 pm1.n4 41.324
R4873 pm1.n6 pm1.n5 22.0055
R4874 pm1 pm1.n8 20.849
R4875 pm1.n0 pm1.t3 19.4457
R4876 pm1.n2 pm1.t2 17.6349
R4877 pm1.n0 pm1.t5 15.7557
R4878 pm1.n8 pm1.n7 14.8955
R4879 pm1.n2 pm1.n0 14.4905
R4880 pm1.n0 pm1.t4 13.8909
R4881 pm1.n4 pm1.t0 13.7649
R4882 pm1.n7 pm1.t9 13.759
R4883 pm1.n3 pm1.t1 13.7197
R4884 pm1.n1 pm1.t6 12.3566
R4885 pm1.n8 pm1.n1 10.1705
R4886 pm1.n6 pm1.t8 9.28421
R4887 pm1.n1 pm1.t7 9.21558
R4888 pm1.n7 pm1.n6 7.5605
R4889 pm1.n5 pm1.t11 4.75058
R4890 pm1 pm1.t10 4.69308
R4891 pm1.n4 pm1.n3 1.9805
R4892 pm1.n3 pm1.n2 1.8905
R4893 pm2.n7 pm2.n6 38.0705
R4894 pm2.n0 pm2.t9 26.7442
R4895 pm2.n4 pm2.t5 19.5609
R4896 pm2 pm2.n9 16.6692
R4897 pm2.n2 pm2.t2 15.6997
R4898 pm2.n3 pm2.n2 14.7155
R4899 pm2.n3 pm2.t0 13.8997
R4900 pm2.n4 pm2.t4 13.7757
R4901 pm2.n2 pm2.t1 13.7649
R4902 pm2.n7 pm2.t6 13.7156
R4903 pm2.n1 pm2.n0 12.1055
R4904 pm2.n8 pm2.n1 10.8905
R4905 pm2.n9 pm2.n8 10.6205
R4906 pm2.n6 pm2.n3 9.3155
R4907 pm2.n5 pm2.t3 9.30085
R4908 pm2.n1 pm2.t11 9.28421
R4909 pm2.n0 pm2.t8 9.25904
R4910 pm2.n9 pm2.t7 9.25158
R4911 pm2.n5 pm2.n4 6.4805
R4912 pm2.n6 pm2.n5 6.1205
R4913 pm2 pm2.t10 4.69308
R4914 pm2.n8 pm2.n7 2.5205
R4915 iref_gate.n0 iref_gate.t3 155.671
R4916 iref_gate.n1 iref_gate.t2 38.5561
R4917 iref_gate.n0 iref_gate.t0 13.6303
R4918 iref_gate.n1 iref_gate.n0 5.9855
R4919 iref_gate iref_gate.t1 4.55384
R4920 iref_gate iref_gate.n1 4.50383
R4921 vbn.n0 vbn.t0 130.732
R4922 vbn.n1 vbn.t3 26.3118
R4923 vbn.n1 vbn.t1 17.7886
R4924 vbn.n0 vbn.t4 17.7886
R4925 vbn vbn.n2 10.4394
R4926 vbn.n2 vbn.n0 6.3005
R4927 vbn vbn.t2 5.1112
R4928 vbn.n2 vbn.n1 4.5005
R4929 psrg_m3_protected.n1 psrg_m3_protected.t3 33.6292
R4930 psrg_m3_protected.n0 psrg_m3_protected.t2 20.4823
R4931 psrg_m3_protected.n1 psrg_m3_protected.n0 11.2505
R4932 psrg_m3_protected.n0 psrg_m3_protected.t1 9.52742
R4933 psrg_m3_protected psrg_m3_protected.t0 4.81592
R4934 psrg_m3_protected psrg_m3_protected.n1 4.559
R4935 psrg_vnc.n0 psrg_vnc.t9 122.335
R4936 psrg_vnc.n9 psrg_vnc.n8 31.8605
R4937 psrg_vnc.n9 psrg_vnc.t10 28.7364
R4938 psrg_vnc psrg_vnc.t11 19.6464
R4939 psrg_vnc.n7 psrg_vnc.t7 17.666
R4940 psrg_vnc.n1 psrg_vnc.t8 15.9186
R4941 psrg_vnc.n8 psrg_vnc.t6 14.1938
R4942 psrg_vnc.n3 psrg_vnc.t0 13.8021
R4943 psrg_vnc.n1 psrg_vnc.t4 13.8021
R4944 psrg_vnc.n4 psrg_vnc.t1 13.7586
R4945 psrg_vnc.n2 psrg_vnc.t5 13.7586
R4946 psrg_vnc.n7 psrg_vnc.n6 13.0955
R4947 psrg_vnc psrg_vnc.n9 10.8376
R4948 psrg_vnc.n6 psrg_vnc.n5 9.4955
R4949 psrg_vnc.n6 psrg_vnc.t3 9.30213
R4950 psrg_vnc.n0 psrg_vnc.t2 9.30213
R4951 psrg_vnc.n8 psrg_vnc.n7 6.9305
R4952 psrg_vnc.n5 psrg_vnc.n0 4.6355
R4953 psrg_vnc.n3 psrg_vnc.n2 2.1605
R4954 psrg_vnc.n5 psrg_vnc.n4 2.0705
R4955 psrg_vnc.n4 psrg_vnc.n3 1.9805
R4956 psrg_vnc.n2 psrg_vnc.n1 1.9805
R4957 vbp_cas.n29 vbp_cas.n28 68.5805
R4958 vbp_cas.n13 vbp_cas.t0 31.3027
R4959 vbp_cas.n4 vbp_cas.t27 27.3674
R4960 vbp_cas.n0 vbp_cas.t21 27.3528
R4961 vbp_cas.n10 vbp_cas.t11 25.8124
R4962 vbp_cas.n25 vbp_cas.t3 25.5874
R4963 vbp_cas.n27 vbp_cas.t9 25.5874
R4964 vbp_cas.n21 vbp_cas.t7 25.5874
R4965 vbp_cas.n23 vbp_cas.t1 25.5874
R4966 vbp_cas.n5 vbp_cas.t29 24.6674
R4967 vbp_cas.n7 vbp_cas.t31 24.6674
R4968 vbp_cas.n3 vbp_cas.t25 24.6528
R4969 vbp_cas.n4 vbp_cas.t28 24.6224
R4970 vbp_cas.n6 vbp_cas.t30 24.6224
R4971 vbp_cas.n8 vbp_cas.t32 24.6224
R4972 vbp_cas.n0 vbp_cas.t22 24.5751
R4973 vbp_cas.n2 vbp_cas.t24 24.5751
R4974 vbp_cas.n17 vbp_cas.t13 24.0124
R4975 vbp_cas.n13 vbp_cas.t15 23.1124
R4976 vbp_cas.n14 vbp_cas.t17 23.1124
R4977 vbp_cas.n10 vbp_cas.t19 23.1124
R4978 vbp_cas.n18 vbp_cas.t5 23.1124
R4979 vbp_cas.n1 vbp_cas.t23 20.1528
R4980 vbp_cas.n9 vbp_cas.t12 16.8665
R4981 vbp_cas.n19 vbp_cas.t14 15.6333
R4982 vbp_cas vbp_cas.t26 15.5628
R4983 vbp_cas.n16 vbp_cas.t16 13.9041
R4984 vbp_cas.n12 vbp_cas.t18 13.8065
R4985 vbp_cas.n24 vbp_cas.t2 13.8031
R4986 vbp_cas.n28 vbp_cas.t10 13.8031
R4987 vbp_cas.n20 vbp_cas.t6 13.8031
R4988 vbp_cas.n9 vbp_cas.t20 13.7691
R4989 vbp_cas.n26 vbp_cas.t4 13.7433
R4990 vbp_cas.n22 vbp_cas.t8 13.7433
R4991 vbp_cas.n15 vbp_cas.n14 11.2955
R4992 vbp_cas.n11 vbp_cas.n10 11.2955
R4993 vbp_cas.n29 vbp_cas.n8 10.8005
R4994 vbp_cas.n1 vbp_cas.n0 7.3805
R4995 vbp_cas.n29 vbp_cas.n3 7.2005
R4996 vbp_cas.n2 vbp_cas.n1 7.2005
R4997 vbp_cas vbp_cas.n29 4.51287
R4998 vbp_cas.n3 vbp_cas.n2 2.8805
R4999 vbp_cas.n7 vbp_cas.n6 2.8805
R5000 vbp_cas.n5 vbp_cas.n4 2.8805
R5001 vbp_cas.n17 vbp_cas.n16 2.7905
R5002 vbp_cas.n8 vbp_cas.n7 2.7005
R5003 vbp_cas.n6 vbp_cas.n5 2.7005
R5004 vbp_cas.n14 vbp_cas.n13 2.7005
R5005 vbp_cas.n19 vbp_cas.n18 2.4305
R5006 vbp_cas.n12 vbp_cas.n11 1.9805
R5007 vbp_cas.n25 vbp_cas.n24 1.8905
R5008 vbp_cas.n27 vbp_cas.n26 1.8905
R5009 vbp_cas.n23 vbp_cas.n22 1.8905
R5010 vbp_cas.n21 vbp_cas.n20 1.8905
R5011 vbp_cas.n16 vbp_cas.n15 1.8905
R5012 vbp_cas.n18 vbp_cas.n17 1.8005
R5013 vbp_cas.n28 vbp_cas.n27 1.1705
R5014 vbp_cas.n24 vbp_cas.n23 1.1705
R5015 vbp_cas.n20 vbp_cas.n19 1.1705
R5016 vbp_cas.n15 vbp_cas.n12 1.0805
R5017 vbp_cas.n26 vbp_cas.n25 0.9905
R5018 vbp_cas.n22 vbp_cas.n21 0.9905
R5019 vbp_cas.n11 vbp_cas.n9 0.9005
R5020 xf1.n5 xf1.t2 42.9365
R5021 xf1.n5 xf1.n4 41.1755
R5022 xf1.n6 xf1.n5 36.0108
R5023 xf1.n8 xf1.n7 25.1105
R5024 xf1.n1 xf1.t3 21.2642
R5025 xf1.n0 xf1.t0 16.6724
R5026 xf1.n2 xf1.t5 13.8392
R5027 xf1.n0 xf1.t1 13.8392
R5028 xf1.n1 xf1.t4 13.8024
R5029 xf1.n9 xf1.t6 13.6715
R5030 xf1.n7 xf1.t9 13.6463
R5031 xf1 xf1.n9 13.0989
R5032 xf1.n7 xf1.n6 11.0115
R5033 xf1.n3 xf1.n2 10.1705
R5034 xf1.n4 xf1.t11 9.30241
R5035 xf1.n8 xf1.t8 9.14631
R5036 xf1.n3 xf1.n0 9.0905
R5037 xf1.n9 xf1.n8 6.6605
R5038 xf1 xf1.t7 4.5781
R5039 xf1.n6 xf1.t10 4.5781
R5040 xf1.n2 xf1.n1 2.8805
R5041 xf1.n4 xf1.n3 2.7905
R5042 xf2.n5 xf2.t5 44.4215
R5043 xf2.n6 xf2.n5 39.4205
R5044 xf2.n5 xf2.n4 33.3905
R5045 xf2.n4 xf2.t1 30.2624
R5046 xf2.n9 xf2.n8 29.6105
R5047 xf2 xf2.n9 22.1187
R5048 xf2.n0 xf2.t3 16.6724
R5049 xf2.n1 xf2.t9 15.0092
R5050 xf2.n0 xf2.t4 13.8392
R5051 xf2.n3 xf2.t11 13.8392
R5052 xf2.n8 xf2.t8 13.6463
R5053 xf2.n2 xf2.t10 9.30241
R5054 xf2.n7 xf2.t0 9.17148
R5055 xf2.n6 xf2.t7 9.14631
R5056 xf2.n1 xf2.n0 9.0905
R5057 xf2.n3 xf2.n2 7.3805
R5058 xf2.n8 xf2.n7 6.4805
R5059 xf2.n7 xf2.n6 5.9405
R5060 xf2.n4 xf2.n3 4.9505
R5061 xf2.n9 xf2.t6 4.64631
R5062 xf2 xf2.t2 4.5781
R5063 xf2.n2 xf2.n1 2.7905
R5064 vgn2.n1 vgn2.t10 49.7719
R5065 vgn2.n2 vgn2.n1 46.3055
R5066 vgn2.n8 vgn2.t8 33.1543
R5067 vgn2.n8 vgn2.n7 22.1072
R5068 vgn2.n7 vgn2.t0 20.3042
R5069 vgn2 vgn2.t9 19.6464
R5070 vgn2.n0 vgn2.t2 19.0975
R5071 vgn2.n2 vgn2.t6 18.6825
R5072 vgn2.n0 vgn2.t1 18.2924
R5073 vgn2.n5 vgn2.t4 18.2516
R5074 vgn2.n6 vgn2.t3 18.2489
R5075 vgn2.n3 vgn2.t5 18.2156
R5076 vgn2.n1 vgn2.t7 16.4921
R5077 vgn2 vgn2.n8 15.3438
R5078 vgn2.n3 vgn2.n2 4.5605
R5079 vgn2.n4 vgn2.n0 1.78717
R5080 vgn2.n4 vgn2.n3 1.7205
R5081 vgn2.n7 vgn2.n6 1.02717
R5082 vgn2.n6 vgn2.n5 0.813833
R5083 vgn2.n5 vgn2.n4 0.813833
R5084 vsp.n5 vsp.n4 37.1705
R5085 vsp.n10 vsp.n9 16.8305
R5086 vsp.n0 vsp.t3 16.2006
R5087 vsp.n4 vsp.t7 13.8156
R5088 vsp.n1 vsp.t13 13.7139
R5089 vsp.n2 vsp.t15 13.7139
R5090 vsp.n0 vsp.t14 13.686
R5091 vsp.n3 vsp.t1 13.686
R5092 vsp.n6 vsp.t12 13.6715
R5093 vsp.n13 vsp.t8 13.6715
R5094 vsp.n11 vsp.t9 13.6715
R5095 vsp.n8 vsp.t0 13.6715
R5096 vsp.n12 vsp.t4 13.6463
R5097 vsp.n10 vsp.t10 13.6463
R5098 vsp.n9 vsp.t6 13.6463
R5099 vsp.n7 vsp.t11 13.6463
R5100 vsp.n5 vsp.t5 13.6463
R5101 vsp vsp.n13 11.2737
R5102 vsp vsp.t2 4.5781
R5103 vsp.n3 vsp.n2 2.5205
R5104 vsp.n1 vsp.n0 2.5205
R5105 vsp.n4 vsp.n3 2.4305
R5106 vsp.n2 vsp.n1 2.3405
R5107 vsp.n7 vsp.n6 2.1605
R5108 vsp.n9 vsp.n8 2.1605
R5109 vsp.n12 vsp.n11 2.1605
R5110 vsp.n8 vsp.n7 1.9805
R5111 vsp.n11 vsp.n10 1.9805
R5112 vsp.n13 vsp.n12 1.9805
R5113 vsp.n6 vsp.n5 1.9805
R5114 v2.n4 v2.t4 65.501
R5115 v2.n5 v2.t3 65.4526
R5116 v2.n3 v2.t5 65.4526
R5117 v2.n2 v2.t6 60.9526
R5118 v2.n1 v2.t7 60.9526
R5119 v2.n1 v2.n0 54.8555
R5120 v2.n7 v2.n0 19.4405
R5121 v2.n0 v2.t2 15.4715
R5122 v2.n6 v2.t1 13.8293
R5123 v2.n2 v2.n1 13.0505
R5124 v2.n3 v2.n2 12.2855
R5125 v2.n6 v2.n5 9.32707
R5126 v2.n7 v2.n6 9.0455
R5127 v2.n5 v2.n4 5.8505
R5128 v2 v2.n7 5.774
R5129 v2 v2.t0 4.81592
R5130 v2.n4 v2.n3 1.8005
R5131 vaux.n0 vaux.t0 60.1892
R5132 vaux vaux.n0 19.7091
R5133 vaux.n0 vaux.t1 4.97375
R5134 vaux vaux.t2 4.93012
R5135 vx3 vx3.n4 34.3187
R5136 vx3.n5 vx3.t4 31.1652
R5137 vx3 vx3.n7 19.6205
R5138 vx3.n6 vx3.n5 18.4205
R5139 vx3.n7 vx3.t7 13.8364
R5140 vx3.n0 vx3.t9 13.3392
R5141 vx3.n0 vx3.t1 13.0962
R5142 vx3.n1 vx3.t3 11.7192
R5143 vx3.n1 vx3.t10 11.4762
R5144 vx3.n3 vx3.t0 10.6392
R5145 vx3.n3 vx3.t2 10.3962
R5146 vx3.n2 vx3.n0 9.61925
R5147 vx3.n6 vx3.t6 9.33641
R5148 vx3.n7 vx3.n6 9.3155
R5149 vx3 vx3.t8 4.76969
R5150 vx3.n5 vx3.t5 4.75991
R5151 vx3.n4 vx3.n2 4.57925
R5152 vx3.n2 vx3.n1 4.5005
R5153 vx3.n4 vx3.n3 4.5005
R5154 psrg_m3_feed.n1 psrg_m3_feed.n0 129.106
R5155 psrg_m3_feed.n7 psrg_m3_feed.t15 49.1087
R5156 psrg_m3_feed.n1 psrg_m3_feed.t9 47.7002
R5157 psrg_m3_feed.n2 psrg_m3_feed.t10 47.7002
R5158 psrg_m3_feed.n3 psrg_m3_feed.t11 47.7002
R5159 psrg_m3_feed.n5 psrg_m3_feed.t13 47.7002
R5160 psrg_m3_feed.n6 psrg_m3_feed.t14 47.7002
R5161 psrg_m3_feed.n13 psrg_m3_feed.t21 47.6777
R5162 psrg_m3_feed.n14 psrg_m3_feed.t22 47.6777
R5163 psrg_m3_feed.n15 psrg_m3_feed.t23 47.6777
R5164 psrg_m3_feed.n16 psrg_m3_feed.t24 47.6777
R5165 psrg_m3_feed.n17 psrg_m3_feed.t25 47.6777
R5166 psrg_m3_feed.n21 psrg_m3_feed.t26 47.6777
R5167 psrg_m3_feed.n7 psrg_m3_feed.t16 47.6688
R5168 psrg_m3_feed.n8 psrg_m3_feed.t17 47.6688
R5169 psrg_m3_feed.n10 psrg_m3_feed.t19 47.6688
R5170 psrg_m3_feed.n11 psrg_m3_feed.t20 47.6688
R5171 psrg_m3_feed.n4 psrg_m3_feed.t12 43.2002
R5172 psrg_m3_feed.n9 psrg_m3_feed.t18 43.1688
R5173 psrg_m3_feed.n18 psrg_m3_feed.t28 36.691
R5174 psrg_m3_feed.n18 psrg_m3_feed.t27 35.431
R5175 psrg_m3_feed.n0 psrg_m3_feed.t8 29.1043
R5176 psrg_m3_feed.n19 psrg_m3_feed.t7 26.7064
R5177 psrg_m3_feed psrg_m3_feed.n24 18.437
R5178 psrg_m3_feed.n23 psrg_m3_feed.t4 16.3114
R5179 psrg_m3_feed.n12 psrg_m3_feed.t2 15.8724
R5180 psrg_m3_feed.n20 psrg_m3_feed.n19 15.3905
R5181 psrg_m3_feed.n23 psrg_m3_feed.n22 15.3005
R5182 psrg_m3_feed.n13 psrg_m3_feed.n12 14.7605
R5183 psrg_m3_feed.n12 psrg_m3_feed.t1 13.8673
R5184 psrg_m3_feed.n0 psrg_m3_feed.t0 11.305
R5185 psrg_m3_feed.n24 psrg_m3_feed.n23 10.3505
R5186 psrg_m3_feed.n19 psrg_m3_feed.t3 9.33641
R5187 psrg_m3_feed.n24 psrg_m3_feed.t5 9.33641
R5188 psrg_m3_feed.n21 psrg_m3_feed.n20 8.8205
R5189 psrg_m3_feed.n10 psrg_m3_feed.n9 5.9405
R5190 psrg_m3_feed.n9 psrg_m3_feed.n8 5.9405
R5191 psrg_m3_feed.n5 psrg_m3_feed.n4 5.9405
R5192 psrg_m3_feed.n4 psrg_m3_feed.n3 5.9405
R5193 psrg_m3_feed.n22 psrg_m3_feed.n6 5.0405
R5194 psrg_m3_feed.n22 psrg_m3_feed.n21 4.8605
R5195 psrg_m3_feed psrg_m3_feed.t6 4.75991
R5196 psrg_m3_feed.n21 psrg_m3_feed.n17 1.4405
R5197 psrg_m3_feed.n17 psrg_m3_feed.n16 1.4405
R5198 psrg_m3_feed.n16 psrg_m3_feed.n15 1.4405
R5199 psrg_m3_feed.n15 psrg_m3_feed.n14 1.4405
R5200 psrg_m3_feed.n14 psrg_m3_feed.n13 1.4405
R5201 psrg_m3_feed.n11 psrg_m3_feed.n10 1.4405
R5202 psrg_m3_feed.n8 psrg_m3_feed.n7 1.4405
R5203 psrg_m3_feed.n6 psrg_m3_feed.n5 1.4405
R5204 psrg_m3_feed.n3 psrg_m3_feed.n2 1.4405
R5205 psrg_m3_feed.n2 psrg_m3_feed.n1 1.4405
R5206 psrg_m3_feed.n20 psrg_m3_feed.n18 1.1705
R5207 psrg_m3_feed.n22 psrg_m3_feed.n11 0.1805
R5208 vx2.n0 vx2.t6 39.3003
R5209 vx2.n8 vx2.n7 34.1431
R5210 vx2.n0 vx2.t7 19.4964
R5211 vx2.n2 vx2.n1 17.3255
R5212 vx2.n8 vx2.n2 13.8605
R5213 vx2.n6 vx2.t5 13.2762
R5214 vx2.n6 vx2.t4 12.7992
R5215 vx2.n3 vx2.t1 12.1962
R5216 vx2.n3 vx2.t0 11.7192
R5217 vx2.n1 vx2.n0 10.8905
R5218 vx2.n4 vx2.t3 10.5762
R5219 vx2.n4 vx2.t2 10.0992
R5220 vx2.n5 vx2.n3 9.61925
R5221 vx2.n1 vx2.t8 9.27752
R5222 vx2.n2 vx2.t9 9.27361
R5223 vx2.n7 vx2.n5 5.11925
R5224 vx2 vx2.t10 4.75991
R5225 vx2 vx2.n8 4.51028
R5226 vx2.n7 vx2.n6 4.5005
R5227 vx2.n5 vx2.n4 4.5005
R5228 vgn1.n3 vgn1.t0 119.844
R5229 vgn1.n7 vgn1.n6 46.8905
R5230 vgn1.n5 vgn1.t3 29.9964
R5231 vgn1.n6 vgn1.t1 28.6542
R5232 vgn1.n0 vgn1.t9 23.9614
R5233 vgn1 vgn1.n7 14.8603
R5234 vgn1.n4 vgn1.t2 13.9643
R5235 vgn1.n3 vgn1.t4 13.8744
R5236 vgn1.n0 vgn1.t6 13.7814
R5237 vgn1.n1 vgn1.t5 13.7775
R5238 vgn1.n2 vgn1.t7 13.7736
R5239 vgn1.n5 vgn1.n4 10.5755
R5240 vgn1.n2 vgn1.n1 4.8605
R5241 vgn1.n1 vgn1.n0 4.8155
R5242 vgn1 vgn1.t8 4.75991
R5243 vgn1.n7 vgn1.n2 2.4755
R5244 vgn1.n4 vgn1.n3 1.8905
R5245 vgn1.n6 vgn1.n5 0.5405
R5246 vx1.n8 vx1.n7 46.0231
R5247 vx1.n0 vx1.t6 37.6353
R5248 vx1.n1 vx1.n0 13.8605
R5249 vx1.n2 vx1.t9 13.8364
R5250 vx1.n4 vx1.t3 13.4562
R5251 vx1.n4 vx1.t2 13.3392
R5252 vx1 vx1.n8 12.137
R5253 vx1.n6 vx1.t5 11.8362
R5254 vx1.n6 vx1.t4 11.7192
R5255 vx1.n2 vx1.n1 10.6655
R5256 vx1.n3 vx1.t1 10.2162
R5257 vx1.n3 vx1.t0 10.0992
R5258 vx1.n0 vx1.t7 9.33641
R5259 vx1.n1 vx1.t8 9.33641
R5260 vx1.n5 vx1.n3 9.07925
R5261 vx1.n8 vx1.n2 5.5805
R5262 vx1.n7 vx1.n5 5.11925
R5263 vx1 vx1.t10 4.75991
R5264 vx1.n7 vx1.n6 4.5005
R5265 vx1.n5 vx1.n4 4.5005
R5266 su_state.n0 su_state.t0 133.34
R5267 su_state.n0 su_state.t2 72.447
R5268 su_state su_state.t1 5.6975
R5269 su_state su_state.n0 2.69913
R5270 vbp_tail.n11 vbp_tail.n10 76.0955
R5271 vbp_tail.n4 vbp_tail.t13 36.0436
R5272 vbp_tail.n0 vbp_tail.t7 34.687
R5273 vbp_tail.n6 vbp_tail.t6 34.6554
R5274 vbp_tail.n2 vbp_tail.t10 32.3785
R5275 vbp_tail.n1 vbp_tail.t9 32.3515
R5276 vbp_tail.n0 vbp_tail.t8 32.3436
R5277 vbp_tail.n3 vbp_tail.t11 32.3337
R5278 vbp_tail.n10 vbp_tail.t4 23.8189
R5279 vbp_tail vbp_tail.t12 23.284
R5280 vbp_tail.n4 vbp_tail.t0 23.1246
R5281 vbp_tail.n5 vbp_tail.t2 23.1102
R5282 vbp_tail.n6 vbp_tail.t1 15.0643
R5283 vbp_tail.n9 vbp_tail.t5 13.9935
R5284 vbp_tail.n8 vbp_tail.t3 13.8613
R5285 vbp_tail vbp_tail.n11 9.05298
R5286 vbp_tail.n9 vbp_tail.n8 2.4305
R5287 vbp_tail.n5 vbp_tail.n4 2.3405
R5288 vbp_tail.n11 vbp_tail.n3 2.3405
R5289 vbp_tail.n3 vbp_tail.n2 2.3405
R5290 vbp_tail.n1 vbp_tail.n0 2.3405
R5291 vbp_tail.n2 vbp_tail.n1 2.1605
R5292 vbp_tail.n7 vbp_tail.n5 1.7105
R5293 vbp_tail.n10 vbp_tail.n9 1.3505
R5294 vbp_tail.n8 vbp_tail.n7 0.8105
R5295 vbp_tail.n7 vbp_tail.n6 0.5405
R5296 vbp_bias.n4 vbp_bias.t0 25.8965
R5297 vbp_bias.n11 vbp_bias.t12 25.8785
R5298 vbp_bias.n0 vbp_bias.t27 25.7583
R5299 vbp_bias.n14 vbp_bias.t14 25.5095
R5300 vbp_bias.n12 vbp_bias.t16 25.469
R5301 vbp_bias.n5 vbp_bias.t4 25.4377
R5302 vbp_bias.n9 vbp_bias.t6 24.0965
R5303 vbp_bias.n11 vbp_bias.t10 23.1627
R5304 vbp_bias.n10 vbp_bias.t8 23.1573
R5305 vbp_bias.n4 vbp_bias.t2 23.1403
R5306 vbp_bias.n3 vbp_bias.t21 16.8291
R5307 vbp_bias.n21 vbp_bias.t18 15.8765
R5308 vbp_bias.n21 vbp_bias.n20 14.7155
R5309 vbp_bias.n5 vbp_bias.t5 14.6957
R5310 vbp_bias.n12 vbp_bias.t17 14.652
R5311 vbp_bias.n24 vbp_bias.n23 14.2205
R5312 vbp_bias.n2 vbp_bias.t24 13.9381
R5313 vbp_bias.n0 vbp_bias.t26 13.9381
R5314 vbp_bias.n20 vbp_bias.t7 13.887
R5315 vbp_bias.n25 vbp_bias.t23 13.8783
R5316 vbp_bias.n1 vbp_bias.t25 13.8783
R5317 vbp_bias.n8 vbp_bias.t1 13.867
R5318 vbp_bias.n3 vbp_bias.t20 13.8065
R5319 vbp_bias.n15 vbp_bias.t13 13.7957
R5320 vbp_bias.n16 vbp_bias.t11 13.7957
R5321 vbp_bias.n13 vbp_bias.t15 13.7481
R5322 vbp_bias.n18 vbp_bias.t9 13.7481
R5323 vbp_bias.n6 vbp_bias.t3 13.7311
R5324 vbp_bias vbp_bias.n25 12.047
R5325 vbp_bias.n2 vbp_bias.n1 11.8805
R5326 vbp_bias.n1 vbp_bias.n0 11.7005
R5327 vbp_bias.n23 vbp_bias.t19 9.26915
R5328 vbp_bias.n24 vbp_bias.n2 7.2005
R5329 vbp_bias vbp_bias.t22 4.72664
R5330 vbp_bias.n23 vbp_bias.n22 4.6355
R5331 vbp_bias.n25 vbp_bias.n24 4.5005
R5332 vbp_bias.n16 vbp_bias.n15 3.0605
R5333 vbp_bias.n22 vbp_bias.n3 2.7905
R5334 vbp_bias.n9 vbp_bias.n8 2.7905
R5335 vbp_bias.n19 vbp_bias.n10 2.2505
R5336 vbp_bias.n7 vbp_bias.n4 2.2505
R5337 vbp_bias.n17 vbp_bias.n11 2.2505
R5338 vbp_bias.n6 vbp_bias.n5 1.9805
R5339 vbp_bias.n18 vbp_bias.n17 1.9805
R5340 vbp_bias.n15 vbp_bias.n14 1.9805
R5341 vbp_bias.n13 vbp_bias.n12 1.9805
R5342 vbp_bias.n20 vbp_bias.n19 1.8905
R5343 vbp_bias.n8 vbp_bias.n7 1.8905
R5344 vbp_bias.n10 vbp_bias.n9 1.8005
R5345 vbp_bias.n22 vbp_bias.n21 0.9005
R5346 vbp_bias.n19 vbp_bias.n18 0.9005
R5347 vbp_bias.n7 vbp_bias.n6 0.9005
R5348 vbp_bias.n17 vbp_bias.n16 0.9005
R5349 vbp_bias.n14 vbp_bias.n13 0.9005
R5350 vbn_sink.n28 vbn_sink.n27 47.3855
R5351 vbn_sink.n24 vbn_sink.n23 46.8905
R5352 vbn_sink.n0 vbn_sink.t21 24.8377
R5353 vbn_sink.n4 vbn_sink.t27 24.8242
R5354 vbn_sink.n0 vbn_sink.t22 22.0027
R5355 vbn_sink.n2 vbn_sink.t24 22.0027
R5356 vbn_sink.n4 vbn_sink.t28 21.9892
R5357 vbn_sink.n6 vbn_sink.t30 21.9892
R5358 vbn_sink.n1 vbn_sink.t23 21.9577
R5359 vbn_sink.n3 vbn_sink.t25 21.9577
R5360 vbn_sink.n5 vbn_sink.t29 21.9442
R5361 vbn_sink.n7 vbn_sink.t31 21.9442
R5362 vbn_sink.n26 vbn_sink.t17 20.1359
R5363 vbn_sink.n24 vbn_sink.t15 20.0583
R5364 vbn_sink.n28 vbn_sink.t32 17.4892
R5365 vbn_sink.n12 vbn_sink.t20 16.863
R5366 vbn_sink.n8 vbn_sink.t3 16.6468
R5367 vbn_sink.n25 vbn_sink.t16 15.5285
R5368 vbn_sink.n27 vbn_sink.t18 15.5033
R5369 vbn_sink.n15 vbn_sink.t5 13.938
R5370 vbn_sink.n23 vbn_sink.t8 13.9355
R5371 vbn_sink.n22 vbn_sink.t6 13.8379
R5372 vbn_sink.n20 vbn_sink.t9 13.8379
R5373 vbn_sink.n8 vbn_sink.t13 13.8042
R5374 vbn_sink.n10 vbn_sink.t11 13.8042
R5375 vbn_sink.n13 vbn_sink.t1 13.803
R5376 vbn_sink.n21 vbn_sink.t7 13.8005
R5377 vbn_sink.n19 vbn_sink.t10 13.8005
R5378 vbn_sink.n9 vbn_sink.t14 13.7668
R5379 vbn_sink.n11 vbn_sink.t12 13.7668
R5380 vbn_sink.n12 vbn_sink.t0 13.7373
R5381 vbn_sink.n14 vbn_sink.t4 13.7373
R5382 vbn_sink vbn_sink.t26 12.8857
R5383 vbn_sink.n16 vbn_sink.n15 9.6755
R5384 vbn_sink.n18 vbn_sink.n17 9.6755
R5385 vbn_sink.n18 vbn_sink.t2 9.33792
R5386 vbn_sink.n16 vbn_sink.t19 9.30417
R5387 vbn_sink vbn_sink.n30 9.2975
R5388 vbn_sink.n19 vbn_sink.n18 7.3805
R5389 vbn_sink.n30 vbn_sink.n29 4.8605
R5390 vbn_sink.n17 vbn_sink.n16 4.6355
R5391 vbn_sink.n29 vbn_sink.n28 4.5005
R5392 vbn_sink.n14 vbn_sink.n13 3.0605
R5393 vbn_sink.n11 vbn_sink.n10 3.0605
R5394 vbn_sink.n9 vbn_sink.n8 3.0605
R5395 vbn_sink.n20 vbn_sink.n19 3.0605
R5396 vbn_sink.n22 vbn_sink.n21 3.0605
R5397 vbn_sink.n13 vbn_sink.n12 2.8805
R5398 vbn_sink.n10 vbn_sink.n9 2.8805
R5399 vbn_sink.n21 vbn_sink.n20 2.8805
R5400 vbn_sink.n29 vbn_sink.n7 2.8805
R5401 vbn_sink.n6 vbn_sink.n5 2.8805
R5402 vbn_sink.n2 vbn_sink.n1 2.8805
R5403 vbn_sink.n15 vbn_sink.n14 2.7905
R5404 vbn_sink.n17 vbn_sink.n11 2.7905
R5405 vbn_sink.n23 vbn_sink.n22 2.7905
R5406 vbn_sink.n7 vbn_sink.n6 2.7005
R5407 vbn_sink.n5 vbn_sink.n4 2.7005
R5408 vbn_sink.n30 vbn_sink.n3 2.7005
R5409 vbn_sink.n3 vbn_sink.n2 2.7005
R5410 vbn_sink.n1 vbn_sink.n0 2.7005
R5411 vbn_sink.n26 vbn_sink.n25 1.8005
R5412 vbn_sink.n27 vbn_sink.n26 1.0805
R5413 vbn_sink.n25 vbn_sink.n24 0.9005
R5414 b3_b b3_b.t2 413.057
R5415 b3_b.n0 b3_b.t0 29.9251
R5416 b3_b.n0 b3_b.t1 18.2995
R5417 b3_b b3_b.n0 11.9367
R5418 b1_b.n1 b1_b.t2 552.784
R5419 b1_b.n2 b1_b.t3 552.491
R5420 b1_b b1_b.t4 543.413
R5421 b1_b.n0 b1_b.t1 19.0513
R5422 b1_b.n0 b1_b.t0 17.9371
R5423 b1_b b1_b.n2 9.91021
R5424 b1_b.n1 b1_b.n0 7.6505
R5425 b1_b.n2 b1_b.n1 0.7205
R5426 b6_b b6_b.t2 70.8681
R5427 b6_b.n0 b6_b.t0 33.2506
R5428 b6_b.n0 b6_b.t1 26.6113
R5429 b6_b b6_b.n0 9.06575
R5430 b4_b b4_b.t2 217.519
R5431 b4_b.n0 b4_b.t1 38.4035
R5432 b4_b.n0 b4_b.t0 20.5606
R5433 b4_b b4_b.n0 19.2897
R5434 b0_b.n1 b0_b.t2 552.495
R5435 b0_b.n3 b0_b.t4 552.482
R5436 b0_b.n2 b0_b.t3 552.424
R5437 b0_b.n4 b0_b.t5 547.922
R5438 b0_b.n5 b0_b.t6 547.922
R5439 b0_b b0_b.t7 543.413
R5440 b0_b.n0 b0_b.t0 21.7749
R5441 b0_b.n0 b0_b.t1 18.3369
R5442 b0_b b0_b.n5 14.4612
R5443 b0_b.n5 b0_b.n4 10.0805
R5444 b0_b.n1 b0_b.n0 5.8055
R5445 b0_b.n4 b0_b.n3 5.4005
R5446 b0_b.n3 b0_b.n2 1.0805
R5447 b0_b.n2 b0_b.n1 1.0805
R5448 rbit0top.n0 rbit0top.t3 47.8149
R5449 rbit0top.n0 rbit0top.t0 27.35
R5450 rbit0top.n1 rbit0top.n0 24.7955
R5451 rbit0top.n5 rbit0top.t2 14.9729
R5452 rbit0top.n2 rbit0top.t4 13.6904
R5453 rbit0top.n5 rbit0top.t1 13.6898
R5454 rbit0top.n4 rbit0top.t6 13.6634
R5455 rbit0top.n7 rbit0top.t9 13.6544
R5456 rbit0top.n3 rbit0top.t7 13.6145
R5457 rbit0top rbit0top.n7 10.3573
R5458 rbit0top.n1 rbit0top.t5 9.11555
R5459 rbit0top.n2 rbit0top.n1 5.7605
R5460 rbit0top rbit0top.t8 4.60718
R5461 rbit0top.n6 rbit0top.n5 2.9396
R5462 rbit0top.n4 rbit0top.n3 1.2605
R5463 rbit0top.n3 rbit0top.n2 1.0805
R5464 rbit0top.n6 rbit0top.n4 0.6755
R5465 rbit0top.n7 rbit0top.n6 0.1355
R5466 rbit1top.n2 rbit1top.n1 31.5783
R5467 rbit1top.n1 rbit1top.t1 22.274
R5468 rbit1top.n0 rbit1top.t3 14.8598
R5469 rbit1top.n7 rbit1top.t12 13.8254
R5470 rbit1top.n9 rbit1top.t10 13.7984
R5471 rbit1top.n10 rbit1top.t9 13.7894
R5472 rbit1top.n2 rbit1top.t7 13.7888
R5473 rbit1top.n0 rbit1top.t2 13.7579
R5474 rbit1top.n8 rbit1top.t11 13.7495
R5475 rbit1top.n3 rbit1top.t4 13.6949
R5476 rbit1top.n5 rbit1top.t6 13.6724
R5477 rbit1top.n6 rbit1top.t13 13.6155
R5478 rbit1top.n4 rbit1top.t5 13.6152
R5479 rbit1top.n11 rbit1top.n0 10.3055
R5480 rbit1top.n1 rbit1top.t0 10.142
R5481 rbit1top rbit1top.n11 9.00729
R5482 rbit1top rbit1top.t8 4.60718
R5483 rbit1top.n3 rbit1top.n2 1.5305
R5484 rbit1top.n5 rbit1top.n4 1.2605
R5485 rbit1top.n4 rbit1top.n3 1.2605
R5486 rbit1top.n11 rbit1top.n10 1.2155
R5487 rbit1top.n7 rbit1top.n6 1.1705
R5488 rbit1top.n9 rbit1top.n8 1.0805
R5489 rbit1top.n6 rbit1top.n5 1.0805
R5490 rbit1top.n10 rbit1top.n9 0.9005
R5491 rbit1top.n8 rbit1top.n7 0.9005
R5492 rbit2top.n1 rbit2top.n0 34.9521
R5493 rbit2top.n0 rbit2top.t1 25.739
R5494 rbit2top.n4 rbit2top.t9 15.0003
R5495 rbit2top.n5 rbit2top.t4 13.9426
R5496 rbit2top.n4 rbit2top.t2 13.9336
R5497 rbit2top.n6 rbit2top.t0 13.8011
R5498 rbit2top.n3 rbit2top.t6 13.7502
R5499 rbit2top.n2 rbit2top.t7 13.6949
R5500 rbit2top.n7 rbit2top.n6 11.9255
R5501 rbit2top.n6 rbit2top.n5 10.6655
R5502 rbit2top.n0 rbit2top.t3 10.106
R5503 rbit2top rbit2top.n7 9.20075
R5504 rbit2top.n1 rbit2top.t8 9.11557
R5505 rbit2top.n2 rbit2top.n1 5.5805
R5506 rbit2top rbit2top.t5 4.60718
R5507 rbit2top.n3 rbit2top.n2 1.1705
R5508 rbit2top.n7 rbit2top.n3 1.0805
R5509 rbit2top.n5 rbit2top.n4 0.9005
R5510 b2_b.n1 b2_b.t2 291.709
R5511 b2_b.n2 b2_b.t3 291.709
R5512 b2_b b2_b.t4 282.7
R5513 b2_b.n0 b2_b.t0 29.7878
R5514 b2_b.n1 b2_b.n0 29.7455
R5515 b2_b b2_b.n2 9.96125
R5516 b2_b.n0 b2_b.t1 9.37191
R5517 b2_b.n2 b2_b.n1 1.0805
R5518 rbit6top.n2 rbit6top.t4 20.1082
R5519 rbit6top rbit6top.n3 16.4243
R5520 rbit6top.n2 rbit6top.t1 16.2905
R5521 rbit6top.n3 rbit6top.n0 11.2267
R5522 rbit6top.n3 rbit6top.t5 10.197
R5523 rbit6top.n1 rbit6top.n2 9.5405
R5524 rbit6top.n1 rbit6top.t3 9.02203
R5525 rbit6top.n1 rbit6top.n0 4.4644
R5526 rbit6top rbit6top.t0 5.06817
R5527 rbit6top.n0 rbit6top.t2 17.5032
R5528 rbit5top.n2 rbit5top.n1 30.1505
R5529 rbit5top rbit5top.t2 29.2375
R5530 rbit5top.n1 rbit5top.t1 28.961
R5531 rbit5top rbit5top.n2 16.7383
R5532 rbit5top.n2 rbit5top.n0 12.9155
R5533 rbit5top.n0 rbit5top.t0 11.3205
R5534 rbit5top.n0 rbit5top.t3 9.9581
R5535 rbit5top.n1 rbit5top.t5 5.59703
R5536 rbit5top rbit5top.t4 4.78433
R5537 b5_b b5_b.t2 119.752
R5538 b5_b b5_b.n0 34.8211
R5539 b5_b.n0 b5_b.t0 31.9875
R5540 b5_b.n0 b5_b.t1 9.33465
R5541 rbit3top.n3 rbit3top.n2 34.6603
R5542 rbit3top.n0 rbit3top.t2 18.735
R5543 rbit3top.n2 rbit3top.t1 18.322
R5544 rbit3top.n2 rbit3top.t4 15.7326
R5545 rbit3top.n5 rbit3top.n4 15.2105
R5546 rbit3top.n0 rbit3top.t5 13.9653
R5547 rbit3top.n4 rbit3top.t7 13.8076
R5548 rbit3top.n1 rbit3top.t6 13.7986
R5549 rbit3top rbit3top.n5 12.5895
R5550 rbit3top.n5 rbit3top.t0 9.43613
R5551 rbit3top rbit3top.t3 4.64242
R5552 rbit3top.n1 rbit3top.n0 1.0805
R5553 rbit3top.n3 rbit3top.n1 0.9905
R5554 rbit3top.n4 rbit3top.n3 0.1355
R5555 rbit4top.n2 rbit4top.t5 31.67
R5556 rbit4top.n3 rbit4top.n2 20.2505
R5557 rbit4top.n0 rbit4top.t0 17.61
R5558 rbit4top.n1 rbit4top.n0 17.0555
R5559 rbit4top.n0 rbit4top.t1 14.5188
R5560 rbit4top.n1 rbit4top.t2 13.9981
R5561 rbit4top.n3 rbit4top.n1 12.2405
R5562 rbit4top.n2 rbit4top.t4 10.097
R5563 rbit4top rbit4top.t3 4.64242
R5564 rbit4top rbit4top.n3 4.53446
R5565 vbn_fold.n13 vbn_fold.n12 129.555
R5566 vbn_fold.n1 vbn_fold.n0 53.9105
R5567 vbn_fold.n1 vbn_fold.t14 25.9901
R5568 vbn_fold.n0 vbn_fold.t12 17.6066
R5569 vbn_fold vbn_fold.t15 16.9451
R5570 vbn_fold.n2 vbn_fold.t0 16.6249
R5571 vbn_fold.n0 vbn_fold.t13 16.0915
R5572 vbn_fold.n6 vbn_fold.t7 13.9378
R5573 vbn_fold.n12 vbn_fold.t4 13.8799
R5574 vbn_fold.n11 vbn_fold.t5 13.8028
R5575 vbn_fold.n9 vbn_fold.t11 13.8028
R5576 vbn_fold.n4 vbn_fold.t9 13.8028
R5577 vbn_fold.n2 vbn_fold.t1 13.8028
R5578 vbn_fold.n10 vbn_fold.t10 13.7449
R5579 vbn_fold.n8 vbn_fold.t2 13.7449
R5580 vbn_fold.n5 vbn_fold.t6 13.7449
R5581 vbn_fold.n3 vbn_fold.t8 13.7449
R5582 vbn_fold.n7 vbn_fold.n6 9.6755
R5583 vbn_fold.n7 vbn_fold.t3 9.30284
R5584 vbn_fold vbn_fold.n13 9.0455
R5585 vbn_fold.n8 vbn_fold.n7 7.3805
R5586 vbn_fold.n3 vbn_fold.n2 3.0605
R5587 vbn_fold.n5 vbn_fold.n4 3.0605
R5588 vbn_fold.n9 vbn_fold.n8 3.0605
R5589 vbn_fold.n11 vbn_fold.n10 3.0605
R5590 vbn_fold.n4 vbn_fold.n3 2.8805
R5591 vbn_fold.n10 vbn_fold.n9 2.8805
R5592 vbn_fold.n6 vbn_fold.n5 2.7905
R5593 vbn_fold.n12 vbn_fold.n11 2.7905
R5594 vbn_fold.n13 vbn_fold.n1 2.3405
R5595 vbn_i.n1 vbn_i.n0 128.25
R5596 vbn_i.n6 vbn_i.n5 61.5605
R5597 vbn_i.n0 vbn_i.t2 25.027
R5598 vbn_i.n4 vbn_i.t10 18.7019
R5599 vbn_i.n0 vbn_i.t8 18.4407
R5600 vbn_i.n2 vbn_i.t3 18.0635
R5601 vbn_i.n3 vbn_i.t9 16.3752
R5602 vbn_i.n9 vbn_i.n8 16.2005
R5603 vbn_i vbn_i.n9 14.8944
R5604 vbn_i.n8 vbn_i.t0 13.8164
R5605 vbn_i.n9 vbn_i.t7 13.8164
R5606 vbn_i.n7 vbn_i.t6 13.7791
R5607 vbn_i.n7 vbn_i.n6 13.1405
R5608 vbn_i.n2 vbn_i.n1 11.0705
R5609 vbn_i.n5 vbn_i.t11 10.307
R5610 vbn_i.n3 vbn_i.n2 9.6755
R5611 vbn_i.n6 vbn_i.t5 9.31644
R5612 vbn_i.n4 vbn_i.n3 8.8205
R5613 vbn_i.n5 vbn_i.n4 7.0205
R5614 vbn_i.n1 vbn_i.t4 5.16057
R5615 vbn_i vbn_i.t1 4.72757
R5616 vbn_i.n8 vbn_i.n7 2.8805
R5617 vbp_i.n0 vbp_i.t11 313.841
R5618 vbp_i.n0 vbp_i.t12 312.521
R5619 vbp_i.n7 vbp_i.t19 31.7827
R5620 vbp_i.n2 vbp_i.t14 31.6027
R5621 vbp_i.n4 vbp_i.t16 31.6027
R5622 vbp_i.n6 vbp_i.t18 31.6027
R5623 vbp_i.n1 vbp_i.t13 31.5532
R5624 vbp_i.n3 vbp_i.t15 31.5532
R5625 vbp_i.n5 vbp_i.t17 31.5532
R5626 vbp_i.n12 vbp_i.t23 26.033
R5627 vbp_i.n16 vbp_i.t29 26.0263
R5628 vbp_i.n23 vbp_i.t40 26.0198
R5629 vbp_i.n27 vbp_i.t46 26.0198
R5630 vbp_i.n32 vbp_i.t56 25.9418
R5631 vbp_i.n20 vbp_i.t35 25.8215
R5632 vbp_i.n54 vbp_i.n11 23.6705
R5633 vbp_i.n12 vbp_i.t24 23.153
R5634 vbp_i.n13 vbp_i.t25 23.153
R5635 vbp_i.n14 vbp_i.t26 23.153
R5636 vbp_i.n15 vbp_i.t27 23.153
R5637 vbp_i.n16 vbp_i.t30 23.1463
R5638 vbp_i.n17 vbp_i.t31 23.1463
R5639 vbp_i.n18 vbp_i.t32 23.1463
R5640 vbp_i.n19 vbp_i.t33 23.1463
R5641 vbp_i.n52 vbp_i.t34 23.1463
R5642 vbp_i.n23 vbp_i.t41 23.1398
R5643 vbp_i.n24 vbp_i.t42 23.1398
R5644 vbp_i.n25 vbp_i.t43 23.1398
R5645 vbp_i.n26 vbp_i.t44 23.1398
R5646 vbp_i.n48 vbp_i.t45 23.1398
R5647 vbp_i.n28 vbp_i.t48 23.1398
R5648 vbp_i.n30 vbp_i.t50 23.1398
R5649 vbp_i.n27 vbp_i.t47 23.1398
R5650 vbp_i.n29 vbp_i.t49 23.1398
R5651 vbp_i.n31 vbp_i.t51 23.1398
R5652 vbp_i.n20 vbp_i.t36 23.1215
R5653 vbp_i.n21 vbp_i.t37 23.1215
R5654 vbp_i.n22 vbp_i.t38 23.1215
R5655 vbp_i.n50 vbp_i.t39 23.1215
R5656 vbp_i.n37 vbp_i.t5 23.0618
R5657 vbp_i.n35 vbp_i.t3 23.0618
R5658 vbp_i.n34 vbp_i.t55 23.0618
R5659 vbp_i.n32 vbp_i.t1 23.0618
R5660 vbp_i.n45 vbp_i.t52 23.0618
R5661 vbp_i.n42 vbp_i.t9 23.0618
R5662 vbp_i.n41 vbp_i.t7 23.0618
R5663 vbp_i.n40 vbp_i.t53 23.0618
R5664 vbp_i.n39 vbp_i.t54 23.0618
R5665 vbp_i.n10 vbp_i.n9 21.3755
R5666 vbp_i.n11 vbp_i.n10 21.3305
R5667 vbp_i.n49 vbp_i.n48 18.0005
R5668 vbp_i.n1 vbp_i.n0 17.0105
R5669 vbp_i.n43 vbp_i.t8 16.6064
R5670 vbp_i.n38 vbp_i.t6 15.9314
R5671 vbp_i.n36 vbp_i.t4 15.8941
R5672 vbp_i.n33 vbp_i.t2 15.8941
R5673 vbp_i.n11 vbp_i.t22 14.9342
R5674 vbp_i vbp_i.t28 14.0765
R5675 vbp_i.n10 vbp_i.t0 14.0571
R5676 vbp_i.n9 vbp_i.t21 14.0084
R5677 vbp_i.n43 vbp_i.t10 13.9141
R5678 vbp_i.n8 vbp_i.t20 13.8092
R5679 vbp_i.n46 vbp_i.n45 13.7705
R5680 vbp_i vbp_i.n54 9.077
R5681 vbp_i.n53 vbp_i.n52 5.5805
R5682 vbp_i.n51 vbp_i.n50 5.4005
R5683 vbp_i.n7 vbp_i.n6 5.2205
R5684 vbp_i.n39 vbp_i.n38 4.8605
R5685 vbp_i.n46 vbp_i.n31 4.4105
R5686 vbp_i.n40 vbp_i.n39 2.8805
R5687 vbp_i.n42 vbp_i.n41 2.8805
R5688 vbp_i.n35 vbp_i.n34 2.8805
R5689 vbp_i.n25 vbp_i.n24 2.8805
R5690 vbp_i.n21 vbp_i.n20 2.8805
R5691 vbp_i.n18 vbp_i.n17 2.8805
R5692 vbp_i.n14 vbp_i.n13 2.8805
R5693 vbp_i.n31 vbp_i.n30 2.8805
R5694 vbp_i.n29 vbp_i.n28 2.8805
R5695 vbp_i.n41 vbp_i.n40 2.7005
R5696 vbp_i.n47 vbp_i.n26 2.7005
R5697 vbp_i.n26 vbp_i.n25 2.7005
R5698 vbp_i.n24 vbp_i.n23 2.7005
R5699 vbp_i.n22 vbp_i.n21 2.7005
R5700 vbp_i.n51 vbp_i.n19 2.7005
R5701 vbp_i.n19 vbp_i.n18 2.7005
R5702 vbp_i.n17 vbp_i.n16 2.7005
R5703 vbp_i.n53 vbp_i.n15 2.7005
R5704 vbp_i.n15 vbp_i.n14 2.7005
R5705 vbp_i.n13 vbp_i.n12 2.7005
R5706 vbp_i.n30 vbp_i.n29 2.7005
R5707 vbp_i.n28 vbp_i.n27 2.7005
R5708 vbp_i.n8 vbp_i.n7 2.2055
R5709 vbp_i.n6 vbp_i.n5 1.9805
R5710 vbp_i.n4 vbp_i.n3 1.9805
R5711 vbp_i.n2 vbp_i.n1 1.9805
R5712 vbp_i.n44 vbp_i.n43 1.8905
R5713 vbp_i.n45 vbp_i.n44 1.8005
R5714 vbp_i.n34 vbp_i.n33 1.8005
R5715 vbp_i.n37 vbp_i.n36 1.8005
R5716 vbp_i.n49 vbp_i.n22 1.8005
R5717 vbp_i.n5 vbp_i.n4 1.8005
R5718 vbp_i.n3 vbp_i.n2 1.8005
R5719 vbp_i.n9 vbp_i.n8 1.6655
R5720 vbp_i.n38 vbp_i.n37 1.0805
R5721 vbp_i.n50 vbp_i.n49 1.0805
R5722 vbp_i.n47 vbp_i.n46 0.9905
R5723 vbp_i.n44 vbp_i.n42 0.9005
R5724 vbp_i.n33 vbp_i.n32 0.9005
R5725 vbp_i.n36 vbp_i.n35 0.9005
R5726 vbp_i.n48 vbp_i.n47 0.1805
R5727 vbp_i.n52 vbp_i.n51 0.1805
R5728 vbp_i.n54 vbp_i.n53 0.1805
C0 b2 rbit5top 0.15945f
C1 psrg_vnc psrg_m3_protected 1.42805f
C2 b1 rbit1top 0.8303f
C3 iref_gate vbn_i 0.44342f
C4 psrg_m3_feed v1 0.30578f
C5 b1 rbit2top 0.99261f
C6 vgn2 pm1 1.18258f
C7 xf2 pm2 0.45658f
C8 vbp_cas v1 2.35996f
C9 bgsu1 psrg_m3_feed 12.1311f
C10 vq3 v1 0.49113f
C11 y1 avdd 50.7803f
C12 b6 vq3 0.3603f
C13 vref rbit6top 0.14357f
C14 b3 b2 0.52826f
C15 avdd vref 42.3999f
C16 dvss b1 1.55352f
C17 xf2 iref_gate 5.31953f
C18 vbn aux_gate 0.13675f
C19 vref vbn_i 0.15089f
C20 vref rbit5top 0.11009f
C21 auxsu1 bgsu1 4.12461f
C22 vsu avdd 3.76296f
C23 vref vgn1 1.04938f
C24 vbp_cas pm2 9.40883f
C25 vgn2 psrg_mf1_protected 0.10811f
C26 xf1 pm1 0.25267f
C27 vref b1_b 0.46737f
C28 b1 b3_b 0.19795f
C29 vsua vbn_fold 0.33308f
C30 vref vcasp 8.70622f
C31 b2 vq3 0.53362f
C32 b0 b2 0.23544f
C33 b3 vref 0.16929f
C34 vbp_cas iref_gate 0.78455f
C35 vx3 avdd 26.3462f
C36 psrg_vnc vbn 14.1477f
C37 b2_b b0_b 0.36378f
C38 psrg_mf1_protected vbn_fold 1.13136f
C39 vaux v2 0.17419f
C40 vaux vbp_i 0.34518f
C41 dvdd b2_b 2.9187f
C42 net4 v1 0.12861f
C43 rbit6top b0_b 0.45445f
C44 dvdd b4_b 2.04749f
C45 avdd vsu2 0.6402f
C46 v2 vsp 11.0642f
C47 v2 vsu1 0.11888f
C48 dvdd rbit6top 3.48836f
C49 dvdd avdd 0.1297f
C50 vref psrg_m3_feed 2.17415f
C51 vbp_i vsu1 0.3328f
C52 vbn_i vsu2 0.30498f
C53 rbit6top rbit0top 0.1802f
C54 rbit5top b0_b 0.12174f
C55 b5_b b4_b 0.1403f
C56 vx3 vgn1 1.01119f
C57 avdd rbit0top 0.46188f
C58 vbp_cas y1 8.24885f
C59 v2 avdd 19.3684f
C60 vref rfix0 0.48258f
C61 avdd vbp_i 0.21074p
C62 vref rfix2 0.48703f
C63 rbit3top b2_b 1.34317f
C64 b5_b rbit6top 0.17822f
C65 v2 vnx_bias 0.12642f
C66 vx3 vcasp 5.64491f
C67 vaux rb_mid 0.24947f
C68 dvdd rbit5top 3.45499f
C69 vref vq3 0.52821f
C70 v2 vbn_i 0.65383f
C71 rbit5top rbit0top 0.19532f
C72 rbit3top b4_b 0.16324f
C73 b2_b rbit2top 0.62978f
C74 vbp_i vbn_i 7.65063f
C75 avdd rbit1top 1.11947f
C76 b4_b b6_b 0.39921f
C77 rbit3top rbit6top 0.73333f
C78 rbit4top b2_b 0.17164f
C79 b5_b rbit5top 0.32349f
C80 iref_gate v1 0.16482f
C81 avdd rbit3top 0.76905f
C82 avdd vx1 25.7192f
C83 rbit4top b4_b 0.52889f
C84 rbit6top rbit2top 0.27768f
C85 dvss b2_b 1.29017f
C86 avdd rbit2top 0.89737f
C87 vsu1 rb_mid 0.15385f
C88 vsu2 vcasp 0.28319f
C89 rbit6top b6_b 0.13315f
C90 b3 b0_b 0.45596f
C91 v2 vgn1 2.08526f
C92 dvss b4_b 1.03305f
C93 vsp su_state 0.31701f
C94 dvdd b1_b 1.71207f
C95 vgn2 avdd 19.8151f
C96 avdd rb_mid 1.18913f
C97 rbit3top rbit5top 5.77788f
C98 rbit4top rbit6top 0.59917f
C99 vbn_i rbit2top 0.16636f
C100 avdd rbit4top 1.06148f
C101 avdd su_state 6.12326f
C102 rbit5top rbit2top 0.13796f
C103 v2 xf2 11.5641f
C104 v2 vcasp 0.49384f
C105 dvss rbit6top 0.95852f
C106 vnx_bias rb_mid 0.13229f
C107 avdd dvss 0.10169f
C108 dvdd b3 2.20359f
C109 vbn_i rb_mid 1.82048f
C110 vbp_i vcasp 0.81571f
C111 b5_b b1_b 0.24169f
C112 vx3 psrg_m3_feed 4.77775f
C113 vsp vbp_tail 7.83253f
C114 b3 rbit0top 0.5252f
C115 vbn_i su_state 0.49605f
C116 psrg_vnc psrg_mf1_protected 0.86885f
C117 rbit1top b1_b 1.0224f
C118 rbit4top rbit5top 2.58032f
C119 avdd vbn_fold 48.9298f
C120 avdd vbp_tail 48.6595f
C121 vx1 vgn1 3.76652f
C122 dvss rbit5top 1.32184f
C123 b3 b5_b 0.1781f
C124 vnx_bias vbn_fold 3.59657f
C125 vbn_i vbn_fold 0.27506f
C126 b3 rbit1top 0.38125f
C127 b6 vref 0.10563f
C128 vbn_i vbp_tail 1.51389f
C129 b2_b b3_b 0.18346f
C130 rbit2top b1_b 1.0123f
C131 vgn2 vgn1 5.07724f
C132 vcasp vx1 5.11514f
C133 b4_b b3_b 0.12044f
C134 bgsu1 y1 0.1124f
C135 iref_gate pm2 1.462f
C136 su_state vq2 0.14322f
C137 avdd vbp_bias 73.6889f
C138 b3 rbit3top 0.36575f
C139 avdd vx2 26.7555f
C140 vgn2 xf2 1.4832f
C141 vsp xf1 4.97169f
C142 avdd vbn_sink 42.2793f
C143 vgn2 vcasp 0.38385f
C144 rb_mid vcasp 0.41312f
C145 rbit6top b3_b 0.26035f
C146 v2 psrg_m3_feed 0.14733f
C147 b3 b6_b 0.12306f
C148 b0 b0_b 1.57273f
C149 dvss b1_b 0.40119f
C150 b4 b4_b 0.44717f
C151 vbp_i psrg_m3_feed 0.18956f
C152 vbp_tail vq2 0.51793f
C153 avdd aux_gate 11.6421f
C154 xf1 avdd 34.0549f
C155 rbit0top rfix0 0.20304f
C156 b3 rbit4top 2.00367f
C157 dvdd vq3 2.37903f
C158 rbit0top rfix2 0.24932f
C159 vaux psrg_m3_protected 0.12928f
C160 v2 vbp_cas 2.26622f
C161 rbit0top vq3 0.13371f
C162 dvss b3 2.17826f
C163 dvdd b0 2.25472f
C164 vbn_i aux_gate 0.56758f
C165 xf2 vbn_fold 1.19048f
C166 vbn_fold vcasp 0.63195f
C167 vbp_cas vbp_i 0.41282f
C168 auxsu1 vsu2 0.34171f
C169 b0 rbit0top 1.30134f
C170 vcasp vbp_tail 0.53601f
C171 b5_b vq3 0.19969f
C172 bgsu1 vsu 0.17301f
C173 pm2 y1 8.82479f
C174 vx1 psrg_m3_feed 5.51197f
C175 vaux psrg_vnc 1.04986f
C176 vgn1 vx2 0.72762f
C177 b4 rbit5top 0.33512f
C178 rbit1top vq3 0.48799f
C179 b0 rbit1top 0.95698f
C180 b2 vref 0.27624f
C181 rbit2top rfix0 0.46931f
C182 vgn2 psrg_m3_feed 0.35919f
C183 xf2 vbn_sink 6.71667f
C184 aux_gate vgn1 0.11923f
C185 vcasp vx2 5.49619f
C186 rbit3top vq3 0.29795f
C187 vbn psrg_mf1_protected 0.14469f
C188 rbit2top rfix2 0.47492f
C189 b0 rbit3top 0.26929f
C190 rbit2top vq3 0.3573f
C191 rbit4top rfix0 0.5693f
C192 xf2 xf1 15.3018f
C193 vgn2 vbp_cas 9.81598f
C194 b0 rbit2top 0.53646f
C195 xf2 aux_gate 2.5748f
C196 b6_b vq3 0.27234f
C197 b5 b4_b 0.51793f
C198 b6 b0_b 0.231f
C199 vsu2 v1 1.13183f
C200 rbit4top vq3 0.19034f
C201 psrg_vnc avdd 16.33434f
C202 su_state vq3 0.29842f
C203 b0 rbit4top 0.27314f
C204 dvss vq3 0.82446f
C205 vnx_bias psrg_vnc 0.15984f
C206 b5 rbit6top 0.23277f
C207 b3 b4 2.21325f
C208 dvss b0 2.19903f
C209 dvdd b6 2.30224f
C210 psrg_vnc vbn_i 1.64743f
C211 vgn2 auxsu1 0.12141f
C212 bgsu1 vsu2 0.30458f
C213 auxsu1 rb_mid 0.15762f
C214 b6 rbit0top 0.35994f
C215 v2 v1 18.8335f
C216 vbp_i v1 0.13447f
C217 psrg_m3_protected vgn1 0.56942f
C218 vbp_tail vq3 0.92418f
C219 vsp net3 0.40118f
C220 vx2 psrg_m3_feed 5.74429f
C221 b6 b5_b 0.12061f
C222 b5 rbit5top 0.18324f
C223 avdd net3 3.10548f
C224 vbp_cas vbp_bias 14.5859f
C225 b6 rbit1top 0.3938f
C226 v2 net4 0.11332f
C227 psrg_vnc vgn1 0.42512f
C228 aux_gate psrg_m3_feed 0.28976f
C229 vbn_i net3 0.22221f
C230 b6 rbit3top 0.22366f
C231 psrg_vnc vcasp 14.1901f
C232 b3_b vq3 0.29429f
C233 b6 b6_b 0.46004f
C234 b2 b0_b 0.4976f
C235 vgn2 v1 0.35798f
C236 rb_mid v1 0.17132f
C237 b6 rbit4top 0.35582f
C238 net3 vq2 0.1153f
C239 y1 vsu 0.11928f
C240 rfix0 rfix1 0.12694f
C241 b4 vq3 0.12386f
C242 b3 b5 0.54286f
C243 dvdd b2 2.80728f
C244 dvss b6 1.76049f
C245 rfix1 rfix2 0.12712f
C246 bgsu1 rb_mid 0.10425f
C247 b2 rbit0top 0.28679f
C248 psrg_m3_protected psrg_m3_feed 0.70719f
C249 vbp_tail v1 0.90876f
C250 vbn avdd 2.01557f
C251 v2 iref_gate 0.45614f
C252 b2 rbit1top 0.59167f
C253 iref_gate vbp_i 3.93968f
C254 bgsu1 vbn_fold 0.14888f
C255 vx3 vref 2.39972f
C256 auxsu2 auxsu1 0.20281f
C257 psrg_vnc psrg_m3_feed 8.96492f
C258 vbp_bias v1 1.29237f
C259 b2 rbit3top 0.28452f
C260 b1 b2_b 0.16487f
C261 b2 rbit2top 0.27743f
C262 vgn2 pm2 1.54129f
C263 b1 b4_b 0.21295f
C264 b6 b3_b 0.28826f
C265 vref b0_b 0.46432f
C266 xf1 v1 10.8469f
C267 b2 rbit4top 0.11838f
C268 pm1 avdd 31.7984f
C269 b5 vq3 0.23405f
C270 b4 b6 0.12575f
C271 dvss b2 1.49362f
C272 dvdd vref 4.35693f
C273 vgn2 iref_gate 0.13577f
C274 psrg_vnc auxsu1 0.21772f
C275 bgsu1 aux_gate 0.11782f
C276 vbn vcasp 2.53988f
C277 vref rbit0top 2.59934f
C278 iref_gate su_state 9.44851f
C279 vref vbp_i 0.20466f
C280 vref rbit1top 2.44423f
C281 iref_gate vbn_fold 1.81815f
C282 auxsu1 bgsu2 0.2998f
C283 iref_gate vbp_tail 0.86895f
C284 psrg_m3_protected v1 1.05463f
C285 vref rbit3top 0.11951f
C286 vsua avdd 0.86767f
C287 vref vx1 0.7335f
C288 vref rbit2top 2.42774f
C289 pm2 aux_gate 1.75448f
C290 vgn2 y1 1.33328f
C291 b1 b1_b 2.00112f
C292 psrg_vnc v1 0.5039f
C293 vbn psrg_m3_feed 0.16912f
C294 iref_gate vbn_sink 0.5317f
C295 vref rbit4top 0.232f
C296 vref su_state 0.16807f
C297 dvss vref 0.18986f
C298 b4 b2 0.12242f
C299 b5 b6 0.74946f
C300 b3 b1 0.14443f
C301 psrg_vnc bgsu1 1.53991f
C302 iref_gate aux_gate 9.00756f
C303 y1 vbn_fold 0.16495f
C304 psrg_mf1_protected vbn_i 0.21759f
C305 vref vbn_fold 0.49857f
C306 vref vbp_tail 2.93673f
C307 net3 v1 1.28893f
C308 dvdd b0_b 4.14987f
C309 auxsu1 vbn 12.9803f
C310 rbit0top b0_b 2.37512f
C311 bgsu2 bgsu1 0.30326f
C312 vsua vcasp 0.38806f
C313 vref vbp_bias 1.13648f
C314 vsu su_state 0.2468f
C315 v2 vsu2 0.71053f
C316 vref vx2 0.93047f
C317 vbp_i vsu2 1.93283f
C318 vx3 vx1 6.5981f
C319 dvdd rbit0top 18.2143f
C320 vbp_cas pm1 9.1631f
C321 psrg_mf1_protected vcasp 0.17385f
C322 rbit1top b0_b 2.10468f
C323 y1 aux_gate 0.37334f
C324 vsu vbn_fold 1.15965f
C325 vref aux_gate 0.49479f
C326 dvdd b5_b 0.80288f
C327 v2 vbp_i 1.20932f
C328 b1 vq3 0.59886f
C329 dvdd rbit1top 25.2992f
C330 b0 b1 0.28169f
C331 b5 b2 0.9131f
C332 b4 vref 0.32122f
C333 vaux avdd 4.24184f
C334 rbit2top b0_b 0.12093f
C335 rbit1top rbit0top 17.4997f
C336 vref rfix1 0.48168f
C337 vaux vnx_bias 0.11873f
C338 dvdd rbit3top 9.08123f
C339 rbit3top rbit0top 0.20774f
C340 rbit4top b0_b 0.10611f
C341 rbit6top b2_b 0.25905f
C342 dvdd rbit2top 14.9437f
C343 rbit2top rbit0top 1.73035f
C344 dvdd b6_b 0.89872f
C345 dvss b0_b 1.14456f
C346 vsp avdd 74.268f
C347 bgsu1 vbn 8.42495f
C348 vsu aux_gate 0.18683f
C349 avdd vsu1 0.6279f
C350 rbit3top b5_b 0.10112f
C351 dvdd rbit4top 5.37254f
C352 psrg_mf1_protected psrg_m3_feed 0.11778f
C353 rbit3top rbit1top 0.19308f
C354 rbit5top b2_b 0.25686f
C355 v2 vgn2 3.00308f
C356 v2 rb_mid 0.24166f
C357 avdd rbit6top 0.41253f
C358 vnx_bias vsu1 0.61064f
C359 dvdd dvss 6.13982f
C360 vgn2 vbp_i 0.21338f
C361 vbp_i rb_mid 0.18995f
C362 rbit2top rbit1top 9.86719f
C363 b5_b b6_b 0.12883f
C364 rbit5top b4_b 0.64681f
C365 dvss rbit0top 7.87695f
C366 vx3 vx2 2.72171f
C367 vsu2 vbp_tail 1.18175f
C368 vbp_i su_state 0.1983f
C369 vnx_bias avdd 4.7554f
C370 psrg_vnc y1 0.72307f
C371 avdd vbn_i 19.083f
C372 auxsu1 vsua 0.11093f
C373 rbit5top rbit6top 1.10162f
C374 rbit3top rbit2top 5.7444f
C375 vaux vcasp 5.42532f
C376 avdd rbit5top 0.75622f
C377 dvss b5_b 1.3604f
C378 vnx_bias vbn_i 4.3608f
C379 rbit3top b6_b 0.10124f
C380 v2 vbp_tail 0.20576f
C381 vbp_i vbn_fold 12.8191f
C382 dvss rbit1top 8.40737f
C383 b5 vref 0.2878f
C384 vbp_i vbp_tail 2.59027f
C385 rbit4top rbit3top 4.12866f
C386 b4_b b1_b 0.13055f
C387 rbit4top rbit2top 1.33249f
C388 dvss rbit3top 2.47236f
C389 avdd vgn1 20.6668f
C390 vsp xf2 4.80498f
C391 v2 vbp_bias 0.40782f
C392 dvss rbit2top 3.84354f
C393 b3 b2_b 0.86019f
C394 vsu1 vcasp 0.77867f
C395 vbp_i vbp_bias 0.35167f
C396 vref net3 0.11361f
C397 rbit6top b1_b 0.61487f
C398 b4 b0_b 0.21404f
C399 dvss b6_b 1.414f
C400 b3 b4_b 0.1346f
C401 dvdd b3_b 0.98607f
C402 vgn2 su_state 1.80265f
C403 vbn_i vgn1 15.2543f
C404 vbp_i vbn_sink 18.381f
C405 xf2 avdd 30.956f
C406 avdd vcasp 48.2263f
C407 dvss rbit4top 2.4366f
C408 v2 xf1 1.25868f
C409 b3 rbit6top 0.27467f
C410 vnx_bias vcasp 0.79682f
C411 dvdd b4 2.36894f
C412 vgn2 vbn_fold 2.46194f
C413 vbn_i vcasp 0.24227f
C414 b5_b b3_b 0.10598f
C415 rbit5top b1_b 0.15391f
C416 auxsu2 vsu2 0.3506f
C417 vaux psrg_m3_feed 1.13504f
C418 b4 rbit0top 0.35802f
C419 rb_mid vbp_tail 0.61519f
C420 vbn_fold su_state 0.54084f
C421 vbp_tail su_state 4.41374f
C422 bgsu1 vsua 0.13226f
C423 rbit0top rfix1 0.23203f
C424 pm2 pm1 4.91378f
C425 vx1 vx2 6.69267f
C426 b3 rbit5top 0.31365f
C427 b4 b5_b 2.31201f
C428 rbit3top b3_b 0.50673f
C429 b4 rbit1top 0.30277f
C430 b2 b1 0.61748f
C431 vbn_fold vbp_tail 0.50114f
C432 vcasp vgn1 5.27291f
C433 vgn2 vbn_sink 1.02932f
C434 vbp_bias su_state 1.0293f
C435 b6_b b3_b 0.10274f
C436 vbn_sink su_state 0.12828f
C437 b2_b vq3 0.16987f
C438 avdd psrg_m3_feed 56.8184f
C439 rbit4top b3_b 0.28591f
C440 v2 psrg_m3_protected 1.98711f
C441 vgn2 xf1 1.1941f
C442 b0 b2_b 0.66587f
C443 vgn2 aux_gate 0.82162f
C444 b4 rbit2top 0.14143f
C445 rbit6top rfix0 2.51098f
C446 avdd rfix0 0.25681f
C447 vbp_bias vbp_tail 0.96828f
C448 vnx_bias psrg_m3_feed 0.71126f
C449 dvss b3_b 0.44394f
C450 b4 b6_b 0.21254f
C451 aux_gate su_state 0.64858f
C452 b5 b0_b 0.18986f
C453 vbn_i psrg_m3_feed 1.96445f
C454 vbp_cas avdd 88.6687f
C455 vbn_fold vbn_sink 3.89325f
C456 rbit2top rfix1 0.47013f
C457 b4 rbit4top 0.15644f
C458 vbn_sink vbp_tail 2.38604f
C459 rbit6top vq3 1.8274f
C460 avdd vq3 2.64336f
C461 v2 psrg_vnc 0.83259f
C462 b0 rbit6top 0.37638f
C463 dvdd b5 1.97331f
C464 dvss b4 1.49472f
C465 psrg_vnc vbp_i 6.7663f
C466 vbn_fold aux_gate 9.8337f
C467 xf1 vbn_fold 4.275f
C468 bgsu2 vsu2 0.27649f
C469 b5 rbit0top 0.31087f
C470 vsu2 net3 0.13418f
C471 rbit5top vq3 0.24223f
C472 vbn vsu 0.35311f
C473 auxsu1 avdd 1.2742f
C474 pm1 y1 10.8108f
C475 vgn1 psrg_m3_feed 10.9294f
C476 b0 rbit5top 0.65409f
C477 b5 b5_b 0.71797f
C478 vgn2 psrg_m3_protected 1.66548f
C479 vnx_bias auxsu1 8.71994f
C480 b5 rbit1top 0.26006f
C481 aux_gate vbp_bias 1.29093f
C482 b1 vref 0.51763f
C483 vaux v1 0.40463f
C484 vbp_cas vgn1 1.53672f
C485 vcasp psrg_m3_feed 8.83225f
C486 xf1 vbn_sink 6.56293f
C487 vbp_i net3 0.27838f
C488 vq3 vq2 1.71091f
C489 b5 rbit3top 0.11617f
C490 vgn2 psrg_vnc 0.25864f
C491 xf1 aux_gate 0.47934f
C492 psrg_vnc rb_mid 0.26276f
C493 vbp_cas vcasp 3.14978f
C494 b1_b vq3 0.46414f
C495 b4 b3_b 0.37929f
C496 b6 b4_b 0.18235f
C497 b0 b1_b 0.11519f
C498 vsp v1 10.877f
C499 auxsu1 vgn1 0.11695f
C500 y1 vsua 0.13441f
C501 b3 vq3 0.73252f
C502 avdd v1 18.76011f
C503 b6 rbit6top 0.21217f
C504 dvss b5 1.9132f
C505 b3 b0 0.11624f
C506 auxsu1 vcasp 0.45799f
C507 vnx_bias v1 0.13405f
C508 vbn_i v1 0.33128f
C509 vgn2 net3 0.12429f
C510 bgsu1 avdd 1.5294f
C511 su_state net3 10.7117f
C512 b6 rbit5top 0.169f
C513 avdd net4 1.14374f
C514 vnx_bias bgsu1 16.5525f
C515 bgsu1 vbn_i 7.29036f
C516 vbp_cas psrg_m3_feed 5.05719f
C517 vbn_fold net3 0.23215f
C518 vbn_i net4 0.51306f
C519 vq2 v1 0.76777f
C520 vbp_tail net3 3.21059f
C521 vgn1 v1 2.28853f
C522 vsua vsu 0.45111f
C523 b2 b2_b 0.6365f
C524 rfix0 vq3 0.5242f
C525 b6 b1_b 0.18908f
C526 b5 b3_b 0.14928f
C527 xf2 v1 0.85722f
C528 vcasp v1 0.90731f
C529 auxsu1 psrg_m3_feed 0.40763f
C530 vbp_bias net3 1.20203f
C531 pm2 avdd 34.7863f
C532 b2 rbit6top 0.32719f
C533 b4 b5 0.42193f
C534 dvdd b1 1.96506f
C535 b3 b6 0.90951f
C536 vsp iref_gate 0.10677f
C537 vbn rb_mid 0.16643f
C538 bgsu1 vcasp 1.07063f
C539 b1 rbit0top 0.3846f
C540 pm2 vbn_i 0.17298f
C541 vbn su_state 0.14211f
C542 iref_gate avdd 20.4972f
C543 vref avss 3.25585p
C544 b1 avss 5.16819f
C545 b2 avss 3.77708f
C546 b6 avss 5.21403f
C547 b5 avss 3.69989f
C548 b0 avss 5.95297f
C549 b4 avss 4.70533f
C550 b3 avss 5.61977f
C551 dvss avss 76.0567f
C552 avdd avss 9.56454p
C553 dvdd avss 0.23839p
C554 psrg_mf1_protected avss 7.86356f
C555 y1 avss 15.69615f
C556 pm1 avss 12.14692f
C557 pm2 avss 13.10763f
C558 iref_gate avss 21.87429f
C559 vbn avss 14.94377f
C560 bgsu1 avss 0.20656f
C561 psrg_m3_protected avss 7.7351f
C562 psrg_vnc avss 26.0029f
C563 vbp_cas avss 21.90905f
C564 xf1 avss 30.4688f
C565 xf2 avss 33.81314f
C566 vgn2 avss 0.27288p
C567 vsp avss 8.66694f
C568 v2 avss 35.46918f
C569 vaux avss 8.69868f
C570 vx3 avss 13.83727f
C571 psrg_m3_feed avss 26.58753f
C572 vx2 avss 7.97917f
C573 vgn1 avss 31.06924f
C574 vx1 avss 4.61977f
C575 su_state avss 27.51421f
C576 vbp_tail avss 22.01381f
C577 vbp_bias avss 12.45396f
C578 aux_gate avss 0.72593f
C579 vsu1 avss 8.79704f
C580 vsu2 avss 11.94717f
C581 vbn_sink avss 89.41556f
C582 rfix2 avss 11.172f
C583 rfix1 avss 11.1355f
C584 rfix0 avss 9.21562f
C585 b3_b avss 2.0381f
C586 b1_b avss 1.35351f
C587 b6_b avss 2.09703f
C588 b4_b avss 2.01231f
C589 b0_b avss 2.04596f
C590 rbit0top avss 20.659f
C591 rbit1top avss 10.0784f
C592 rbit2top avss 11.41613f
C593 b2_b avss 2.27429f
C594 rbit6top avss 16.98034f
C595 rbit5top avss 21.71097f
C596 b5_b avss 6.12618f
C597 rbit3top avss 23.63819f
C598 rbit4top avss 13.61981f
C599 vbn_fold avss 37.12764f
C600 vbn_i avss 67.01259f
C601 vbp_i avss 80.90348f
C602 vbp_i.n0 avss 2.01762f
C603 vbp_i.n1 avss 0.98931f
C604 vbp_i.n2 avss 0.51628f
C605 vbp_i.n3 avss 0.51287f
C606 vbp_i.n4 avss 0.51628f
C607 vbp_i.n5 avss 0.51287f
C608 vbp_i.n6 avss 0.63073f
C609 vbp_i.n7 avss 0.64436f
C610 vbp_i.n8 avss 0.14773f
C611 vbp_i.n9 avss 0.75947f
C612 vbp_i.t0 avss 3.47995f
C613 vbp_i.n10 avss 1.11043f
C614 vbp_i.n11 avss 1.18636f
C615 vbp_i.n12 avss 1.3911f
C616 vbp_i.n13 avss 0.77457f
C617 vbp_i.n14 avss 0.77457f
C618 vbp_i.n15 avss 0.76896f
C619 vbp_i.n16 avss 1.39092f
C620 vbp_i.n17 avss 0.77449f
C621 vbp_i.n18 avss 0.77449f
C622 vbp_i.n19 avss 0.76888f
C623 vbp_i.n20 avss 1.38888f
C624 vbp_i.n21 avss 0.77384f
C625 vbp_i.n22 avss 0.74017f
C626 vbp_i.n23 avss 1.39344f
C627 vbp_i.n24 avss 0.77583f
C628 vbp_i.n25 avss 0.77583f
C629 vbp_i.n26 avss 0.77022f
C630 vbp_i.n27 avss 1.39068f
C631 vbp_i.n28 avss 0.77438f
C632 vbp_i.n29 avss 0.77438f
C633 vbp_i.n30 avss 0.77438f
C634 vbp_i.n31 avss 0.83049f
C635 vbp_i.t6 avss 2.95235f
C636 vbp_i.t4 avss 2.94963f
C637 vbp_i.t2 avss 2.94963f
C638 vbp_i.n32 avss 1.31755f
C639 vbp_i.n33 avss 0.2194f
C640 vbp_i.n34 avss 0.73743f
C641 vbp_i.n35 avss 0.70938f
C642 vbp_i.n36 avss 0.2194f
C643 vbp_i.n37 avss 0.68132f
C644 vbp_i.n38 avss 0.33511f
C645 vbp_i.n39 avss 0.84176f
C646 vbp_i.n40 avss 0.76549f
C647 vbp_i.n41 avss 0.76549f
C648 vbp_i.n42 avss 0.70938f
C649 vbp_i.t8 avss 2.9595f
C650 vbp_i.t10 avss 2.93917f
C651 vbp_i.n43 avss 0.26096f
C652 vbp_i.n44 avss 0.14308f
C653 vbp_i.n45 avss 1.0983f
C654 vbp_i.n46 avss 0.61775f
C655 vbp_i.n47 avss 0.12115f
C656 vbp_i.n48 avss 1.18337f
C657 vbp_i.n49 avss 0.65577f
C658 vbp_i.n50 avss 0.80564f
C659 vbp_i.n51 avss 0.26279f
C660 vbp_i.n52 avss 0.78381f
C661 vbp_i.n53 avss 0.26843f
C662 vbp_i.n54 avss 0.75895f
C663 vbn_i.t7 avss 3.5911f
C664 vbn_i.t5 avss 3.57626f
C665 vbn_i.t4 avss 3.2704f
C666 vbn_i.t2 avss 8.4764f
C667 vbn_i.n0 avss 9.27618f
C668 vbn_i.n1 avss 8.68017f
C669 vbn_i.n2 avss 1.12257f
C670 vbn_i.n3 avss 1.77715f
C671 vbn_i.n4 avss 1.23965f
C672 vbn_i.n5 avss 3.77033f
C673 vbn_i.n6 avss 5.06151f
C674 vbn_i.t6 avss 3.58483f
C675 vbn_i.n7 avss 1.1583f
C676 vbn_i.t0 avss 3.5911f
C677 vbn_i.n8 avss 1.5393f
C678 vbn_i.n9 avss 2.0242f
C679 vbn_i.t1 avss 3.58371f
C680 vbn_fold.t13 avss 2.32155f
C681 vbn_fold.n0 avss 5.5744f
C682 vbn_fold.n1 avss 6.66805f
C683 vbn_fold.t4 avss 4.07994f
C684 vbn_fold.t5 avss 4.0496f
C685 vbn_fold.t10 avss 4.04094f
C686 vbn_fold.t11 avss 4.0496f
C687 vbn_fold.t2 avss 4.04094f
C688 vbn_fold.t7 avss 4.04976f
C689 vbn_fold.t6 avss 4.04047f
C690 vbn_fold.t9 avss 4.04914f
C691 vbn_fold.t8 avss 4.04047f
C692 vbn_fold.t1 avss 4.04914f
C693 vbn_fold.t0 avss 4.14023f
C694 vbn_fold.n2 avss 0.99568f
C695 vbn_fold.n3 avss 0.69666f
C696 vbn_fold.n4 avss 0.70262f
C697 vbn_fold.n5 avss 0.68651f
C698 vbn_fold.n6 avss 0.95203f
C699 vbn_fold.t3 avss 4.03035f
C700 vbn_fold.n7 avss 0.72428f
C701 vbn_fold.n8 avss 0.89615f
C702 vbn_fold.n9 avss 0.70283f
C703 vbn_fold.n10 avss 0.69645f
C704 vbn_fold.n11 avss 0.69295f
C705 vbn_fold.n12 avss 13.3713f
C706 vbn_fold.n13 avss 12.7551f
C707 rbit4top.t2 avss 1.7338f
C708 rbit4top.t0 avss 1.43381f
C709 rbit4top.t1 avss 0.73265f
C710 rbit4top.n0 avss 2.97051f
C711 rbit4top.n1 avss 2.95416f
C712 rbit4top.t5 avss 2.23131f
C713 rbit4top.t4 avss 0.73575f
C714 rbit4top.n2 avss 4.91002f
C715 rbit4top.n3 avss 3.60937f
C716 rbit4top.t3 avss 3.18576f
C717 rbit3top.t3 avss 1.95233f
C718 rbit3top.t0 avss 1.42881f
C719 rbit3top.t2 avss 0.98697f
C720 rbit3top.t5 avss 1.36575f
C721 rbit3top.n0 avss 0.70245f
C722 rbit3top.t6 avss 1.37677f
C723 rbit3top.n1 avss 0.18272f
C724 rbit3top.t4 avss 0.42761f
C725 rbit3top.t1 avss 2.40378f
C726 rbit3top.n2 avss 19.4729f
C727 rbit3top.n3 avss 1.7263f
C728 rbit3top.t7 avss 1.37176f
C729 rbit3top.n4 avss 0.63207f
C730 rbit3top.n5 avss 1.6262f
C731 b5_b.t1 avss 0.38803f
C732 b5_b.t0 avss 0.83409f
C733 b5_b.n0 avss 3.825f
C734 rbit5top.t0 avss 0.73894f
C735 rbit5top.t3 avss 0.6329f
C736 rbit5top.n0 avss 0.61967f
C737 rbit5top.t1 avss 2.61507f
C738 rbit5top.t5 avss 0.58368f
C739 rbit5top.n1 avss 5.24053f
C740 rbit5top.n2 avss 4.5938f
C741 rbit5top.t2 avss 0.91542f
C742 rbit5top.t4 avss 1.46526f
C743 rbit6top.n0 avss 2.6475f
C744 rbit6top.n1 avss 1.05911f
C745 rbit6top.t2 avss 0.32899f
C746 rbit6top.t4 avss 1.70503f
C747 rbit6top.t1 avss 1.36073f
C748 rbit6top.n2 avss 4.32442f
C749 rbit6top.t3 avss 0.1325f
C750 rbit6top.t5 avss 0.36733f
C751 rbit6top.n3 avss 2.06687f
C752 rbit6top.t0 avss 0.65633f
C753 b2_b.t1 avss 0.18115f
C754 b2_b.t0 avss 0.88453f
C755 b2_b.n0 avss 3.08323f
C756 b2_b.n1 avss 2.87926f
C757 b2_b.n2 avss 0.77103f
C758 rbit2top.t5 avss 4.86098f
C759 rbit2top.t6 avss 4.9309f
C760 rbit2top.t8 avss 4.96548f
C761 rbit2top.t3 avss 0.87638f
C762 rbit2top.t1 avss 1.84082f
C763 rbit2top.n0 avss 5.75802f
C764 rbit2top.n1 avss 3.85319f
C765 rbit2top.t7 avss 4.94456f
C766 rbit2top.n2 avss 0.53347f
C767 rbit2top.n3 avss 0.41844f
C768 rbit2top.t4 avss 2.5717f
C769 rbit2top.t2 avss 2.5584f
C770 rbit2top.t9 avss 2.58082f
C771 rbit2top.n4 avss 0.65418f
C772 rbit2top.n5 avss 1.7709f
C773 rbit2top.t0 avss 2.63831f
C774 rbit2top.n6 avss 3.30992f
C775 rbit2top.n7 avss 1.95781f
C776 rbit1top.t8 avss 4.89893f
C777 rbit1top.t2 avss 5.05358f
C778 rbit1top.t3 avss 5.06891f
C779 rbit1top.n0 avss 2.01852f
C780 rbit1top.t9 avss 4.97442f
C781 rbit1top.t10 avss 4.97009f
C782 rbit1top.t11 avss 4.97128f
C783 rbit1top.t7 avss 5.0508f
C784 rbit1top.t0 avss 0.89419f
C785 rbit1top.t1 avss 1.16642f
C786 rbit1top.n1 avss 5.49059f
C787 rbit1top.n2 avss 5.17697f
C788 rbit1top.t4 avss 4.99106f
C789 rbit1top.n3 avss 0.50243f
C790 rbit1top.t5 avss 4.98548f
C791 rbit1top.n4 avss 0.46256f
C792 rbit1top.t6 avss 4.99166f
C793 rbit1top.n5 avss 0.43071f
C794 rbit1top.t13 avss 4.96796f
C795 rbit1top.n6 avss 0.39614f
C796 rbit1top.t12 avss 4.97471f
C797 rbit1top.n7 avss 0.4133f
C798 rbit1top.n8 avss 0.38468f
C799 rbit1top.n9 avss 0.39421f
C800 rbit1top.n10 avss 0.40823f
C801 rbit1top.n11 avss 1.71891f
C802 rbit0top.t9 avss 3.85028f
C803 rbit0top.t5 avss 3.83352f
C804 rbit0top.t3 avss 3.15315f
C805 rbit0top.t0 avss 1.07774f
C806 rbit0top.n0 avss 7.92505f
C807 rbit0top.n1 avss 2.74896f
C808 rbit0top.t4 avss 3.86123f
C809 rbit0top.n2 avss 0.45153f
C810 rbit0top.t7 avss 3.85242f
C811 rbit0top.n3 avss 0.32431f
C812 rbit0top.t6 avss 3.85547f
C813 rbit0top.n4 avss 0.27842f
C814 rbit0top.t2 avss 3.95282f
C815 rbit0top.t1 avss 3.93619f
C816 rbit0top.n5 avss 3.91266f
C817 rbit0top.n6 avss 9.45609f
C818 rbit0top.n7 avss 0.29713f
C819 rbit0top.t8 avss 3.79811f
C820 b0_b.t0 avss 0.71443f
C821 b0_b.t1 avss 0.20041f
C822 b0_b.n0 avss 2.26517f
C823 b0_b.n1 avss 1.35034f
C824 b0_b.n2 avss 0.7377f
C825 b0_b.n3 avss 0.72384f
C826 b0_b.n4 avss 0.71662f
C827 b0_b.n5 avss 0.83399f
C828 b4_b.t1 avss 1.0073f
C829 b4_b.t0 avss 0.72159f
C830 b4_b.n0 avss 4.04723f
C831 b6_b.t1 avss 0.56886f
C832 b6_b.t0 avss 0.99818f
C833 b6_b.n0 avss 3.0041f
C834 b1_b.t1 avss 0.20107f
C835 b1_b.t0 avss 0.52843f
C836 b1_b.n0 avss 1.96838f
C837 b1_b.n1 avss 1.64649f
C838 b1_b.n2 avss 0.83168f
C839 b3_b.t1 avss 0.23378f
C840 b3_b.t0 avss 1.06921f
C841 b3_b.n0 avss 1.84146f
C842 vbn_sink.n0 avss 1.11061f
C843 vbn_sink.n1 avss 0.62457f
C844 vbn_sink.n2 avss 0.62679f
C845 vbn_sink.n3 avss 0.61924f
C846 vbn_sink.n4 avss 1.11021f
C847 vbn_sink.n5 avss 0.62438f
C848 vbn_sink.n6 avss 0.6266f
C849 vbn_sink.n7 avss 0.62438f
C850 vbn_sink.t18 avss 1.92432f
C851 vbn_sink.t16 avss 1.92363f
C852 vbn_sink.t8 avss 2.98395f
C853 vbn_sink.t6 avss 2.94787f
C854 vbn_sink.t7 avss 2.94543f
C855 vbn_sink.t9 avss 2.94787f
C856 vbn_sink.t10 avss 2.94543f
C857 vbn_sink.t3 avss 2.99967f
C858 vbn_sink.t13 avss 2.94639f
C859 vbn_sink.n8 avss 0.28148f
C860 vbn_sink.t14 avss 2.94395f
C861 vbn_sink.n9 avss 0.19678f
C862 vbn_sink.t11 avss 2.94639f
C863 vbn_sink.n10 avss 0.19847f
C864 vbn_sink.t12 avss 2.94395f
C865 vbn_sink.n11 avss 0.19393f
C866 vbn_sink.t5 avss 2.94453f
C867 vbn_sink.t4 avss 2.94191f
C868 vbn_sink.t1 avss 2.94436f
C869 vbn_sink.t20 avss 2.9996f
C870 vbn_sink.t0 avss 2.94191f
C871 vbn_sink.n12 avss 0.28327f
C872 vbn_sink.n13 avss 0.19777f
C873 vbn_sink.n14 avss 0.19324f
C874 vbn_sink.n15 avss 0.26805f
C875 vbn_sink.t19 avss 2.94072f
C876 vbn_sink.n16 avss 0.169f
C877 vbn_sink.n17 avss 0.26186f
C878 vbn_sink.t2 avss 2.74917f
C879 vbn_sink.n18 avss 0.20096f
C880 vbn_sink.n19 avss 0.25368f
C881 vbn_sink.n20 avss 0.19922f
C882 vbn_sink.n21 avss 0.19741f
C883 vbn_sink.n22 avss 0.19643f
C884 vbn_sink.n23 avss 1.5096f
C885 vbn_sink.n24 avss 1.73012f
C886 vbn_sink.n25 avss 0.18155f
C887 vbn_sink.n26 avss 0.39117f
C888 vbn_sink.n27 avss 1.41869f
C889 vbn_sink.n28 avss 1.86622f
C890 vbn_sink.n29 avss 0.23285f
C891 vbn_sink.n30 avss 0.24413f
C892 vbp_bias.t23 avss 3.28185f
C893 vbp_bias.t24 avss 3.31982f
C894 vbp_bias.t25 avss 3.316f
C895 vbp_bias.t26 avss 3.31982f
C896 vbp_bias.t27 avss 3.42311f
C897 vbp_bias.n0 avss 0.43331f
C898 vbp_bias.n1 avss 0.3045f
C899 vbp_bias.n2 avss 0.26302f
C900 vbp_bias.t21 avss 3.35141f
C901 vbp_bias.t20 avss 3.28735f
C902 vbp_bias.n3 avss 0.44186f
C903 vbp_bias.t18 avss 3.30283f
C904 vbp_bias.t7 avss 4.42371f
C905 vbp_bias.t1 avss 4.45766f
C906 vbp_bias.n4 avss 2.04088f
C907 vbp_bias.t5 avss 4.45463f
C908 vbp_bias.n5 avss 1.21389f
C909 vbp_bias.t3 avss 4.40343f
C910 vbp_bias.n6 avss 0.15948f
C911 vbp_bias.n7 avss 0.23713f
C912 vbp_bias.n8 avss 0.25436f
C913 vbp_bias.n9 avss 1.15811f
C914 vbp_bias.n10 avss 1.08463f
C915 vbp_bias.n11 avss 2.04105f
C916 vbp_bias.t17 avss 4.45408f
C917 vbp_bias.n12 avss 1.21408f
C918 vbp_bias.t15 avss 4.45285f
C919 vbp_bias.n13 avss 0.16094f
C920 vbp_bias.n14 avss 1.15743f
C921 vbp_bias.t13 avss 4.46213f
C922 vbp_bias.n15 avss 0.26516f
C923 vbp_bias.t11 avss 4.40774f
C924 vbp_bias.n16 avss 0.2131f
C925 vbp_bias.n17 avss 0.24161f
C926 vbp_bias.t9 avss 4.40552f
C927 vbp_bias.n18 avss 0.16019f
C928 vbp_bias.n19 avss 0.23713f
C929 vbp_bias.n20 avss 0.49131f
C930 vbp_bias.n21 avss 0.42169f
C931 vbp_bias.n22 avss 0.18802f
C932 vbp_bias.t19 avss 3.27565f
C933 vbp_bias.n23 avss 0.29999f
C934 vbp_bias.n24 avss 0.33121f
C935 vbp_bias.n25 avss 0.28962f
C936 vbp_bias.t22 avss 3.2725f
C937 vbp_tail.n0 avss 2.88908f
C938 vbp_tail.n1 avss 1.53664f
C939 vbp_tail.n2 avss 1.53727f
C940 vbp_tail.n3 avss 1.54391f
C941 vbp_tail.n4 avss 1.9484f
C942 vbp_tail.n5 avss 0.66782f
C943 vbp_tail.t6 avss 5.4125f
C944 vbp_tail.t1 avss 2.46388f
C945 vbp_tail.n6 avss 0.86572f
C946 vbp_tail.n7 avss 0.13611f
C947 vbp_tail.t3 avss 2.4541f
C948 vbp_tail.n8 avss 0.17287f
C949 vbp_tail.t5 avss 2.46328f
C950 vbp_tail.n9 avss 0.20629f
C951 vbp_tail.n10 avss 3.49232f
C952 vbp_tail.n11 avss 3.23081f
C953 su_state.t2 avss 4.9526f
C954 su_state.t0 avss 11.12332f
C955 su_state.n0 avss 22.7492f
C956 su_state.t1 avss 0.34921f
C957 vx1.t7 avss 2.14842f
C958 vx1.t6 avss 3.42136f
C959 vx1.n0 avss 3.2167f
C960 vx1.t8 avss 2.14767f
C961 vx1.n1 avss 1.82286f
C962 vx1.t9 avss 2.17811f
C963 vx1.n2 avss 2.62476f
C964 vx1.t1 avss 3.82691f
C965 vx1.t0 avss 3.82313f
C966 vx1.n3 avss 1.18921f
C967 vx1.t3 avss 4.0987f
C968 vx1.t2 avss 4.07486f
C969 vx1.n4 avss 2.38329f
C970 vx1.n5 avss 2.19672f
C971 vx1.t5 avss 3.93643f
C972 vx1.t4 avss 3.92867f
C973 vx1.n6 avss 1.56211f
C974 vx1.n7 avss 6.65675f
C975 vx1.n8 avss 6.16634f
C976 vx1.t10 avss 2.08515f
C977 vgn1.t6 avss 1.51935f
C978 vgn1.t9 avss 2.0831f
C979 vgn1.n0 avss 2.66757f
C980 vgn1.t5 avss 1.51864f
C981 vgn1.n1 avss 1.21205f
C982 vgn1.t7 avss 1.51792f
C983 vgn1.n2 avss 0.92832f
C984 vgn1.t2 avss 5.05419f
C985 vgn1.t0 avss 22.439f
C986 vgn1.t4 avss 5.09157f
C987 vgn1.n3 avss 14.6184f
C988 vgn1.n4 avss 0.66885f
C989 vgn1.n5 avss 1.60608f
C990 vgn1.n6 avss 5.98325f
C991 vgn1.n7 avss 6.15048f
C992 vgn1.t8 avss 1.46269f
C993 vx2.t8 avss 1.88366f
C994 vx2.t7 avss 2.18561f
C995 vx2.t6 avss 2.90784f
C996 vx2.n0 avss 3.88677f
C997 vx2.n1 avss 2.29097f
C998 vx2.t9 avss 1.88298f
C999 vx2.n2 avss 2.22006f
C1000 vx2.t1 avss 3.70172f
C1001 vx2.t0 avss 3.67332f
C1002 vx2.n3 avss 1.90383f
C1003 vx2.t3 avss 3.59804f
C1004 vx2.t2 avss 3.54355f
C1005 vx2.n4 avss 0.62998f
C1006 vx2.n5 avss 1.97986f
C1007 vx2.t5 avss 3.74195f
C1008 vx2.t4 avss 3.70518f
C1009 vx2.n6 avss 2.0102f
C1010 vx2.n7 avss 5.08876f
C1011 vx2.n8 avss 5.89286f
C1012 vx2.t10 avss 1.83802f
C1013 psrg_m3_feed.t4 avss 1.27556f
C1014 psrg_m3_feed.t0 avss 11.31937f
C1015 psrg_m3_feed.n0 avss 11.6674f
C1016 psrg_m3_feed.n1 avss 12.6797f
C1017 psrg_m3_feed.n2 avss 1.05542f
C1018 psrg_m3_feed.n3 avss 0.98596f
C1019 psrg_m3_feed.n4 avss 1.11f
C1020 psrg_m3_feed.n5 avss 1.16854f
C1021 psrg_m3_feed.n6 avss 1.43123f
C1022 psrg_m3_feed.n7 avss 1.93683f
C1023 psrg_m3_feed.n8 avss 0.97825f
C1024 psrg_m3_feed.n9 avss 1.10156f
C1025 psrg_m3_feed.n10 avss 1.16084f
C1026 psrg_m3_feed.n11 avss 0.92475f
C1027 psrg_m3_feed.t1 avss 3.96099f
C1028 psrg_m3_feed.t2 avss 4.22709f
C1029 psrg_m3_feed.n12 avss 0.9461f
C1030 psrg_m3_feed.n13 avss 1.63492f
C1031 psrg_m3_feed.n14 avss 1.05221f
C1032 psrg_m3_feed.n15 avss 1.05221f
C1033 psrg_m3_feed.n16 avss 1.05221f
C1034 psrg_m3_feed.n17 avss 1.05221f
C1035 psrg_m3_feed.n18 avss 1.25647f
C1036 psrg_m3_feed.t3 avss 1.21504f
C1037 psrg_m3_feed.t7 avss 1.69048f
C1038 psrg_m3_feed.n19 avss 2.12405f
C1039 psrg_m3_feed.n20 avss 2.40085f
C1040 psrg_m3_feed.n21 avss 2.26113f
C1041 psrg_m3_feed.n22 avss 1.71998f
C1042 psrg_m3_feed.n23 avss 1.78137f
C1043 psrg_m3_feed.t5 avss 1.21377f
C1044 psrg_m3_feed.n24 avss 1.17141f
C1045 psrg_m3_feed.t6 avss 1.17885f
C1046 vx3.t1 avss 3.89187f
C1047 vx3.t9 avss 3.91206f
C1048 vx3.n0 avss 2.74001f
C1049 vx3.t10 avss 3.7551f
C1050 vx3.t3 avss 3.76998f
C1051 vx3.n1 avss 1.42022f
C1052 vx3.n2 avss 2.0547f
C1053 vx3.t2 avss 3.75375f
C1054 vx3.t0 avss 3.72185f
C1055 vx3.n3 avss 0.72951f
C1056 vx3.n4 avss 4.57517f
C1057 vx3.t4 avss 3.96483f
C1058 vx3.t5 avss 17.47236f
C1059 vx3.n5 avss 2.66821f
C1060 vx3.t6 avss 2.02245f
C1061 vx3.n6 avss 1.72461f
C1062 vx3.t7 avss 2.05112f
C1063 vx3.n7 avss 3.0943f
C1064 vx3.t8 avss 1.96358f
C1065 vaux.t1 avss 1.95426f
C1066 vaux.t0 avss 4.86847f
C1067 vaux.n0 avss 6.6423f
C1068 vaux.t2 avss 1.96365f
C1069 v2.t2 avss 0.1308f
C1070 v2.n0 avss 1.9528f
C1071 v2.n1 avss 3.35913f
C1072 v2.n2 avss 2.26056f
C1073 v2.n3 avss 1.99327f
C1074 v2.n4 avss 1.98959f
C1075 v2.n5 avss 15.7818f
C1076 v2.t1 avss 0.57929f
C1077 v2.n6 avss 14.233f
C1078 v2.n7 avss 0.91341f
C1079 v2.t0 avss 0.54425f
C1080 vsp.t8 avss 9.83369f
C1081 vsp.t4 avss 10.09566f
C1082 vsp.t9 avss 9.83315f
C1083 vsp.t10 avss 9.82647f
C1084 vsp.t6 avss 10.15908f
C1085 vsp.t0 avss 10.16587f
C1086 vsp.t11 avss 9.82647f
C1087 vsp.t7 avss 7.13335f
C1088 vsp.t3 avss 7.5177f
C1089 vsp.t14 avss 7.38737f
C1090 vsp.n0 avss 1.34941f
C1091 vsp.t13 avss 7.39868f
C1092 vsp.n1 avss 0.90601f
C1093 vsp.t15 avss 7.39956f
C1094 vsp.n2 avss 0.90617f
C1095 vsp.t1 avss 7.38751f
C1096 vsp.n3 avss 0.9172f
C1097 vsp.n4 avss 5.18906f
C1098 vsp.t5 avss 10.15908f
C1099 vsp.n5 avss 5.05934f
C1100 vsp.t12 avss 9.85472f
C1101 vsp.n6 avss 0.79436f
C1102 vsp.n7 avss 0.78961f
C1103 vsp.n8 avss 0.79436f
C1104 vsp.n9 avss 3.21892f
C1105 vsp.n10 avss 3.16792f
C1106 vsp.n11 avss 0.79436f
C1107 vsp.n12 avss 0.78961f
C1108 vsp.n13 avss 1.13203f
C1109 vsp.t2 avss 10.00193f
C1110 vgn2.t0 avss 3.13305f
C1111 vgn2.t3 avss 3.12637f
C1112 vgn2.t4 avss 3.12439f
C1113 vgn2.t1 avss 3.12761f
C1114 vgn2.t2 avss 3.12743f
C1115 vgn2.n0 avss 0.12398f
C1116 vgn2.t6 avss 6.1901f
C1117 vgn2.n1 avss 0.43117f
C1118 vgn2.n2 avss 0.38083f
C1119 vgn2.t5 avss 3.16961f
C1120 vgn2.n3 avss 0.21554f
C1121 vgn2.n4 avss 0.14325f
C1122 vgn2.n7 avss 0.88799f
C1123 vgn2.n8 avss 0.89325f
C1124 xf2.t6 avss 8.95142f
C1125 xf2.t8 avss 9.0925f
C1126 xf2.t5 avss 9.74618f
C1127 xf2.t1 avss 4.34425f
C1128 xf2.t3 avss 3.8774f
C1129 xf2.t4 avss 3.80262f
C1130 xf2.n0 avss 1.51297f
C1131 xf2.t9 avss 4.14254f
C1132 xf2.n1 avss 2.31965f
C1133 xf2.t10 avss 3.77871f
C1134 xf2.n2 avss 0.59938f
C1135 xf2.t11 avss 3.80533f
C1136 xf2.n3 avss 1.38278f
C1137 xf2.n4 avss 5.59512f
C1138 xf2.n5 avss 12.766f
C1139 xf2.t7 avss 9.06674f
C1140 xf2.n6 avss 5.54663f
C1141 xf2.t0 avss 9.07147f
C1142 xf2.n7 avss 0.99494f
C1143 xf2.n8 avss 2.65048f
C1144 xf2.n9 avss 4.17416f
C1145 xf2.t2 avss 8.95019f
C1146 xf1.t8 avss 8.71191f
C1147 xf1.t2 avss 9.20609f
C1148 xf1.t0 avss 3.87039f
C1149 xf1.t1 avss 3.79592f
C1150 xf1.n0 avss 1.50702f
C1151 xf1.t3 avss 4.20553f
C1152 xf1.t4 avss 3.79538f
C1153 xf1.n1 avss 2.17436f
C1154 xf1.t5 avss 3.7986f
C1155 xf1.n2 avss 1.57498f
C1156 xf1.n3 avss 1.44283f
C1157 xf1.t11 avss 3.6098f
C1158 xf1.n4 avss 4.03282f
C1159 xf1.n5 avss 12.9696f
C1160 xf1.t10 avss 8.6815f
C1161 xf1.n6 avss 5.17208f
C1162 xf1.t9 avss 8.73757f
C1163 xf1.n7 avss 3.00046f
C1164 xf1.n8 avss 3.46723f
C1165 xf1.t6 avss 8.74333f
C1166 xf1.n9 avss 1.5679f
C1167 xf1.t7 avss 8.66047f
C1168 vbp_cas.n0 avss 1.76259f
C1169 vbp_cas.n1 avss 1.07988f
C1170 vbp_cas.n2 avss 1.02082f
C1171 vbp_cas.n3 avss 0.97912f
C1172 vbp_cas.n4 avss 1.75453f
C1173 vbp_cas.n5 avss 0.96694f
C1174 vbp_cas.n6 avss 0.96465f
C1175 vbp_cas.n7 avss 0.96694f
C1176 vbp_cas.n8 avss 1.1694f
C1177 vbp_cas.t10 avss 3.12226f
C1178 vbp_cas.t4 avss 3.11958f
C1179 vbp_cas.t16 avss 3.08705f
C1180 vbp_cas.t12 avss 3.14823f
C1181 vbp_cas.t20 avss 3.08687f
C1182 vbp_cas.n9 avss 0.24565f
C1183 vbp_cas.n10 avss 1.43733f
C1184 vbp_cas.n11 avss 0.17075f
C1185 vbp_cas.t18 avss 3.08954f
C1186 vbp_cas.n12 avss 0.12078f
C1187 vbp_cas.t0 avss 0.67889f
C1188 vbp_cas.n13 avss 1.22466f
C1189 vbp_cas.n14 avss 0.79791f
C1190 vbp_cas.n15 avss 0.17397f
C1191 vbp_cas.n16 avss 0.18027f
C1192 vbp_cas.n17 avss 0.80877f
C1193 vbp_cas.n18 avss 0.76318f
C1194 vbp_cas.t14 avss 3.10721f
C1195 vbp_cas.n19 avss 0.25f
C1196 vbp_cas.t6 avss 3.08811f
C1197 vbp_cas.n20 avss 0.12128f
C1198 vbp_cas.n21 avss 0.81386f
C1199 vbp_cas.t8 avss 3.11958f
C1200 vbp_cas.n22 avss 0.11342f
C1201 vbp_cas.n23 avss 0.82022f
C1202 vbp_cas.t2 avss 3.12226f
C1203 vbp_cas.n24 avss 0.12128f
C1204 vbp_cas.n25 avss 0.81386f
C1205 vbp_cas.n26 avss 0.11342f
C1206 vbp_cas.n27 avss 0.82022f
C1207 vbp_cas.n28 avss 2.0224f
C1208 vbp_cas.n29 avss 2.4303f
C1209 psrg_vnc.t2 avss 2.48748f
C1210 psrg_vnc.n0 avss 11.4145f
C1211 psrg_vnc.t1 avss 2.50071f
C1212 psrg_vnc.t8 avss 2.53781f
C1213 psrg_vnc.t4 avss 2.5054f
C1214 psrg_vnc.n1 avss 0.72941f
C1215 psrg_vnc.t5 avss 2.50071f
C1216 psrg_vnc.n2 avss 0.48934f
C1217 psrg_vnc.t0 avss 2.5054f
C1218 psrg_vnc.n3 avss 0.49316f
C1219 psrg_vnc.n4 avss 0.47951f
C1220 psrg_vnc.n5 avss 0.70709f
C1221 psrg_vnc.t3 avss 2.49019f
C1222 psrg_vnc.n6 avss 0.82028f
C1223 psrg_vnc.t7 avss 2.04344f
C1224 psrg_vnc.n7 avss 0.85036f
C1225 psrg_vnc.n8 avss 2.78674f
C1226 psrg_vnc.n9 avss 3.80912f
C1227 psrg_m3_protected.t3 avss 1.61388f
C1228 psrg_m3_protected.t1 avss 4.05841f
C1229 psrg_m3_protected.t2 avss 3.9163f
C1230 psrg_m3_protected.n0 avss 1.43428f
C1231 psrg_m3_protected.n1 avss 1.76917f
C1232 psrg_m3_protected.t0 avss 1.11048f
C1233 vbn.t0 avss 10.2533f
C1234 vbn.n0 avss 16.1483f
C1235 vbn.t3 avss 2.08688f
C1236 vbn.n1 avss 2.50177f
C1237 vbn.n2 avss 0.70751f
C1238 vbn.t2 avss 2.97392f
C1239 iref_gate.t2 avss 2.20481f
C1240 iref_gate.t0 avss 9.22628f
C1241 iref_gate.n0 avss 18.9202f
C1242 iref_gate.n1 avss 2.3799f
C1243 iref_gate.t1 avss 9.15187f
C1244 pm2.t8 avss 5.77681f
C1245 pm2.t9 avss 6.34899f
C1246 pm2.n0 avss 2.85861f
C1247 pm2.t11 avss 5.77941f
C1248 pm2.n1 avss 2.3423f
C1249 pm2.t6 avss 5.83972f
C1250 pm2.t0 avss 4.88101f
C1251 pm2.t2 avss 4.92967f
C1252 pm2.t1 avss 4.88767f
C1253 pm2.n2 avss 1.86548f
C1254 pm2.n3 avss 1.89333f
C1255 pm2.t3 avss 4.87025f
C1256 pm2.t4 avss 4.89491f
C1257 pm2.t5 avss 5.23493f
C1258 pm2.n4 avss 2.3462f
C1259 pm2.n5 avss 1.21935f
C1260 pm2.n6 avss 7.61185f
C1261 pm2.n7 avss 5.81145f
C1262 pm2.n8 avss 1.84532f
C1263 pm2.t7 avss 5.77039f
C1264 pm2.n9 avss 1.67551f
C1265 pm2.t10 avss 5.71374f
C1266 pm1.n0 avss 3.39299f
C1267 pm1.t6 avss 5.80542f
C1268 pm1.t7 avss 5.56255f
C1269 pm1.n1 avss 1.55114f
C1270 pm1.t11 avss 5.6431f
C1271 pm1.t1 avss 4.76817f
C1272 pm1.t2 avss 4.95221f
C1273 pm1.t3 avss 5.07007f
C1274 pm1.t5 avss 4.83129f
C1275 pm1.t4 avss 4.79016f
C1276 pm1.n2 avss 2.21222f
C1277 pm1.n3 avss 0.68934f
C1278 pm1.t0 avss 4.77588f
C1279 pm1.n4 avss 5.32074f
C1280 pm1.n5 avss 6.33807f
C1281 pm1.t8 avss 5.66075f
C1282 pm1.n6 avss 2.35f
C1283 pm1.t9 avss 5.68774f
C1284 pm1.n7 avss 2.14139f
C1285 pm1.n8 avss 2.62575f
C1286 pm1.t10 avss 5.36978f
C1287 y1.t4 avss 3.95085f
C1288 y1.t2 avss 11.60074f
C1289 y1.n0 avss 1.97186f
C1290 y1.n1 avss 1.06475f
C1291 y1.n2 avss 1.05857f
C1292 y1.n3 avss 1.06475f
C1293 y1.n4 avss 2.38957f
C1294 y1.n5 avss 1.96451f
C1295 y1.n6 avss 1.06069f
C1296 y1.n7 avss 1.05513f
C1297 y1.n8 avss 1.06069f
C1298 y1.n9 avss 0.9564f
C1299 y1.n10 avss 1.75959f
C1300 y1.t6 avss 3.99375f
C1301 y1.n11 avss 1.9438f
C1302 y1.t3 avss 3.95068f
C1303 y1.n12 avss 0.66418f
C1304 y1.n13 avss 0.54331f
C1305 y1.t1 avss 3.8493f
C1306 y1.t0 avss 4.04981f
C1307 y1.n14 avss 0.61362f
C1308 y1.n15 avss 0.93991f
C1309 y1.t5 avss 3.69048f
C1310 psrg_mf1_protected.t1 avss 11.48392f
C1311 psrg_mf1_protected.t0 avss 6.41163f
C1312 avss.t234 avss 49.4872f
C1313 avss.t6 avss 0.56976f
C1314 avss.t0 avss 7.80641f
C1315 avss.t240 avss 3.07737f
C1316 avss.t239 avss 1.34375f
C1317 avss.t208 avss 2.12742f
C1318 avss.t209 avss 2.09724f
C1319 avss.t210 avss 2.09569f
C1320 avss.t236 avss 2.09724f
C1321 avss.t237 avss 2.09569f
C1322 avss.t238 avss 1.93495f
C1323 avss.t203 avss 2.12712f
C1324 avss.t204 avss 2.09694f
C1325 avss.t205 avss 2.09539f
C1326 avss.t7 avss 2.09694f
C1327 avss.t8 avss 2.09539f
C1328 avss.t3 avss 2.03759f
C1329 avss.t218 avss 16.03639f
C1330 avss.t222 avss 15.95368f
C1331 avss.t220 avss 15.99849f
C1332 avss.t216 avss 15.99206f
C1333 avss.t214 avss 16.43016f
C1334 avss.t206 avss 17.85634f
C1335 avss.t207 avss 6.95262f
C1336 avss.t4 avss 1.6345f
C1337 avss.t5 avss 1.63627f
C1338 avss.t213 avss 0.72593f
C1339 avss.t212 avss 2.25547f
C1340 avss.t1 avss 2.25547f
C1341 avss.t211 avss 2.84502f
C1342 avss.t2 avss 4.56465f
C1343 dvdd.n0 avss 4.7158f
C1344 dvdd.n1 avss 56.7641f
C1345 dvdd.n2 avss 0.70175f
C1346 dvdd.t2 avss 0.32398f
C1347 dvdd.t6 avss 0.34522f
C1348 dvdd.t4 avss 0.37118f
C1349 dvdd.t0 avss 0.36838f
C1350 dvdd.n3 avss 1.30974f
C1351 dvdd.t3 avss 0.37284f
C1352 dvdd.n4 avss 9.50888f
C1353 dvdd.t5 avss 0.34207f
C1354 dvdd.n5 avss 0.2607f
C1355 dvdd.t1 avss 0.47388f
C1356 dvdd.n6 avss 3.95639f
C1357 dvdd.n7 avss 8.75311f
C1358 dvdd.n8 avss 1.25154f
C1359 dvdd.n9 avss 1.06931f
C1360 dvdd.n10 avss 1.51913f
C1361 dvdd.n11 avss 3.66787f
C1362 dvdd.n12 avss 18.648f
C1363 avdd.n0 avss 13.2977f
C1364 avdd.n1 avss 19.9662f
C1365 avdd.n2 avss 1.44738f
C1366 avdd.n3 avss 3.20765f
C1367 avdd.n4 avss 6.71937f
C1368 avdd.n5 avss 13.6511f
C1369 avdd.n6 avss 10.0058f
C1370 avdd.n8 avss 1.66023f
C1371 avdd.n9 avss 2.39451f
C1372 avdd.n10 avss 2.59871f
C1373 avdd.n11 avss 10.2287f
C1374 avdd.n13 avss 1.99534f
C1375 avdd.n14 avss 7.95771f
C1376 avdd.n15 avss 0.95448f
C1377 avdd.n16 avss 0.81922f
C1378 avdd.n19 avss 0.33403f
C1379 avdd.n20 avss 0.13144f
C1380 avdd.n21 avss 0.81844f
C1381 avdd.n24 avss 0.23056f
C1382 avdd.n26 avss 0.55763f
C1383 avdd.n27 avss 0.35694f
C1384 avdd.n29 avss 6.83688f
C1385 avdd.n30 avss 1.5798f
C1386 avdd.n31 avss 0.52743f
C1387 avdd.n35 avss 0.11821f
C1388 avdd.n36 avss 1.03171f
C1389 avdd.n37 avss 0.55222f
C1390 avdd.n38 avss 2.71526f
C1391 avdd.n39 avss 0.90709f
C1392 avdd.n40 avss 2.35376f
C1393 avdd.n41 avss 2.45725f
C1394 avdd.n42 avss 1.80027f
C1395 avdd.n43 avss 0.81766f
C1396 avdd.n44 avss 1.17607f
C1397 avdd.n45 avss 1.74404f
C1398 avdd.n46 avss 1.79938f
C1399 avdd.n47 avss 2.32194f
C1400 avdd.n48 avss 2.35216f
C1401 avdd.n49 avss 1.86993f
C1402 avdd.n50 avss 0.17062f
C1403 avdd.n51 avss 4.29999f
C1404 avdd.n52 avss 5.80009f
C1405 avdd.n53 avss 1.0896f
C1406 avdd.n54 avss 2.14241f
C1407 avdd.n55 avss 6.00778f
C1408 avdd.n56 avss 1.10212f
C1409 avdd.n58 avss 2.00337f
C1410 avdd.n59 avss 2.02144f
C1411 avdd.n60 avss 1.5082f
C1412 avdd.n62 avss 1.11935f
C1413 avdd.n63 avss 2.56339f
C1414 avdd.n64 avss 2.43942f
C1415 avdd.n65 avss 2.27103f
C1416 avdd.n66 avss 1.36549f
C1417 avdd.n67 avss 2.84624f
C1418 avdd.n68 avss 2.56218f
C1419 avdd.n69 avss 2.78785f
C1420 avdd.n70 avss 2.72639f
C1421 avdd.n71 avss 2.65895f
C1422 avdd.n72 avss 1.99492f
C1423 avdd.n73 avss 1.43319f
C1424 avdd.n74 avss 2.60466f
C1425 avdd.n75 avss 2.3996f
C1426 avdd.n76 avss 2.14257f
C1427 avdd.n77 avss 2.60161f
C1428 avdd.n78 avss 1.27864f
C1429 avdd.n79 avss 0.11194f
C1430 avdd.n81 avss 2.66415f
C1431 avdd.n82 avss 2.39158f
C1432 avdd.n83 avss 2.43189f
C1433 avdd.n84 avss 2.19875f
C1434 avdd.n85 avss 2.01062f
C1435 avdd.n86 avss 0.15438f
C1436 avdd.n87 avss 0.14949f
C1437 avdd.n88 avss 0.87414f
C1438 avdd.n89 avss 0.63744f
C1439 avdd.t131 avss 0.39534f
C1440 avdd.t132 avss 0.39534f
C1441 avdd.n90 avss 1.12326f
C1442 avdd.t128 avss 0.3957f
C1443 avdd.t129 avss 0.3957f
C1444 avdd.n92 avss 1.12326f
C1445 avdd.n93 avss 1.3674f
C1446 avdd.t155 avss 0.39488f
C1447 avdd.t156 avss 0.39488f
C1448 avdd.n94 avss 1.12125f
C1449 avdd.n95 avss 1.36473f
C1450 avdd.n96 avss 1.1284f
C1451 avdd.t152 avss 0.39488f
C1452 avdd.t153 avss 0.39488f
C1453 avdd.n97 avss 1.12125f
C1454 avdd.n98 avss 1.36473f
C1455 avdd.t584 avss 2.59534f
C1456 avdd.t149 avss 0.39488f
C1457 avdd.t150 avss 0.39488f
C1458 avdd.n100 avss 1.12125f
C1459 avdd.n101 avss 1.36473f
C1460 avdd.t173 avss 0.39488f
C1461 avdd.t174 avss 0.39488f
C1462 avdd.n102 avss 1.12125f
C1463 avdd.n103 avss 1.36473f
C1464 avdd.n104 avss 1.11372f
C1465 avdd.t182 avss 0.39488f
C1466 avdd.t183 avss 0.39488f
C1467 avdd.n105 avss 1.12125f
C1468 avdd.n106 avss 1.36473f
C1469 avdd.n107 avss 1.44984f
C1470 avdd.t188 avss 0.39488f
C1471 avdd.t189 avss 0.39488f
C1472 avdd.n108 avss 1.12125f
C1473 avdd.n109 avss 1.36473f
C1474 avdd.n110 avss 1.10141f
C1475 avdd.n111 avss 0.19818f
C1476 avdd.t0 avss 3.86669f
C1477 avdd.n112 avss 0.15314f
C1478 avdd.n113 avss 0.10165f
C1479 avdd.t637 avss 3.83151f
C1480 avdd.n115 avss 2.27689f
C1481 avdd.n117 avss 0.61919f
C1482 avdd.t620 avss 3.81172f
C1483 avdd.t621 avss 3.81129f
C1484 avdd.t656 avss 3.85877f
C1485 avdd.t633 avss 3.86161f
C1486 avdd.n118 avss 0.65443f
C1487 avdd.t495 avss 0.23479f
C1488 avdd.t496 avss 0.23479f
C1489 avdd.n119 avss 0.78671f
C1490 avdd.n120 avss 0.86304f
C1491 avdd.t492 avss 0.23479f
C1492 avdd.t493 avss 0.23479f
C1493 avdd.n121 avss 0.78671f
C1494 avdd.n122 avss 0.79497f
C1495 avdd.n123 avss 0.63363f
C1496 avdd.t489 avss 0.23479f
C1497 avdd.t490 avss 0.23479f
C1498 avdd.n124 avss 0.78671f
C1499 avdd.n125 avss 0.79497f
C1500 avdd.t486 avss 0.23479f
C1501 avdd.t487 avss 0.23479f
C1502 avdd.n126 avss 0.78671f
C1503 avdd.n127 avss 0.79497f
C1504 avdd.t483 avss 0.23479f
C1505 avdd.t484 avss 0.23479f
C1506 avdd.n128 avss 0.78671f
C1507 avdd.n129 avss 0.79497f
C1508 avdd.t480 avss 0.23479f
C1509 avdd.t481 avss 0.23479f
C1510 avdd.n130 avss 0.78671f
C1511 avdd.n131 avss 0.79497f
C1512 avdd.n132 avss 0.63362f
C1513 avdd.t477 avss 0.23479f
C1514 avdd.t478 avss 0.23479f
C1515 avdd.n133 avss 0.78671f
C1516 avdd.n134 avss 0.79497f
C1517 avdd.n135 avss 0.28645f
C1518 avdd.t504 avss 0.23364f
C1519 avdd.n136 avss 0.12677f
C1520 avdd.n138 avss 0.71707f
C1521 avdd.t636 avss 2.39688f
C1522 avdd.t624 avss 2.3684f
C1523 avdd.n139 avss 0.16961f
C1524 avdd.t625 avss 2.37056f
C1525 avdd.n140 avss 0.10526f
C1526 avdd.t626 avss 2.3684f
C1527 avdd.n141 avss 0.10526f
C1528 avdd.t627 avss 2.37056f
C1529 avdd.n142 avss 0.10526f
C1530 avdd.t657 avss 2.3684f
C1531 avdd.n144 avss 0.50164f
C1532 avdd.n145 avss 0.35661f
C1533 avdd.t638 avss 2.39826f
C1534 avdd.t596 avss 2.37001f
C1535 avdd.n146 avss 0.16961f
C1536 avdd.t640 avss 2.37186f
C1537 avdd.n147 avss 0.10526f
C1538 avdd.t639 avss 2.37001f
C1539 avdd.n148 avss 0.10526f
C1540 avdd.t634 avss 2.37186f
C1541 avdd.n149 avss 0.10526f
C1542 avdd.t635 avss 2.37001f
C1543 avdd.n152 avss 0.3066f
C1544 avdd.t507 avss 0.23479f
C1545 avdd.t508 avss 0.23479f
C1546 avdd.n153 avss 0.78671f
C1547 avdd.n154 avss 0.79497f
C1548 avdd.n155 avss 1.31704f
C1549 avdd.n156 avss 1.25659f
C1550 avdd.t561 avss 0.23479f
C1551 avdd.t562 avss 0.23479f
C1552 avdd.n157 avss 0.78671f
C1553 avdd.n158 avss 0.79497f
C1554 avdd.n159 avss 0.63054f
C1555 avdd.t558 avss 0.23479f
C1556 avdd.t559 avss 0.23479f
C1557 avdd.n160 avss 0.78671f
C1558 avdd.n161 avss 0.79497f
C1559 avdd.n162 avss 0.63191f
C1560 avdd.n163 avss 4.28035f
C1561 avdd.t555 avss 0.23479f
C1562 avdd.t556 avss 0.23479f
C1563 avdd.n164 avss 0.78671f
C1564 avdd.n165 avss 0.79497f
C1565 avdd.t552 avss 0.23479f
C1566 avdd.t553 avss 0.23479f
C1567 avdd.n166 avss 0.78671f
C1568 avdd.n167 avss 0.79497f
C1569 avdd.t549 avss 0.23479f
C1570 avdd.t550 avss 0.23479f
C1571 avdd.n168 avss 0.78671f
C1572 avdd.n169 avss 0.79497f
C1573 avdd.t546 avss 0.23479f
C1574 avdd.t547 avss 0.23479f
C1575 avdd.n170 avss 0.78671f
C1576 avdd.n171 avss 0.79497f
C1577 avdd.t543 avss 0.23479f
C1578 avdd.t544 avss 0.23479f
C1579 avdd.n172 avss 0.78671f
C1580 avdd.n173 avss 0.79497f
C1581 avdd.t468 avss 0.45997f
C1582 avdd.t469 avss 0.45997f
C1583 avdd.n174 avss 1.28822f
C1584 avdd.n175 avss 1.58256f
C1585 avdd.t439 avss 0.45997f
C1586 avdd.t440 avss 0.45997f
C1587 avdd.n176 avss 1.28822f
C1588 avdd.n177 avss 2.30997f
C1589 avdd.t436 avss 0.45997f
C1590 avdd.t437 avss 0.45997f
C1591 avdd.n178 avss 1.28822f
C1592 avdd.n179 avss 1.58256f
C1593 avdd.n180 avss 4.03407f
C1594 avdd.t433 avss 0.45997f
C1595 avdd.t434 avss 0.45997f
C1596 avdd.n181 avss 1.28822f
C1597 avdd.n182 avss 1.58256f
C1598 avdd.n183 avss 2.38747f
C1599 avdd.t430 avss 0.45997f
C1600 avdd.t431 avss 0.45997f
C1601 avdd.n184 avss 1.28822f
C1602 avdd.n185 avss 1.58256f
C1603 avdd.n186 avss 2.38747f
C1604 avdd.t427 avss 0.45997f
C1605 avdd.t428 avss 0.45997f
C1606 avdd.n187 avss 1.28822f
C1607 avdd.n188 avss 1.58256f
C1608 avdd.n189 avss 2.38747f
C1609 avdd.t424 avss 0.45997f
C1610 avdd.t425 avss 0.45997f
C1611 avdd.n190 avss 1.28822f
C1612 avdd.n191 avss 1.58256f
C1613 avdd.n192 avss 2.38747f
C1614 avdd.t421 avss 0.45997f
C1615 avdd.t422 avss 0.45997f
C1616 avdd.n193 avss 1.28822f
C1617 avdd.n194 avss 1.58256f
C1618 avdd.n195 avss 2.38719f
C1619 avdd.t418 avss 0.45997f
C1620 avdd.t419 avss 0.45997f
C1621 avdd.n196 avss 1.28822f
C1622 avdd.n197 avss 1.59009f
C1623 avdd.n198 avss 2.57913f
C1624 avdd.t501 avss 0.45997f
C1625 avdd.t502 avss 0.45997f
C1626 avdd.n199 avss 1.28822f
C1627 avdd.n200 avss 4.27961f
C1628 avdd.n201 avss 2.21225f
C1629 avdd.t416 avss 2.11196f
C1630 avdd.n202 avss 3.02596f
C1631 avdd.n203 avss 4.33765f
C1632 avdd.t531 avss 0.45997f
C1633 avdd.t532 avss 0.45997f
C1634 avdd.n204 avss 1.28822f
C1635 avdd.n205 avss 2.31503f
C1636 avdd.t528 avss 0.45997f
C1637 avdd.t529 avss 0.45997f
C1638 avdd.n206 avss 1.28822f
C1639 avdd.n207 avss 1.58256f
C1640 avdd.n208 avss 4.02901f
C1641 avdd.t525 avss 0.45997f
C1642 avdd.t526 avss 0.45997f
C1643 avdd.n209 avss 1.28822f
C1644 avdd.n210 avss 1.58256f
C1645 avdd.n211 avss 2.38747f
C1646 avdd.t522 avss 0.45997f
C1647 avdd.t523 avss 0.45997f
C1648 avdd.n212 avss 1.28822f
C1649 avdd.n213 avss 1.58256f
C1650 avdd.n214 avss 2.38747f
C1651 avdd.t519 avss 0.45997f
C1652 avdd.t520 avss 0.45997f
C1653 avdd.n215 avss 1.28822f
C1654 avdd.n216 avss 1.58256f
C1655 avdd.n217 avss 2.38747f
C1656 avdd.t516 avss 0.45997f
C1657 avdd.t517 avss 0.45997f
C1658 avdd.n218 avss 1.28822f
C1659 avdd.n219 avss 1.58256f
C1660 avdd.n220 avss 2.38747f
C1661 avdd.t513 avss 0.45997f
C1662 avdd.t514 avss 0.45997f
C1663 avdd.n221 avss 1.28822f
C1664 avdd.n222 avss 1.58256f
C1665 avdd.n223 avss 2.39098f
C1666 avdd.t510 avss 0.45997f
C1667 avdd.t511 avss 0.45997f
C1668 avdd.n224 avss 1.28822f
C1669 avdd.n225 avss 1.58256f
C1670 avdd.n226 avss 1.29811f
C1671 avdd.t498 avss 0.45997f
C1672 avdd.t499 avss 0.45997f
C1673 avdd.n227 avss 1.28822f
C1674 avdd.n228 avss 1.58256f
C1675 avdd.n229 avss 1.49453f
C1676 avdd.n230 avss 0.89244f
C1677 avdd.t466 avss 2.11196f
C1678 avdd.n231 avss 3.02596f
C1679 avdd.t464 avss 2.11196f
C1680 avdd.n232 avss 3.02596f
C1681 avdd.t462 avss 2.11196f
C1682 avdd.n233 avss 3.02596f
C1683 avdd.t460 avss 2.11196f
C1684 avdd.n234 avss 3.02596f
C1685 avdd.t458 avss 2.11196f
C1686 avdd.n235 avss 3.02596f
C1687 avdd.t456 avss 2.11196f
C1688 avdd.n236 avss 3.02596f
C1689 avdd.t454 avss 2.11196f
C1690 avdd.n237 avss 3.02596f
C1691 avdd.t452 avss 2.11196f
C1692 avdd.n238 avss 3.02596f
C1693 avdd.t450 avss 2.11196f
C1694 avdd.n239 avss 3.02596f
C1695 avdd.t448 avss 2.11196f
C1696 avdd.n240 avss 3.02596f
C1697 avdd.t446 avss 2.11196f
C1698 avdd.n241 avss 3.02596f
C1699 avdd.t444 avss 2.11196f
C1700 avdd.n242 avss 3.02596f
C1701 avdd.t566 avss 1.40364f
C1702 avdd.t644 avss 1.40462f
C1703 avdd.n244 avss 0.65302f
C1704 avdd.t414 avss 2.11196f
C1705 avdd.n245 avss 4.48006f
C1706 avdd.n246 avss 3.4831f
C1707 avdd.t412 avss 2.11196f
C1708 avdd.n247 avss 3.02596f
C1709 avdd.n248 avss 4.26676f
C1710 avdd.n249 avss 0.14034f
C1711 avdd.n250 avss 0.89982f
C1712 avdd.t442 avss 3.11238f
C1713 avdd.n251 avss 0.57075f
C1714 avdd.t583 avss 1.20078f
C1715 avdd.t645 avss 1.20338f
C1716 avdd.t610 avss 1.20297f
C1717 avdd.t611 avss 1.20168f
C1718 avdd.t582 avss 1.20297f
C1719 avdd.t606 avss 1.20307f
C1720 avdd.n256 avss 1.91831f
C1721 avdd.t605 avss 1.20297f
C1722 avdd.n258 avss 1.34623f
C1723 avdd.n259 avss 3.93534f
C1724 avdd.n260 avss 2.92502f
C1725 avdd.n261 avss 2.92502f
C1726 avdd.n262 avss 2.92502f
C1727 avdd.n263 avss 2.92502f
C1728 avdd.n264 avss 2.92502f
C1729 avdd.n265 avss 2.92502f
C1730 avdd.n266 avss 2.92502f
C1731 avdd.n267 avss 2.92502f
C1732 avdd.n268 avss 2.92502f
C1733 avdd.n269 avss 2.92502f
C1734 avdd.n270 avss 2.92502f
C1735 avdd.n271 avss 2.19091f
C1736 avdd.n272 avss 0.76122f
C1737 avdd.n273 avss 0.26322f
C1738 avdd.n274 avss 0.86938f
C1739 avdd.n275 avss 2.09302f
C1740 avdd.t471 avss 0.45997f
C1741 avdd.t472 avss 0.45997f
C1742 avdd.n276 avss 1.28822f
C1743 avdd.n277 avss 1.58256f
C1744 avdd.n278 avss 3.38396f
C1745 avdd.t663 avss 8.41304f
C1746 avdd.n279 avss 0.22194f
C1747 avdd.t641 avss 1.24988f
C1748 avdd.n280 avss 0.19493f
C1749 avdd.n281 avss 0.10157f
C1750 avdd.t649 avss 0.4224f
C1751 avdd.n285 avss 0.1618f
C1752 avdd.t540 avss 0.23479f
C1753 avdd.t541 avss 0.23479f
C1754 avdd.n286 avss 0.78671f
C1755 avdd.n287 avss 0.79497f
C1756 avdd.n288 avss 0.62274f
C1757 avdd.n290 avss 1.13366f
C1758 avdd.n291 avss 0.63693f
C1759 avdd.n293 avss 0.63918f
C1760 avdd.n294 avss 0.63191f
C1761 avdd.n295 avss 0.63918f
C1762 avdd.n296 avss 1.89536f
C1763 avdd.n297 avss 1.22081f
C1764 avdd.n298 avss 4.17748f
C1765 avdd.n299 avss 0.96937f
C1766 avdd.t537 avss 0.23479f
C1767 avdd.t538 avss 0.23479f
C1768 avdd.n300 avss 0.78671f
C1769 avdd.n301 avss 0.79497f
C1770 avdd.n302 avss 1.36535f
C1771 avdd.n303 avss 0.66578f
C1772 avdd.n305 avss 0.37768f
C1773 avdd.t534 avss 0.23364f
C1774 avdd.t535 avss 0.23364f
C1775 avdd.n306 avss 0.78671f
C1776 avdd.n308 avss 0.10858f
C1777 avdd.n310 avss 0.45106f
C1778 avdd.n311 avss 0.35585f
C1779 avdd.n312 avss 0.60381f
C1780 avdd.t505 avss 0.23364f
C1781 avdd.n315 avss 0.78671f
C1782 avdd.n316 avss 0.37768f
C1783 avdd.t474 avss 0.23479f
C1784 avdd.t475 avss 0.23479f
C1785 avdd.n318 avss 0.78671f
C1786 avdd.n319 avss 0.79497f
C1787 avdd.n320 avss 1.12653f
C1788 avdd.n321 avss 0.651f
C1789 avdd.n323 avss 0.64181f
C1790 avdd.n324 avss 0.63362f
C1791 avdd.n325 avss 0.64181f
C1792 avdd.n326 avss 12.7514f
C1793 avdd.t170 avss 0.39488f
C1794 avdd.t171 avss 0.39488f
C1795 avdd.n327 avss 1.12125f
C1796 avdd.n328 avss 1.36473f
C1797 avdd.t167 avss 0.39488f
C1798 avdd.t168 avss 0.39488f
C1799 avdd.n329 avss 1.12125f
C1800 avdd.n330 avss 1.36473f
C1801 avdd.t164 avss 0.39488f
C1802 avdd.t165 avss 0.39488f
C1803 avdd.n331 avss 1.12125f
C1804 avdd.n332 avss 1.36473f
C1805 avdd.n333 avss 1.12828f
C1806 avdd.t143 avss 0.3957f
C1807 avdd.t144 avss 0.3957f
C1808 avdd.n334 avss 1.12326f
C1809 avdd.n335 avss 1.3674f
C1810 avdd.n336 avss 1.12449f
C1811 avdd.t122 avss 0.3957f
C1812 avdd.t123 avss 0.3957f
C1813 avdd.n337 avss 1.12326f
C1814 avdd.n338 avss 1.3674f
C1815 avdd.t642 avss 2.59896f
C1816 avdd.t77 avss 0.3957f
C1817 avdd.t78 avss 0.3957f
C1818 avdd.n339 avss 1.12326f
C1819 avdd.n340 avss 1.3674f
C1820 avdd.n341 avss 1.32964f
C1821 avdd.t569 avss 2.64492f
C1822 avdd.t570 avss 2.59509f
C1823 avdd.n343 avss 0.47125f
C1824 avdd.t74 avss 0.3957f
C1825 avdd.t75 avss 0.3957f
C1826 avdd.n344 avss 1.12326f
C1827 avdd.n345 avss 1.3674f
C1828 avdd.n346 avss 1.11592f
C1829 avdd.t613 avss 2.596f
C1830 avdd.t612 avss 2.59986f
C1831 avdd.t44 avss 0.3957f
C1832 avdd.t45 avss 0.3957f
C1833 avdd.n347 avss 1.12326f
C1834 avdd.n348 avss 1.3674f
C1835 avdd.n349 avss 1.1177f
C1836 avdd.t41 avss 0.3957f
C1837 avdd.t42 avss 0.3957f
C1838 avdd.n350 avss 1.12326f
C1839 avdd.n351 avss 1.3674f
C1840 avdd.t119 avss 0.3957f
C1841 avdd.t120 avss 0.3957f
C1842 avdd.n352 avss 1.12326f
C1843 avdd.n353 avss 1.3674f
C1844 avdd.n354 avss 0.29029f
C1845 avdd.t125 avss 0.3957f
C1846 avdd.t126 avss 0.3957f
C1847 avdd.n355 avss 1.12326f
C1848 avdd.n356 avss 1.3674f
C1849 avdd.n357 avss 1.09423f
C1850 avdd.t577 avss 2.84703f
C1851 avdd.t574 avss 2.57898f
C1852 avdd.t607 avss 2.56741f
C1853 avdd.n359 avss 0.67019f
C1854 avdd.t632 avss 2.57039f
C1855 avdd.t575 avss 2.60635f
C1856 avdd.t5 avss 0.3908f
C1857 avdd.t6 avss 0.3908f
C1858 avdd.n360 avss 1.11118f
C1859 avdd.n361 avss 1.35138f
C1860 avdd.n362 avss 1.11136f
C1861 avdd.t38 avss 0.3908f
C1862 avdd.t39 avss 0.3908f
C1863 avdd.n363 avss 1.11118f
C1864 avdd.n364 avss 1.35138f
C1865 avdd.t35 avss 0.3908f
C1866 avdd.t36 avss 0.3908f
C1867 avdd.n365 avss 1.11118f
C1868 avdd.n366 avss 1.35138f
C1869 avdd.t32 avss 0.3908f
C1870 avdd.t33 avss 0.3908f
C1871 avdd.n367 avss 1.11118f
C1872 avdd.n368 avss 1.35138f
C1873 avdd.t29 avss 0.3908f
C1874 avdd.t30 avss 0.3908f
C1875 avdd.n369 avss 1.11118f
C1876 avdd.n370 avss 1.35138f
C1877 avdd.t26 avss 0.3908f
C1878 avdd.t27 avss 0.3908f
C1879 avdd.n371 avss 1.11118f
C1880 avdd.n372 avss 1.35138f
C1881 avdd.t23 avss 0.3908f
C1882 avdd.t24 avss 0.3908f
C1883 avdd.n373 avss 1.11118f
C1884 avdd.n374 avss 1.35138f
C1885 avdd.t598 avss 2.56774f
C1886 avdd.n375 avss 1.28281f
C1887 avdd.n376 avss 0.15671f
C1888 avdd.t71 avss 0.3908f
C1889 avdd.t72 avss 0.3908f
C1890 avdd.n377 avss 1.11118f
C1891 avdd.n378 avss 1.35138f
C1892 avdd.n379 avss 1.08109f
C1893 avdd.n380 avss 0.79203f
C1894 avdd.n381 avss 0.72378f
C1895 avdd.t113 avss 0.39044f
C1896 avdd.t114 avss 0.39044f
C1897 avdd.n382 avss 1.11118f
C1898 avdd.t110 avss 0.3908f
C1899 avdd.t111 avss 0.3908f
C1900 avdd.n384 avss 1.11118f
C1901 avdd.n385 avss 1.35138f
C1902 avdd.t107 avss 0.3908f
C1903 avdd.t108 avss 0.3908f
C1904 avdd.n386 avss 1.11118f
C1905 avdd.n387 avss 1.35138f
C1906 avdd.t104 avss 0.3908f
C1907 avdd.t105 avss 0.3908f
C1908 avdd.n388 avss 1.11118f
C1909 avdd.n389 avss 1.35138f
C1910 avdd.t101 avss 0.3908f
C1911 avdd.t102 avss 0.3908f
C1912 avdd.n390 avss 1.11118f
C1913 avdd.n391 avss 1.35138f
C1914 avdd.t98 avss 0.3908f
C1915 avdd.t99 avss 0.3908f
C1916 avdd.n392 avss 1.11118f
C1917 avdd.n393 avss 1.35138f
C1918 avdd.t95 avss 0.3908f
C1919 avdd.t96 avss 0.3908f
C1920 avdd.n394 avss 1.11118f
C1921 avdd.n395 avss 1.35138f
C1922 avdd.t92 avss 0.3908f
C1923 avdd.t93 avss 0.3908f
C1924 avdd.n396 avss 1.11118f
C1925 avdd.n397 avss 1.35138f
C1926 avdd.t89 avss 0.3908f
C1927 avdd.t90 avss 0.3908f
C1928 avdd.n398 avss 1.11118f
C1929 avdd.n399 avss 1.35138f
C1930 avdd.t86 avss 0.3908f
C1931 avdd.t87 avss 0.3908f
C1932 avdd.n400 avss 1.11118f
C1933 avdd.n401 avss 1.35138f
C1934 avdd.t83 avss 0.3908f
C1935 avdd.t84 avss 0.3908f
C1936 avdd.n402 avss 1.11118f
C1937 avdd.n403 avss 1.35138f
C1938 avdd.t80 avss 0.3908f
C1939 avdd.t81 avss 0.3908f
C1940 avdd.n404 avss 1.11118f
C1941 avdd.n405 avss 1.35138f
C1942 avdd.n406 avss 1.1074f
C1943 avdd.n407 avss 1.12076f
C1944 avdd.n408 avss 1.1195f
C1945 avdd.n409 avss 1.12083f
C1946 avdd.t623 avss 0.69602f
C1947 avdd.t653 avss 1.07283f
C1948 avdd.t654 avss 1.08271f
C1949 avdd.n412 avss 0.24044f
C1950 avdd.t266 avss 0.11108f
C1951 avdd.t267 avss 0.11108f
C1952 avdd.n413 avss 0.47566f
C1953 avdd.n414 avss 0.3716f
C1954 avdd.n415 avss 0.13032f
C1955 avdd.t661 avss 2.04998f
C1956 avdd.n419 avss 0.33286f
C1957 avdd.t659 avss 2.04123f
C1958 avdd.t591 avss 2.04257f
C1959 avdd.n423 avss 0.11081f
C1960 avdd.n424 avss 0.64114f
C1961 avdd.n425 avss 0.16942f
C1962 avdd.n426 avss 0.16957f
C1963 avdd.t284 avss 0.11108f
C1964 avdd.t285 avss 0.11108f
C1965 avdd.n427 avss 0.47566f
C1966 avdd.n428 avss 0.3716f
C1967 avdd.n429 avss 0.3269f
C1968 avdd.t281 avss 0.11108f
C1969 avdd.t282 avss 0.11108f
C1970 avdd.n430 avss 0.47566f
C1971 avdd.n431 avss 0.47982f
C1972 avdd.n432 avss 0.16571f
C1973 avdd.t278 avss 0.11108f
C1974 avdd.t279 avss 0.11108f
C1975 avdd.n433 avss 0.47566f
C1976 avdd.n434 avss 0.47982f
C1977 avdd.n435 avss 0.15953f
C1978 avdd.t275 avss 0.11108f
C1979 avdd.t276 avss 0.11108f
C1980 avdd.n436 avss 0.47566f
C1981 avdd.n437 avss 0.47982f
C1982 avdd.n438 avss 0.15953f
C1983 avdd.t272 avss 0.11108f
C1984 avdd.t273 avss 0.11108f
C1985 avdd.n439 avss 0.47566f
C1986 avdd.n440 avss 0.47982f
C1987 avdd.n441 avss 0.15953f
C1988 avdd.t269 avss 0.11108f
C1989 avdd.t270 avss 0.11108f
C1990 avdd.n442 avss 0.47566f
C1991 avdd.n443 avss 0.47982f
C1992 avdd.n444 avss 0.16571f
C1993 avdd.n445 avss 0.26059f
C1994 avdd.t263 avss 0.11108f
C1995 avdd.t264 avss 0.11108f
C1996 avdd.n446 avss 0.47566f
C1997 avdd.n447 avss 0.3716f
C1998 avdd.n448 avss 0.26875f
C1999 avdd.n449 avss 0.19046f
C2000 avdd.n450 avss 0.17038f
C2001 avdd.n451 avss 0.17112f
C2002 avdd.t409 avss 0.11108f
C2003 avdd.t410 avss 0.11108f
C2004 avdd.n452 avss 0.47566f
C2005 avdd.n453 avss 0.5354f
C2006 avdd.t406 avss 0.11108f
C2007 avdd.t407 avss 0.11108f
C2008 avdd.n454 avss 0.47566f
C2009 avdd.n455 avss 0.37154f
C2010 avdd.n456 avss 0.35884f
C2011 avdd.t403 avss 0.11108f
C2012 avdd.t404 avss 0.11108f
C2013 avdd.n457 avss 0.47566f
C2014 avdd.n458 avss 0.47942f
C2015 avdd.n459 avss 0.17227f
C2016 avdd.t400 avss 0.11108f
C2017 avdd.t401 avss 0.11108f
C2018 avdd.n460 avss 0.47566f
C2019 avdd.n461 avss 0.37186f
C2020 avdd.n462 avss 0.26231f
C2021 avdd.t397 avss 0.11108f
C2022 avdd.t398 avss 0.11108f
C2023 avdd.n463 avss 0.47566f
C2024 avdd.n464 avss 0.37154f
C2025 avdd.n465 avss 0.26063f
C2026 avdd.t394 avss 0.11108f
C2027 avdd.t395 avss 0.11108f
C2028 avdd.n466 avss 0.47566f
C2029 avdd.n467 avss 0.47942f
C2030 avdd.n468 avss 0.16611f
C2031 avdd.t391 avss 0.11108f
C2032 avdd.t392 avss 0.11108f
C2033 avdd.n469 avss 0.47566f
C2034 avdd.n470 avss 0.47942f
C2035 avdd.n471 avss 0.15872f
C2036 avdd.t388 avss 0.11108f
C2037 avdd.t389 avss 0.11108f
C2038 avdd.n472 avss 0.47566f
C2039 avdd.n473 avss 0.47942f
C2040 avdd.n474 avss 0.17378f
C2041 avdd.t364 avss 0.11108f
C2042 avdd.t365 avss 0.11108f
C2043 avdd.n480 avss 0.47566f
C2044 avdd.n481 avss 0.90153f
C2045 avdd.t564 avss 1.67685f
C2046 avdd.t576 avss 1.67528f
C2047 avdd.n483 avss 0.13455f
C2048 avdd.t599 avss 1.67528f
C2049 avdd.t567 avss 1.63495f
C2050 avdd.t563 avss 1.67528f
C2051 avdd.t664 avss 1.67528f
C2052 avdd.t346 avss 0.11108f
C2053 avdd.t347 avss 0.11108f
C2054 avdd.n494 avss 0.47566f
C2055 avdd.n495 avss 1.0409f
C2056 avdd.t665 avss 1.68908f
C2057 avdd.t666 avss 1.67408f
C2058 avdd.n496 avss 0.13455f
C2059 avdd.t628 avss 1.67408f
C2060 avdd.t629 avss 1.63412f
C2061 avdd.t630 avss 1.67408f
C2062 avdd.t593 avss 1.67408f
C2063 avdd.t594 avss 1.67626f
C2064 avdd.t595 avss 1.67469f
C2065 avdd.n505 avss 0.13455f
C2066 avdd.t600 avss 1.67469f
C2067 avdd.t601 avss 1.67469f
C2068 avdd.t602 avss 1.67469f
C2069 avdd.t652 avss 1.67469f
C2070 avdd.t328 avss 0.11108f
C2071 avdd.t329 avss 0.11108f
C2072 avdd.n510 avss 0.47566f
C2073 avdd.n511 avss 1.04052f
C2074 avdd.n512 avss 0.71157f
C2075 avdd.t325 avss 0.11108f
C2076 avdd.t326 avss 0.11108f
C2077 avdd.n513 avss 0.47566f
C2078 avdd.n514 avss 0.37092f
C2079 avdd.n516 avss 0.21282f
C2080 avdd.n517 avss 0.25238f
C2081 avdd.n518 avss 1.09158f
C2082 avdd.n532 avss 0.20387f
C2083 avdd.t343 avss 0.11108f
C2084 avdd.t344 avss 0.11108f
C2085 avdd.n533 avss 0.47566f
C2086 avdd.n534 avss 0.37092f
C2087 avdd.n536 avss 0.71349f
C2088 avdd.n552 avss 0.20373f
C2089 avdd.t361 avss 0.11108f
C2090 avdd.t362 avss 0.11108f
C2091 avdd.n553 avss 0.47566f
C2092 avdd.n554 avss 0.37093f
C2093 avdd.n556 avss 0.85944f
C2094 avdd.n570 avss 0.19083f
C2095 avdd.t382 avss 0.18741f
C2096 avdd.t383 avss 0.18741f
C2097 avdd.n572 avss 0.64247f
C2098 avdd.n573 avss 0.6416f
C2099 avdd.t376 avss 0.18741f
C2100 avdd.t377 avss 0.18741f
C2101 avdd.n574 avss 0.64247f
C2102 avdd.n575 avss 0.6416f
C2103 avdd.t373 avss 0.18741f
C2104 avdd.t374 avss 0.18741f
C2105 avdd.n576 avss 0.64247f
C2106 avdd.n577 avss 0.6416f
C2107 avdd.t370 avss 0.18741f
C2108 avdd.t371 avss 0.18741f
C2109 avdd.n578 avss 0.64247f
C2110 avdd.n579 avss 0.6416f
C2111 avdd.t358 avss 0.18741f
C2112 avdd.t359 avss 0.18741f
C2113 avdd.n580 avss 0.64247f
C2114 avdd.n581 avss 0.6416f
C2115 avdd.n582 avss 0.74492f
C2116 avdd.t355 avss 0.18741f
C2117 avdd.t356 avss 0.18741f
C2118 avdd.n583 avss 0.64247f
C2119 avdd.n584 avss 0.6416f
C2120 avdd.n585 avss 1.1662f
C2121 avdd.t352 avss 0.18741f
C2122 avdd.t353 avss 0.18741f
C2123 avdd.n586 avss 0.64247f
C2124 avdd.n587 avss 0.6416f
C2125 avdd.n588 avss 1.0005f
C2126 avdd.t340 avss 0.18741f
C2127 avdd.t341 avss 0.18741f
C2128 avdd.n589 avss 0.64247f
C2129 avdd.n590 avss 0.6416f
C2130 avdd.n591 avss 0.4916f
C2131 avdd.t337 avss 0.18741f
C2132 avdd.t338 avss 0.18741f
C2133 avdd.n592 avss 0.64247f
C2134 avdd.n593 avss 0.6416f
C2135 avdd.n594 avss 1.27667f
C2136 avdd.t334 avss 0.18741f
C2137 avdd.t335 avss 0.18741f
C2138 avdd.n595 avss 0.64247f
C2139 avdd.n596 avss 0.6416f
C2140 avdd.n597 avss 1.15742f
C2141 avdd.t260 avss 0.18741f
C2142 avdd.t261 avss 0.18741f
C2143 avdd.n598 avss 0.64247f
C2144 avdd.n599 avss 0.6416f
C2145 avdd.n600 avss 0.4916f
C2146 avdd.t257 avss 0.18741f
C2147 avdd.t258 avss 0.18741f
C2148 avdd.n601 avss 0.64247f
C2149 avdd.n602 avss 0.6416f
C2150 avdd.n603 avss 1.00662f
C2151 avdd.t254 avss 0.18741f
C2152 avdd.t255 avss 0.18741f
C2153 avdd.n604 avss 0.64247f
C2154 avdd.n605 avss 0.6416f
C2155 avdd.n606 avss 1.25212f
C2156 avdd.t236 avss 0.18741f
C2157 avdd.t237 avss 0.18741f
C2158 avdd.n607 avss 0.64247f
C2159 avdd.n608 avss 0.6416f
C2160 avdd.n609 avss 0.49024f
C2161 avdd.n610 avss 0.26554f
C2162 avdd.t248 avss 0.18647f
C2163 avdd.t249 avss 0.18647f
C2164 avdd.n611 avss 0.64247f
C2165 avdd.n612 avss 0.3114f
C2166 avdd.n613 avss 0.13966f
C2167 avdd.n614 avss 0.18329f
C2168 avdd.t233 avss 0.18741f
C2169 avdd.t234 avss 0.18741f
C2170 avdd.n617 avss 0.64247f
C2171 avdd.n618 avss 0.6416f
C2172 avdd.n619 avss 0.90639f
C2173 avdd.t230 avss 0.18741f
C2174 avdd.t231 avss 0.18741f
C2175 avdd.n620 avss 0.64247f
C2176 avdd.n621 avss 0.6416f
C2177 avdd.n622 avss 0.90657f
C2178 avdd.t227 avss 0.18741f
C2179 avdd.t228 avss 0.18741f
C2180 avdd.n623 avss 0.64247f
C2181 avdd.n624 avss 0.6416f
C2182 avdd.t224 avss 0.18741f
C2183 avdd.t225 avss 0.18741f
C2184 avdd.n625 avss 0.64247f
C2185 avdd.n626 avss 0.6416f
C2186 avdd.t221 avss 0.18741f
C2187 avdd.t222 avss 0.18741f
C2188 avdd.n627 avss 0.64247f
C2189 avdd.n628 avss 0.6416f
C2190 avdd.t218 avss 0.18741f
C2191 avdd.t219 avss 0.18741f
C2192 avdd.n629 avss 0.64247f
C2193 avdd.n630 avss 0.84215f
C2194 avdd.n631 avss 1.60417f
C2195 avdd.n632 avss 0.90668f
C2196 avdd.n633 avss 0.89443f
C2197 avdd.t245 avss 0.18741f
C2198 avdd.t246 avss 0.18741f
C2199 avdd.n635 avss 0.64247f
C2200 avdd.n636 avss 0.6416f
C2201 avdd.n637 avss 1.09833f
C2202 avdd.n638 avss 0.24963f
C2203 avdd.t242 avss 0.18741f
C2204 avdd.t243 avss 0.18741f
C2205 avdd.n639 avss 0.64247f
C2206 avdd.n640 avss 0.6416f
C2207 avdd.n641 avss 1.01164f
C2208 avdd.t239 avss 0.18741f
C2209 avdd.t240 avss 0.18741f
C2210 avdd.n642 avss 0.64247f
C2211 avdd.n643 avss 0.64521f
C2212 avdd.n644 avss 1.1071f
C2213 avdd.t251 avss 0.18741f
C2214 avdd.t252 avss 0.18741f
C2215 avdd.n645 avss 0.64247f
C2216 avdd.n646 avss 0.6416f
C2217 avdd.n647 avss 0.78365f
C2218 avdd.n648 avss 0.29256f
C2219 avdd.t313 avss 0.18741f
C2220 avdd.t314 avss 0.18741f
C2221 avdd.n649 avss 0.64247f
C2222 avdd.n650 avss 0.6416f
C2223 avdd.n651 avss 0.78371f
C2224 avdd.t322 avss 0.18741f
C2225 avdd.t323 avss 0.18741f
C2226 avdd.n652 avss 0.64247f
C2227 avdd.n653 avss 0.6416f
C2228 avdd.n654 avss 0.81745f
C2229 avdd.t319 avss 0.18741f
C2230 avdd.t320 avss 0.18741f
C2231 avdd.n655 avss 0.64247f
C2232 avdd.n656 avss 0.6416f
C2233 avdd.n657 avss 1.07968f
C2234 avdd.t316 avss 0.18741f
C2235 avdd.t317 avss 0.18741f
C2236 avdd.n658 avss 0.64247f
C2237 avdd.n659 avss 0.6416f
C2238 avdd.n660 avss 1.02328f
C2239 avdd.n661 avss 0.12214f
C2240 avdd.t331 avss 0.18741f
C2241 avdd.t332 avss 0.18741f
C2242 avdd.n662 avss 0.64247f
C2243 avdd.n663 avss 0.6416f
C2244 avdd.n664 avss 0.78378f
C2245 avdd.n665 avss 0.12208f
C2246 avdd.t349 avss 0.18741f
C2247 avdd.t350 avss 0.18741f
C2248 avdd.n666 avss 0.64247f
C2249 avdd.n667 avss 0.6416f
C2250 avdd.n668 avss 0.78384f
C2251 avdd.n669 avss 0.12201f
C2252 avdd.t367 avss 0.18741f
C2253 avdd.t368 avss 0.18741f
C2254 avdd.n670 avss 0.64247f
C2255 avdd.n671 avss 0.6416f
C2256 avdd.n672 avss 0.79626f
C2257 avdd.n673 avss 0.90651f
C2258 avdd.n674 avss 0.90668f
C2259 avdd.n675 avss 0.90368f
C2260 avdd.t379 avss 0.18741f
C2261 avdd.t380 avss 0.18741f
C2262 avdd.n676 avss 0.64247f
C2263 avdd.n677 avss 0.6416f
C2264 avdd.n678 avss 0.91159f
C2265 avdd.n679 avss 0.90673f
C2266 avdd.t385 avss 0.18741f
C2267 avdd.t386 avss 0.18741f
C2268 avdd.n680 avss 0.64247f
C2269 avdd.n681 avss 0.6416f
C2270 avdd.n682 avss 1.32378f
C2271 avdd.n684 avss 0.13357f
C2272 avdd.n685 avss 5.68927f
C2273 avdd.n686 avss 1.11098f
C2274 avdd.n687 avss 1.12068f
C2275 avdd.n688 avss 1.12077f
C2276 avdd.n689 avss 1.12073f
C2277 avdd.n690 avss 1.11957f
C2278 avdd.n691 avss 1.12083f
C2279 avdd.n692 avss 1.12072f
C2280 avdd.n693 avss 0.93678f
C2281 avdd.n696 avss 0.79203f
C2282 avdd.n697 avss 0.72378f
C2283 avdd.t116 avss 0.39044f
C2284 avdd.t117 avss 0.39044f
C2285 avdd.n698 avss 1.11118f
C2286 avdd.n700 avss 0.52781f
C2287 avdd.t586 avss 2.6003f
C2288 avdd.t587 avss 2.59647f
C2289 avdd.n701 avss 0.37191f
C2290 avdd.n704 avss 0.85363f
C2291 avdd.n705 avss 0.4234f
C2292 avdd.t597 avss 2.57848f
C2293 avdd.n708 avss 0.30921f
C2294 avdd.t631 avss 2.57893f
C2295 avdd.n709 avss 0.26686f
C2296 avdd.t581 avss 2.57848f
C2297 avdd.n710 avss 0.28552f
C2298 avdd.t68 avss 0.3908f
C2299 avdd.t69 avss 0.3908f
C2300 avdd.n711 avss 1.11118f
C2301 avdd.n712 avss 3.22176f
C2302 avdd.n713 avss 1.47271f
C2303 avdd.t568 avss 2.56877f
C2304 avdd.t20 avss 0.3908f
C2305 avdd.t21 avss 0.3908f
C2306 avdd.n716 avss 1.11118f
C2307 avdd.n717 avss 1.35138f
C2308 avdd.t17 avss 0.3908f
C2309 avdd.t18 avss 0.3908f
C2310 avdd.n718 avss 1.11118f
C2311 avdd.n719 avss 1.35138f
C2312 avdd.t14 avss 0.3908f
C2313 avdd.t15 avss 0.3908f
C2314 avdd.n720 avss 1.11118f
C2315 avdd.n721 avss 1.35138f
C2316 avdd.t11 avss 0.3908f
C2317 avdd.t12 avss 0.3908f
C2318 avdd.n722 avss 1.11118f
C2319 avdd.n723 avss 1.35138f
C2320 avdd.t8 avss 0.3908f
C2321 avdd.t9 avss 0.3908f
C2322 avdd.n724 avss 1.11118f
C2323 avdd.n725 avss 1.35138f
C2324 avdd.n726 avss 1.12091f
C2325 avdd.n727 avss 1.12081f
C2326 avdd.n728 avss 1.12087f
C2327 avdd.n729 avss 1.12075f
C2328 avdd.n730 avss 1.12077f
C2329 avdd.n732 avss 1.10382f
C2330 avdd.n733 avss 1.12078f
C2331 avdd.n734 avss 1.1208f
C2332 avdd.n735 avss 1.12082f
C2333 avdd.n736 avss 1.12064f
C2334 avdd.n737 avss 1.10749f
C2335 avdd.t62 avss 0.3957f
C2336 avdd.t63 avss 0.3957f
C2337 avdd.n738 avss 1.12326f
C2338 avdd.n739 avss 1.3674f
C2339 avdd.t59 avss 0.3957f
C2340 avdd.t60 avss 0.3957f
C2341 avdd.n740 avss 1.12326f
C2342 avdd.n741 avss 1.3674f
C2343 avdd.t56 avss 0.3957f
C2344 avdd.t57 avss 0.3957f
C2345 avdd.n742 avss 1.12326f
C2346 avdd.n743 avss 1.3674f
C2347 avdd.t53 avss 0.3957f
C2348 avdd.t54 avss 0.3957f
C2349 avdd.n744 avss 1.12326f
C2350 avdd.n745 avss 1.3674f
C2351 avdd.t50 avss 0.3957f
C2352 avdd.t51 avss 0.3957f
C2353 avdd.n746 avss 1.12326f
C2354 avdd.n747 avss 1.3674f
C2355 avdd.t47 avss 0.3957f
C2356 avdd.t48 avss 0.3957f
C2357 avdd.n748 avss 1.12326f
C2358 avdd.n749 avss 1.3674f
C2359 avdd.n750 avss 1.13482f
C2360 avdd.n751 avss 1.13484f
C2361 avdd.n752 avss 1.13492f
C2362 avdd.n753 avss 1.13482f
C2363 avdd.n754 avss 1.13482f
C2364 avdd.n755 avss 1.1213f
C2365 avdd.t2 avss 0.3908f
C2366 avdd.t3 avss 0.3908f
C2367 avdd.n756 avss 1.11118f
C2368 avdd.n757 avss 1.35138f
C2369 avdd.n758 avss 1.10295f
C2370 avdd.n762 avss 0.21537f
C2371 avdd.t65 avss 0.3908f
C2372 avdd.t66 avss 0.3908f
C2373 avdd.n763 avss 1.11118f
C2374 avdd.n764 avss 1.35138f
C2375 avdd.n765 avss 1.25818f
C2376 avdd.n766 avss 1.78171f
C2377 avdd.n767 avss 1.12138f
C2378 avdd.n771 avss 0.39767f
C2379 avdd.t616 avss 2.60656f
C2380 avdd.t617 avss 2.59509f
C2381 avdd.n773 avss 0.14035f
C2382 avdd.n774 avss 0.36609f
C2383 avdd.t643 avss 2.59555f
C2384 avdd.n777 avss 0.30908f
C2385 avdd.t603 avss 2.6455f
C2386 avdd.t604 avss 2.59555f
C2387 avdd.n779 avss 0.52788f
C2388 avdd.n780 avss 1.33016f
C2389 avdd.t146 avss 0.3957f
C2390 avdd.t147 avss 0.3957f
C2391 avdd.n781 avss 1.12326f
C2392 avdd.n782 avss 1.3674f
C2393 avdd.n783 avss 1.12193f
C2394 avdd.t140 avss 0.3957f
C2395 avdd.t141 avss 0.3957f
C2396 avdd.n784 avss 1.12326f
C2397 avdd.n785 avss 1.3674f
C2398 avdd.n786 avss 1.12466f
C2399 avdd.t137 avss 0.3957f
C2400 avdd.t138 avss 0.3957f
C2401 avdd.n787 avss 1.12326f
C2402 avdd.n788 avss 1.3674f
C2403 avdd.t161 avss 0.39488f
C2404 avdd.t162 avss 0.39488f
C2405 avdd.n789 avss 1.12125f
C2406 avdd.n790 avss 1.36473f
C2407 avdd.t158 avss 0.39488f
C2408 avdd.t159 avss 0.39488f
C2409 avdd.n791 avss 1.12125f
C2410 avdd.n792 avss 1.36473f
C2411 avdd.n793 avss 1.12823f
C2412 avdd.n794 avss 1.12824f
C2413 avdd.n795 avss 0.8182f
C2414 avdd.n796 avss 1.12466f
C2415 avdd.t134 avss 0.3957f
C2416 avdd.t135 avss 0.3957f
C2417 avdd.n797 avss 1.12326f
C2418 avdd.n798 avss 1.3674f
C2419 avdd.n799 avss 1.12456f
C2420 avdd.n800 avss 0.81821f
C2421 avdd.n801 avss 1.12823f
C2422 avdd.n802 avss 1.11914f
C2423 avdd.n803 avss 2.19147f
C2424 avdd.t619 avss 2.59591f
C2425 avdd.t615 avss 2.59288f
C2426 avdd.t650 avss 2.60037f
C2427 avdd.t179 avss 0.39488f
C2428 avdd.t180 avss 0.39488f
C2429 avdd.n805 avss 1.12125f
C2430 avdd.n806 avss 1.36473f
C2431 avdd.n807 avss 1.11834f
C2432 avdd.t176 avss 0.39488f
C2433 avdd.t177 avss 0.39488f
C2434 avdd.n808 avss 1.12125f
C2435 avdd.n809 avss 1.36473f
C2436 avdd.n810 avss 3.12667f
C2437 avdd.t651 avss 2.63676f
C2438 avdd.n811 avss 0.33041f
C2439 avdd.t571 avss 2.60204f
C2440 avdd.t572 avss 2.59059f
C2441 avdd.n813 avss 0.30858f
C2442 avdd.t585 avss 2.59149f
C2443 avdd.n815 avss 0.3713f
C2444 avdd.n816 avss 0.16769f
C2445 avdd.t614 avss 2.59149f
C2446 avdd.n820 avss 0.1987f
C2447 avdd.t589 avss 2.59537f
C2448 avdd.t590 avss 2.64185f
C2449 avdd.t588 avss 2.59184f
C2450 avdd.n822 avss 0.52616f
C2451 avdd.t194 avss 0.39488f
C2452 avdd.t195 avss 0.39488f
C2453 avdd.n823 avss 1.12125f
C2454 avdd.n824 avss 1.36473f
C2455 avdd.t200 avss 0.39488f
C2456 avdd.t201 avss 0.39488f
C2457 avdd.n825 avss 1.12125f
C2458 avdd.n826 avss 1.36473f
C2459 avdd.n827 avss 1.11605f
C2460 avdd.t197 avss 0.39488f
C2461 avdd.t198 avss 0.39488f
C2462 avdd.n828 avss 1.12125f
C2463 avdd.n829 avss 1.36473f
C2464 avdd.t191 avss 0.39488f
C2465 avdd.t192 avss 0.39488f
C2466 avdd.n830 avss 1.12125f
C2467 avdd.n831 avss 1.36473f
C2468 avdd.n832 avss 1.32828f
C2469 avdd.t215 avss 0.39488f
C2470 avdd.t216 avss 0.39488f
C2471 avdd.n833 avss 1.12125f
C2472 avdd.n834 avss 1.53015f
C2473 avdd.t212 avss 0.39488f
C2474 avdd.t213 avss 0.39488f
C2475 avdd.n835 avss 1.12125f
C2476 avdd.n836 avss 1.36473f
C2477 avdd.t209 avss 0.39488f
C2478 avdd.t210 avss 0.39488f
C2479 avdd.n837 avss 1.12125f
C2480 avdd.n838 avss 1.36473f
C2481 avdd.t206 avss 0.39488f
C2482 avdd.t207 avss 0.39488f
C2483 avdd.n839 avss 1.12125f
C2484 avdd.n840 avss 1.36473f
C2485 avdd.t203 avss 0.39488f
C2486 avdd.t204 avss 0.39488f
C2487 avdd.n841 avss 1.12125f
C2488 avdd.n842 avss 1.36473f
C2489 avdd.t667 avss 3.8568f
C2490 avdd.t573 avss 3.81094f
C2491 avdd.n843 avss 0.3515f
C2492 avdd.n848 avss 1.13315f
C2493 avdd.n849 avss 1.13312f
C2494 avdd.n850 avss 1.13319f
C2495 avdd.n851 avss 1.1329f
C2496 avdd.n852 avss 1.13283f
C2497 avdd.n853 avss 0.91614f
C2498 avdd.n854 avss 0.40164f
C2499 avdd.t609 avss 2.59224f
C2500 avdd.t578 avss 2.4048f
C2501 avdd.n856 avss 0.25019f
C2502 avdd.n857 avss 0.39981f
C2503 avdd.t608 avss 2.59184f
C2504 avdd.n860 avss 0.36517f
C2505 avdd.t579 avss 2.64139f
C2506 avdd.t618 avss 2.59149f
C2507 avdd.n862 avss 0.4714f
C2508 avdd.t185 avss 0.39488f
C2509 avdd.t186 avss 0.39488f
C2510 avdd.n863 avss 1.12125f
C2511 avdd.n864 avss 1.36473f
C2512 avdd.n865 avss 1.32799f
C2513 avdd.n866 avss 2.242f
C2514 avdd.n867 avss 7.44043f
C2515 avdd.n868 avss 13.03f
C2516 avdd.t592 avss 3.99541f
C2517 avdd.n869 avss 0.23952f
C2518 avdd.t660 avss 3.9457f
C2519 avdd.t658 avss 3.94666f
C2520 avdd.t662 avss 3.94789f
C2521 avdd.t565 avss 3.94509f
C2522 avdd.t622 avss 3.68687f
C2523 avdd.n875 avss 0.14718f
C2524 avdd.n876 avss 2.1019f
C2525 avdd.t311 avss 2.11196f
C2526 avdd.n877 avss 3.02596f
C2527 avdd.n878 avss 2.98349f
C2528 avdd.t309 avss 2.11196f
C2529 avdd.n879 avss 3.02596f
C2530 avdd.n880 avss 2.92502f
C2531 avdd.t307 avss 2.11196f
C2532 avdd.n881 avss 3.02596f
C2533 avdd.n882 avss 2.92502f
C2534 avdd.t305 avss 2.11196f
C2535 avdd.n883 avss 3.02596f
C2536 avdd.n884 avss 2.92502f
C2537 avdd.t303 avss 2.11196f
C2538 avdd.n885 avss 3.02596f
C2539 avdd.n886 avss 2.92502f
C2540 avdd.t301 avss 2.11196f
C2541 avdd.n887 avss 3.02596f
C2542 avdd.n888 avss 2.92502f
C2543 avdd.t299 avss 2.11196f
C2544 avdd.n889 avss 3.02596f
C2545 avdd.n890 avss 2.92502f
C2546 avdd.t297 avss 2.11196f
C2547 avdd.n891 avss 3.02596f
C2548 avdd.n892 avss 2.92502f
C2549 avdd.t295 avss 2.11196f
C2550 avdd.n893 avss 3.02596f
C2551 avdd.n894 avss 2.92502f
C2552 avdd.t293 avss 2.11196f
C2553 avdd.n895 avss 3.02596f
C2554 avdd.n896 avss 2.92502f
C2555 avdd.t291 avss 2.11196f
C2556 avdd.n897 avss 3.02596f
C2557 avdd.n898 avss 2.92502f
C2558 avdd.t289 avss 2.11196f
C2559 avdd.n899 avss 3.02596f
C2560 avdd.n900 avss 2.93665f
C2561 avdd.t287 avss 2.11196f
C2562 avdd.n901 avss 3.02596f
C2563 avdd.n902 avss 3.14912f
C2564 avdd.n903 avss 0.38452f
C2565 avdd.t655 avss 3.86633f
C2566 avdd.n910 avss 0.17127f
C2567 avdd.n913 avss 0.10851f
C2568 avdd.n915 avss 0.16872f
C2569 avdd.n916 avss 1.94969f
C2570 avdd.n917 avss 2.3255f
C2571 avdd.n919 avss 1.11122f
C2572 avdd.n920 avss 0.79877f
C2573 avdd.n921 avss 1.12438f
C2574 avdd.n922 avss 0.87734f
C2575 avdd.n923 avss 0.82993f
C2576 avdd.n925 avss 0.15928f
C2577 dvss.t0 avss 0.14961f
C2578 dvss.t4 avss 0.94368f
C2579 dvss.t3 avss 0.65084f
C2580 dvss.t1 avss 0.37336f
C2581 dvss.n0 avss 1.23715f
C2582 dvss.t5 avss 1.3845f
C2583 dvss.n1 avss 4.52422f
C2584 dvss.n2 avss 2.57922f
C2585 dvss.t6 avss 0.13232f
C2586 dvss.n3 avss 0.88965f
C2587 dvss.n4 avss 0.94276f
C2588 dvss.t2 avss 0.13385f
C2589 dvss.n5 avss 3.08271f
C2590 b3.n0 avss 7.87988f
C2591 b3.n1 avss 4.31089f
C2592 b4.n0 avss 5.37404f
C2593 b4.n1 avss 4.60701f
C2594 b0.n0 avss 1.69023f
C2595 b0.n1 avss 0.7605f
C2596 b0.n2 avss 4.02553f
C2597 b5.n0 avss 2.5482f
C2598 b5.n1 avss 4.66644f
C2599 b6.n0 avss 2.18106f
C2600 b6.n1 avss 4.10212f
C2601 vq3.t0 avss 0.33455f
C2602 vq3.n0 avss 1.20035f
C2603 vq3.n1 avss 0.60978f
C2604 vq3.t1 avss 0.18105f
C2605 vq3.n2 avss 10.6727f
C2606 b2.n0 avss 3.41611f
C2607 b2.n1 avss 4.49212f
C2608 b1.n0 avss 2.37804f
C2609 b1.n1 avss 4.95878f
C2610 vref.t0 avss 1.13626f
C2611 vref.t1 avss 15.51752f
C2612 vref.n18 avss 0.41216f
C2613 net3.t0 avss 11.0896f
C2614 vq2.t0 avss 0.45858f
C2615 net4.t0 avss 4.39746f
C2616 v1.n0 avss 2.38347f
C2617 v1.n1 avss 3.17557f
C2618 v1.t1 avss 4.08339f
C2619 v1.t0 avss 4.04135f
C2620 v1.n2 avss 0.65023f
C2621 v1.n3 avss 3.5571f
C2622 v1.n4 avss 3.4151f
C2623 v1.n5 avss 1.9404f
C2624 v1.n6 avss 0.62003f
C2625 v1.n7 avss 1.77552f
C2626 v1.n8 avss 8.6914f
C2627 v1.n9 avss 14.3422f
C2628 v1.n10 avss 1.15213f
C2629 net4 avss 2.52125f
C2630 net3 avss 32.25772f
C2631 vq2 avss 7.74137f
C2632 v1 avss 49.24251f
C2633 vq3 avss 30.043f
.ends
